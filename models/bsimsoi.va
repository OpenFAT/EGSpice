// **************************************************************************************
// *  BSIM-SOI 101.0.0 released on 09/15/2026                                           *
// *  Symmetric BSIM-SOI MOSFET Model Equations (Verilog-A)                             *
// *  SOIMOD=0: Partial depleted mode (PD), SOIMOD=1: Dynamic depletion mode (DD)       *
// **************************************************************************************

// **************************************************************************************
// *  Copyright © 2026 University of California                                         *
// *  Project director: Prof.Sayeef Salahuddin and Prof. Chenming Hu                    *
// *  List of Developers: https://www.bsim.berkeley.edu/models/bsimsoi/auth_soi_s/      *
// **************************************************************************************

`include "constants.vams"
`include "disciplines.vams"

// Disable strobe for improved performance speed
// To Use DISABLE_STROBE, Activate it here. Used Only at GEOMOD and RGEOMOD
// `define DISABLE_STROBE
`ifdef DISABLE_STROBE
    `define STROBE(X)
    `define STROBE2(X,Y)
`else
    `define STROBE(X) $strobe(X)
    `define STROBE2(X,Y) $strobe(X,Y)
`endif

// Other constants
`define oneThird              3.3333333333333333e-01

//  --------------------------------------------------------------------------------------------------------------
`define sigma0(d,f,tau,eta,z) \
    nu           =  (d) + (f); \
    mutau        =  nu * nu + (tau) * (0.5 * ((f) * (f)) - (d)); \
    z            =  (eta) + (d) * nu * (tau) / (mutau + (nu / mutau) * (tau) * (tau) * (f) * ((f) * (f) * `oneThird - (d))); \

// modified version of sigma function
//  --------------------------------------------------------------------------------------------------------------
`define sigma1(d,e,f,tau,eta,z) \
    nu           =  (d) + (f); \
    mutau        =  (nu) * (nu) + (tau) * (0.5 * ((f) * (f)) - (d) * (e)); \
    z            =  (eta) + (d) * nu * (tau) / (mutau + (nu / mutau) * (tau) * (tau) * (f) * ((f) * (f) * `oneThird - (d) * (e))); \

// Some functions
`define MINF(x,y,a)           0.5*((x)+(y)-sqrt(((x)-(y))*((x)-(y))+(a)))

// Junction capacitance macro between S/D and bulk
`define JunCap(Czbx, Vbx_jct, PBX_t, MJX, czbx_p1, czbx_p2, Qbxj) \
    if (Czbx > 0.0) begin \
        T1 = Vbx_jct / PBX_t; \
        if (T1 < 0.9) begin \
            arg = 1.0 - T1; \
            if (MJX != 1.0) begin \
                if (MJX == 0.5) begin \
                    sarg = 1.0 / sqrt(arg); \
                end else begin \
                    sarg = lexp(-MJX * ln(arg)); \
                end \
                Qbxj = PBX_t * Czbx * (1.0 - arg * sarg) / (1.0 - MJX); \
            end else begin \
                Qbxj = PBX_t * Czbx * (-ln(arg)); \
            end \
        end else begin \
            T2  = czbx_p1 * (T1 - 1.0) * (5.0 * MJX * (T1 - 1.0) + (1.0 + MJX)); \
            Qbxj = PBX_t * Czbx * (T2 + czbx_p2); \
        end \
    end else begin \
        Qbxj = 0.0; \
    end \

// Normalized pinch-off voltage including PD
`define PO_psip(vg_vfb, gamma, DPD, phif, psip) \
    T1 = 1.0 + DPD; \
    vgfbPD   = vg_vfb / T1; \
    gammaPD  = gamma / T1; \
    T1       = 0.5 * vgfbPD - 3.0 * (1.0 + gammaPD / `M_SQRT2); \
    T2       = T1 + sqrt(T1 * T1 + 6.0 * vgfbPD); \
    if (vgfbPD < 0.0) begin \
        T3   = (vgfbPD - T2) / gammaPD; \
        psip = -lln(1.0 - T2 + T3 * T3); \
    end else begin \
        T3   = lexp(-T2); \
        T1   = 0.5 * gammaPD; \
        T2   = sqrt(vgfbPD - 1.0 + T3 + T1 * T1) - T1; \
        psip = T2 * T2 + 1.0 - T3; \
    end \

// Normalized charge-voltage relationship
`define BSIM_q(psip, phib, vch, gam, q) \
    T8 = 0.5 * (psip + 1.0 + sqrt((psip - 1.0) * (psip - 1.0) + 0.25 * 2.0 * 2.0)); \
    sqrtpsip = sqrt(T8); \
    T0 = (1.0 + (gam / (2.0 * sqrtpsip))) / gam; \
    T1 = psip - 2.0 * phib - vch; \
    T2 = T1 - lln(4.0 * T0 * sqrtpsip); \
    T8 = 0.5 * (T2 - 0.201491 - sqrt(T2 * (T2 + 0.402982) + 2.446562)); \
    sqrtpsisa = sqrtpsip; \
    if (T8 <= -68.0) begin \
        T4 = -100.0; \
        T5 = 20.0; \
        if (T8 < T4 - 0.5 * T5) \
            T3 = lexp(T4); \
        else begin \
            if (T8 > T4 + 0.5 * T5) \
                T3 = lexp(T8); \
            else begin \
                T2 = (T8 - T4) / T5; \
                T6 = T2 * T2; \
                T3 = lexp(T4 + T5 * ((5.0 / 64.0) + 0.5 * T2 + T6 * ((15.0 / 16.0) - T6 * (1.25 - T6)))); \
            end \
        end \
        q = T3 * (1.0 + T1 - T8 - lln(2.0 * T0 * (T3 * 2.0 * T0 + 2.0 * sqrtpsisa))); \
    end else begin \
        T3 = lexp(T8); \
        sqrtpsisainv = 1.0 / sqrtpsisa; \
        T4 = 2.0 * T3 + lln(T3 * 2.0 * T0 * (T3 *  2.0 * T0 + 2.0 * sqrtpsisa)) - T1; \
        T5 = 2.0 + (1.0 / T3) + (T0 + sqrtpsisainv) / (T0 * T3 + sqrtpsisa); \
        T3 = T3 - T4 / T5; \
        T4 = 2.0 * T3 + lln(T3 * 2.0 * T0 * (T3 * 2.0 * T0 + 2.0 * sqrtpsisa)) - T1; \
        T5 = 2.0 + (1.0 / T3) + (T0 + sqrtpsisainv) / (T0 * T3 + sqrtpsisa); \
        T6 = ((T0 + sqrtpsisainv) / (T0 * T3 + sqrtpsisa)) * ((T0 + sqrtpsisainv) / (T0 * T3 + sqrtpsisa)); \
        T7 = -((1.0 / T3) * (1.0 / T3)) - (1.0 / (sqrtpsisa * sqrtpsisa * sqrtpsisa * (T0 * T3 + sqrtpsisa))) - T6; \
        q  = T3 - (T4 / T5) * (1.0 + T4 * T7 / (2.0 * T5 * T5)); \
    end \

// Smoothing function for (max of x, x0 with deltax)
`define Smooth(x, x0, deltax, xsmooth) \
    xsmooth = 0.5 * (x + x0 + sqrt((x - x0) * (x - x0) + 0.25 * deltax * deltax)); \

// Smoothing function for (min of x, x0 with deltax)
`define Smooth2(x, x0, deltax, xsmooth) \
    xsmooth = 0.5 * (x + x0 - sqrt((x - x0) * (x - x0) + 0.25 * deltax * deltax)) + 0.25 * deltax; \

 // These macros represent the subroutines to process the geometry dependent
 // parasitics for BSIM-BULK, which calculates Ps, Pd, As, Ad, and Rs and Rd
 // for multi-fingers and various GEO and RGEO options.

// Define GEOMOD and RGEOMOD in the modelcard
`define BSIMBULKNumFingerDiff(nf, minSD, nuIntD, nuEndD, nuIntS, nuEndS) \
    if ((nf % 2) != 0) begin \
        nuEndD = 1.0; \
        nuEndS = 1.0; \
        nuIntD = 2.0 * max((nf - 1.0) / 2.0, 0.0); \
        nuIntS = nuIntD; \
    end else begin \
        if (minSD == 1) begin \
            nuEndD = 2.0; \
            nuIntD = 2.0 * max((nf / 2.0 - 1.0), 0.0); \
            nuEndS = 0.0; \
            nuIntS = nf; \
        end else begin \
            nuEndD = 0.0; \
            nuIntD = nf; \
            nuEndS = 2.0; \
            nuIntS = 2.0 * max((nf / 2.0 - 1.0), 0.0); \
        end \
    end

`define BSIMBULKRdsEndIso(Weffcj, Rsh, DMCG, DMCI, DMDG, nuEnd, rgeo, SRCFLAG, Rend) \
    if (SRCFLAG == 1) begin \
        case (rgeo) \
            1, 2, 5: begin \
                if (nuEnd == 0.0) begin \
                    Rend = 0.0; \
                end else begin \
                    Rend = Rsh * DMCG / (Weffcj * nuEnd); \
                end \
            end \
            3, 4, 6: begin \
                if ((DMCG + DMCI) == 0.0) begin \
                    `STROBE("(DMCG + DMCI) can not be equal to zero"); \
                end \
                if (nuEnd == 0.0 || (DMCG + DMCI) == 0.0) begin \
                    Rend = 0.0; \
                end else begin \
                    Rend = Rsh * Weffcj / (3.0 * nuEnd * (DMCG + DMCI)); \
                end \
            end \
            default: begin \
                `STROBE2("Warning: (instance %M) Specified RGEO = %d not matched (BSIMBULKRdsEndIso), Rend is set to zero.", rgeo); \
                Rend = 0.0; \
            end \
        endcase \
    end else begin \
        case (rgeo) \
            1, 3, 7: begin \
                if (nuEnd == 0.0) begin \
                    Rend = 0.0; \
                end else begin \
                    Rend = Rsh * DMCG / (Weffcj * nuEnd); \
                end \
            end \
            2, 4, 8: begin \
                if ((DMCG + DMCI) == 0.0) begin \
                    `STROBE("(DMCG + DMCI) can not be equal to zero"); \
                end \
                if (nuEnd == 0.0 || (DMCG + DMCI) == 0.0) begin \
                    Rend = 0.0; \
                end \
                else begin \
                    Rend = Rsh * Weffcj / (3.0 * nuEnd * (DMCG + DMCI)); \
                end \
            end \
            default: begin \
                `STROBE2("Warning: (instance %M) Specified RGEO = %d not matched (BSIMBULKRdsEndIso type 2), Rend is set to zero.", rgeo); \
                Rend = 0.0; \
            end \
        endcase \
    end

`define BSIMBULKRdsEndSha(Weffcj, Rsh, DMCG, DMCI, DMDG, nuEnd, rgeo, SRCFLAG, Rend) \
    begin \
        if (SRCFLAG == 1) begin \
            case (rgeo) \
                1, 2, 5: begin \
                    if (nuEnd == 0.0) begin \
                        Rend = 0.0; \
                    end else begin \
                        Rend = Rsh * DMCG / (Weffcj * nuEnd); \
                    end \
                end \
                3, 4, 6: begin \
                    if (DMCG == 0.0) begin \
                        `STROBE("DMCG can not be equal to zero"); \
                    end \
                    if (nuEnd == 0.0 || DMCG == 0.0) begin \
                        Rend = 0.0; \
                    end \
                    else begin \
                        Rend = Rsh * Weffcj / (6.0 * nuEnd * DMCG); \
                    end \
                end \
                default: begin \
                    `STROBE2("Warning: (instance %M) Specified RGEO = %d not matched (BSIMBULKRdsEndSha), Rend is set to zero.", rgeo); \
                    Rend = 0.0; \
                end \
            endcase \
        end else begin \
            case (rgeo) \
                1, 3, 7: begin \
                    if (nuEnd == 0.0) begin \
                        Rend = 0.0; \
                    end else begin \
                        Rend = Rsh * DMCG / (Weffcj * nuEnd); \
                    end \
                end \
                2, 4, 8: begin \
                    if (DMCG == 0.0) begin \
                        `STROBE("DMCG can not be equal to zero"); \
                    end \
                    if (nuEnd == 0.0 || DMCG == 0.0) begin \
                        Rend = 0.0; \
                    end \
                    else begin \
                        Rend = Rsh * Weffcj / (6.0 * nuEnd * DMCG); \
                    end \
                end \
                default: begin \
                    `STROBE2("Warning: (instance %M) Specified RGEO=%d not matched (BSIMBULKRdsEndSha \
                    type 2), Rend is set to zero.", rgeo); \
                    Rend = 0.0; \
                end \
            endcase \
        end \
    end

`define BSIMBULKRdseffGeo(nf, geo, rgeo, minSD, Weffcj, Rsh, DMCG, DMCI, DMDG, SRCFLAG, Rtot) \
    begin \
        if (geo < 9) begin \
            `BSIMBULKNumFingerDiff(nf, minSD, nuIntD, nuEndD, nuIntS, nuEndS) \
            if (SRCFLAG == 1) begin \
                if (nuIntS == 0.0) begin \
                    Rint = 0.0; \
                end else begin \
                    Rint = Rsh * DMCG / ( Weffcj * nuIntS); \
                end \
            end \
            else begin \
                if (nuIntD == 0.0) begin \
                    Rint = 0.0; \
                end else begin \
                    Rint = Rsh * DMCG / ( Weffcj * nuIntD); \
                end \
            end \
        end \
        case (geo) \
            0: begin \
                if (SRCFLAG == 1) begin \
                    `BSIMBULKRdsEndIso(Weffcj, Rsh, DMCG, DMCI, DMDG, nuEndS, \
                    rgeo, 1, Rend) \
                end else begin \
                    `BSIMBULKRdsEndIso(Weffcj, Rsh, DMCG, DMCI, DMDG, nuEndD, \
                    rgeo, 0, Rend) \
                end \
            end \
            1: begin \
                if (SRCFLAG == 1) begin \
                    `BSIMBULKRdsEndIso(Weffcj, Rsh, DMCG, DMCI, DMDG, nuEndS, \
                    rgeo, 1, Rend) \
                end else begin \
                    `BSIMBULKRdsEndSha(Weffcj, Rsh, DMCG, DMCI, DMDG, nuEndD, \
                    rgeo, 0, Rend) \
                end \
            end \
            2: begin \
                if (SRCFLAG == 1) begin \
                    `BSIMBULKRdsEndSha(Weffcj, Rsh, DMCG, DMCI, DMDG, nuEndS, \
                    rgeo, 1, Rend) \
                end else begin \
                    `BSIMBULKRdsEndIso(Weffcj, Rsh, DMCG, DMCI, DMDG, nuEndD, \
                    rgeo, 0, Rend) \
                end \
            end \
            3: begin \
                if (SRCFLAG == 1) begin \
                    `BSIMBULKRdsEndSha(Weffcj, Rsh, DMCG, DMCI, DMDG, nuEndS, \
                    rgeo, 1, Rend) \
                end else begin \
                    `BSIMBULKRdsEndSha(Weffcj, Rsh, DMCG, DMCI, DMDG, nuEndD, \
                    rgeo, 0, Rend) \
                end \
            end \
            4: begin \
                if (SRCFLAG == 1) begin \
                    `BSIMBULKRdsEndIso(Weffcj, Rsh, DMCG, DMCI, DMDG, nuEndS, \
                    rgeo, 1, Rend) \
                end else begin \
                    Rend = Rsh * DMDG / Weffcj; \
                end \
            end \
            5: begin \
                if (SRCFLAG == 1) begin \
                    `BSIMBULKRdsEndSha(Weffcj, Rsh, DMCG, DMCI, DMDG, nuEndS, \
                    rgeo, 1, Rend) \
                end else begin \
                    if (nuEndD == 0) begin \
                        Rend = 0; \
                    end else begin \
                        Rend = Rsh * DMDG / (Weffcj * nuEndD); \
                    end \
                end \
            end \
            6: begin \
                if (SRCFLAG == 1) begin \
                    Rend = Rsh * DMDG / Weffcj; \
                end else begin \
                    `BSIMBULKRdsEndIso(Weffcj, Rsh, DMCG, DMCI, DMDG, nuEndD, \
                    rgeo, 0, Rend) \
                end \
            end \
            7:begin \
                if (SRCFLAG == 1) begin \
                    if (nuEndS == 0) begin \
                        Rend = 0; \
                    end else begin \
                        Rend = Rsh * DMDG / (Weffcj * nuEndS); \
                    end \
                end else \
                    `BSIMBULKRdsEndSha(Weffcj, Rsh, DMCG, DMCI, DMDG, nuEndD, \
                    rgeo, 0, Rend) \
            end \
            8: begin \
                Rend = Rsh * DMDG / Weffcj; \
            end \
            9: begin /* all wide contacts assumed for geo = 9 and 10 */ \
                if (SRCFLAG == 1) begin \
                    Rend = 0.5 * Rsh * DMCG / Weffcj; \
                    if (nf == 2.0) begin \
                        Rint = 0.0; \
                    end else begin \
                        Rint = Rsh * DMCG / (Weffcj * (nf - 2.0)); \
                    end \
                end \
                else begin \
                    Rend = 0.0; \
                    Rint = Rsh * DMCG / (Weffcj * nf); \
                end \
            end \
            10: begin \
                if (SRCFLAG == 1) begin \
                    Rend = 0.0; \
                    Rint = Rsh * DMCG / (Weffcj * nf); \
                end \
                else begin \
                    Rend = 0.5 * Rsh * DMCG / Weffcj; \
                    if (nf == 2.0) begin \
                        Rint = 0.0; \
                    end else begin \
                        Rint = Rsh * DMCG / (Weffcj * (nf - 2.0)); \
                    end \
                end \
            end \
            default: begin \
                `STROBE2("Warning: (instance %M) Specified GEO = %d not matched (BSIMBULKRdseffGeo), Rint is set to zero.", geo); \
                Rint = 0.0; \
            end \
        endcase \
        if (Rint <= 0.0) begin \
            Rtot = Rend; \
        end else if (Rend <= 0.0) begin \
            Rtot = Rint; \
        end else begin \
            Rtot = Rint * Rend / (Rint + Rend); \
        end \
        if (Rtot == 0.0) begin \
            `STROBE("Warning: (instance %M) Zero resistance returned from RdseffGeo"); \
        end \
    end

// Effective PS, PD, AS, AD calculation, Ref: BSIM4
`define BSIMBULKPAeffGeo(nf, geo, minSD,Weffcj, DMCG, DMCI, DMDG, Ps, Pd, As, Ad) \
    begin \
        if (geo < 9) begin \
            `BSIMBULKNumFingerDiff(nf, minSD, nuIntD, nuEndD, nuIntS, nuEndS) \
        end \
        T0 = DMCG + DMCI; \
        T1 = DMCG + DMCG; \
        T2 = DMDG + DMDG; \
        PSiso = T0 + T0 + Weffcj; \
        PDiso = T0 + T0 + Weffcj; \
        PSsha = T1; \
        PDsha = T1; \
        PSmer = T2; \
        PDmer = T2; \
        ASiso = T0 * Weffcj; \
        ADiso = T0 * Weffcj; \
        ASsha = DMCG * Weffcj; \
        ADsha = DMCG * Weffcj; \
        ASmer = DMDG * Weffcj; \
        ADmer = DMDG * Weffcj; \
        case (geo) \
            0: begin \
                Ps = nuEndS * PSiso + nuIntS * PSsha; \
                Pd = nuEndD * PDiso + nuIntD * PDsha; \
                As = nuEndS * ASiso + nuIntS * ASsha; \
                Ad = nuEndD * ADiso + nuIntD * ADsha; \
            end \
            1: begin \
                Ps = nuEndS * PSiso + nuIntS * PSsha; \
                Pd = (nuEndD + nuIntD) * PDsha; \
                As = nuEndS * ASiso + nuIntS * ASsha; \
                Ad = (nuEndD + nuIntD) * ADsha; \
            end \
            2: begin \
                Ps = (nuEndS + nuIntS) * PSsha; \
                Pd = nuEndD * PDiso + nuIntD * PDsha; \
                As = (nuEndS + nuIntS) * ASsha; \
                Ad = nuEndD * ADiso + nuIntD * ADsha; \
            end \
            3: begin \
                Ps = (nuEndS + nuIntS) * PSsha; \
                Pd = (nuEndD + nuIntD) * PDsha; \
                As = (nuEndS + nuIntS) * ASsha; \
                Ad = (nuEndD + nuIntD) * ADsha; \
            end \
            4: begin \
                Ps = nuEndS * PSiso + nuIntS * PSsha; \
                Pd = nuEndD * PDmer + nuIntD * PDsha; \
                As = nuEndS * ASiso + nuIntS * ASsha; \
                Ad = nuEndD * ADmer + nuIntD * ADsha; \
            end \
            5: begin \
                Ps = (nuEndS + nuIntS) * PSsha; \
                Pd = nuEndD * PDmer + nuIntD * PDsha; \
                As = (nuEndS + nuIntS) * ASsha; \
                Ad = nuEndD * ADmer + nuIntD * ADsha; \
            end \
            6: begin \
                Ps = nuEndS * PSmer + nuIntS * PSsha; \
                Pd = nuEndD * PDiso + nuIntD * PDsha; \
                As = nuEndS * ASmer + nuIntS * ASsha; \
                Ad = nuEndD * ADiso + nuIntD * ADsha; \
            end \
            7: begin \
                Ps = nuEndS * PSmer + nuIntS * PSsha; \
                Pd = (nuEndD + nuIntD) * PDsha; \
                As = nuEndS * ASmer + nuIntS * ASsha; \
                Ad = (nuEndD + nuIntD) * ADsha; \
            end \
            8: begin \
                Ps = nuEndS * PSmer + nuIntS * PSsha; \
                Pd = nuEndD * PDmer + nuIntD * PDsha; \
                As = nuEndS * ASmer + nuIntS * ASsha; \
                Ad = nuEndD * ADmer + nuIntD * ADsha; \
            end \
            9: begin \
                Ps = PSiso + (nf - 1.0) * PSsha; \
                Pd = nf * PDsha; \
                As = ASiso + (nf - 1.0) * ASsha; \
                Ad = nf * ADsha; \
            end \
            10: begin \
                Ps = nf * PSsha; \
                Pd = PDiso + (nf - 1.0) * PDsha; \
                As = nf * ASsha; \
                Ad = ADiso + (nf - 1.0) * ADsha; \
            end \
            default: begin \
                `STROBE2("Warning: (instance %M) Specified GEO = %d not matched (BSIMBULKPAeffGeo \
                ), PS,PD,AS,AD set to zero.", geo); \
                Ps = 0; \
                Pd = 0; \
                As = 0; \
                Ad = 0; \
            end \
        endcase \
    end \
 // Specific to DD model Definition,

// Other constants
`define invSqrt2              7.0710678118654746e-01
`define oneSixth              1.6666666666666667e-01

//  ----Ending defining additional constants for DD-Model -----------------

// Numerical Constants
`define EXPL_THRESHOLD  80.0
`define MAX_EXPL        5.540622384e34
`define MIN_EXPL        1.804851387e-35
`define N_MINLOG        1.0e-38
`define DELTA_1         0.02
`define Oneby3          0.33333333333333333
`define REFTEMP         300.15       // 27 degrees C
`define Eg300           1.115       // Energy gap at 300K

// Physical Constants
`define ntype       1
`define ptype       -1

//  Macros for the model/instance parameters
//
//  MPRxx    model    parameter real
//  MPIxx    model    parameter integer
//  IPRxx    instance parameter real
//  IPIxx    instance parameter integer
//     ||
//     cc    closed lower bound, closed upper bound
//     oo    open   lower bound, open   upper bound
//     co    closed lower bound, open   upper bound
//     oc    open   lower bound, closed upper bound
//     cz    closed lower bound = 0, open upper bound=inf
//     oz    open   lower bound = 0, open upper bound=inf
//     nb    no bounds
//     ex    no bounds with exclude
//     sw    switch(integer only, values  0 = false  and  1 = true)
//     ty    switch(integer only, values -1 = p-type and +1 = n-type)
//
//  LS linear scaling for instance parameters
//  QS quadratic scaling for instance parameters
//
//  IPM   instance parameter mFactor(multiplicity, implicit for LRM 2.2)
//  OPP   operating point parameter, includes units and description for printing

`define OPP(nam,uni,des)               (* units = uni, desc = des *)           real    nam;
`define OPM(nam,uni,des)               (* units = uni, desc = des, multiplicity = "multiply" *)  real    nam;
`define OPD(nam,uni,des)               (* units = uni, desc = des, multiplicity = "divide"   *)  real    nam;

`define MPRnb(nam,def,uni,        des) (* units = uni, desc = des *) parameter real    nam = def;
`define MPRex(nam,def,uni,exc,    des) (* units = uni, desc = des *) parameter real    nam = def exclude exc;
`define MPRcc(nam,def,uni,lwr,upr,des) (* units = uni, desc = des *) parameter real    nam = def from[lwr:upr];
`define MPRoo(nam,def,uni,lwr,upr,des) (* units = uni, desc = des *) parameter real    nam = def from(lwr:upr);
`define MPRco(nam,def,uni,lwr,upr,des) (* units = uni, desc = des *) parameter real    nam = def from[lwr:upr);
`define MPRoc(nam,def,uni,lwr,upr,des) (* units = uni, desc = des *) parameter real    nam = def from(lwr:upr];
`define MPRcz(nam,def,uni,        des) (* units = uni, desc = des *) parameter real    nam = def from[  0:inf);
`define MPRoz(nam,def,uni,        des) (* units = uni, desc = des *) parameter real    nam = def from(  0:inf);

`define MPInb(nam,def,uni,        des) (* units = uni, desc = des *) parameter integer nam = def;
`define MPIex(nam,def,uni,exc,    des) (* units = uni, desc = des *) parameter integer nam = def exclude exc;
`define MPIcc(nam,def,uni,lwr,upr,des) (* units = uni, desc = des *) parameter integer nam = def from[lwr:upr];
`define MPIoo(nam,def,uni,lwr,upr,des) (* units = uni, desc = des *) parameter integer nam = def from(lwr:upr);
`define MPIco(nam,def,uni,lwr,upr,des) (* units = uni, desc = des *) parameter integer nam = def from[lwr:upr);
`define MPIoc(nam,def,uni,lwr,upr,des) (* units = uni, desc = des *) parameter integer nam = def from(lwr:upr];
`define MPIcz(nam,def,uni,        des) (* units = uni, desc = des *) parameter integer nam = def from[  0:inf);
`define MPIoz(nam,def,uni,        des) (* units = uni, desc = des *) parameter integer nam = def from(  0:inf);
`define MPIsw(nam,def,uni,        des) (* units = uni, desc = des *) parameter integer nam = def from[  0:  1];
`define MPIty(nam,def,uni,        des) (* units = uni, desc = des *) parameter integer nam = def from[ -1:  1] exclude 0;
`define IPRnb(nam,def,uni,        des) (* units = uni, type = "instance", desc = des *) parameter real    nam = def;
`define IPRex(nam,def,uni,exc,    des) (* units = uni, type = "instance", desc = des *) parameter real    nam = def exclude exc;
`define IPRcc(nam,def,uni,lwr,upr,des) (* units = uni, type = "instance", desc = des *) parameter real    nam = def from[lwr:upr];
`define IPRoo(nam,def,uni,lwr,upr,des) (* units = uni, type = "instance", desc = des *) parameter real    nam = def from(lwr:upr);
`define IPRco(nam,def,uni,lwr,upr,des) (* units = uni, type = "instance", desc = des *) parameter real    nam = def from[lwr:upr);
`define IPRoc(nam,def,uni,lwr,upr,des) (* units = uni, type = "instance", desc = des *) parameter real    nam = def from(lwr:upr];
`define IPRcz(nam,def,uni,        des) (* units = uni, type = "instance", desc = des *) parameter real    nam = def from[  0:inf);
`define IPRoz(nam,def,uni,        des) (* units = uni, type = "instance", desc = des *) parameter real    nam = def from(  0:inf);
`define IPInb(nam,def,uni,        des) (* units = uni, type = "instance", desc = des *) parameter integer nam = def;
`define IPIex(nam,def,uni,exc,    des) (* units = uni, type = "instance", desc = des *) parameter integer nam = def exclude exc;
`define IPIcc(nam,def,uni,lwr,upr,des) (* units = uni, type = "instance", desc = des *) parameter integer nam = def from[lwr:upr];
`define IPIoo(nam,def,uni,lwr,upr,des) (* units = uni, type = "instance", desc = des *) parameter integer nam = def from(lwr:upr);
`define IPIco(nam,def,uni,lwr,upr,des) (* units = uni, type = "instance", desc = des *) parameter integer nam = def from[lwr:upr);
`define IPIoc(nam,def,uni,lwr,upr,des) (* units = uni, type = "instance", desc = des *) parameter integer nam = def from(lwr:upr];
`define IPIcz(nam,def,uni,        des) (* units = uni, type = "instance", desc = des *) parameter integer nam = def from[  0:inf);
`define IPIoz(nam,def,uni,        des) (* units = uni, type = "instance", desc = des *) parameter integer nam = def from(  0:inf);
`define BPRco(nam, def, uni, lwr, upr, des) (* units = uni, type = "instance", desc = des *) parameter real    nam = def from[lwr : upr);
`define BPRoz(nam, def, uni,           des) (* units = uni, type = "instance", desc = des *) parameter real    nam = def from(0.0 : inf);
`define BPRcz(nam, def, uni,           des) (* units = uni, type = "instance", desc = des *) parameter real    nam = def from[0.0 : inf);
`define BPIcc(nam, def, uni, lwr, upr, des) (* units = uni, type = "instance", desc = des *) parameter integer nam = def from[lwr : upr];
`define BPInb(nam,def,uni,        des) (* units = uni, type = "instance", desc = des *) parameter integer nam = def;
`define BPRnb(nam,def,uni,        des) (* units = uni, type = "instance", desc = des *) parameter real nam = def;

`define LS , scale="linear"
`define QS , scale="quadratic"

module bsimsoi(d, g, s, e, b, t);
inout d, g, s, e, b, t;
electrical d, g, s, e, b, di, si, gi, gm, bi, bi2;
thermal t;

// Extra internal nodes and branches (TNOIMOD=1) for correlated drain and gate noise
electrical N1, N2;
branch (N1) NI;
branch (N1) NR;
branch (N1) NC;

// Clamped exponential function
analog function real lexp;
    input x;
    real x;
    begin
        if (x > `EXPL_THRESHOLD) begin
            lexp = `MAX_EXPL * (1.0 + x - `EXPL_THRESHOLD);
        end else if (x < -`EXPL_THRESHOLD) begin
            lexp = `MIN_EXPL;
        end else begin
            lexp = exp(x);
        end
    end
endfunction

// Clamped log function
analog function real lln;
    input x;
    real x;
    begin
        lln = ln(max(x, `N_MINLOG));
    end
endfunction

// Hyperbolic smoothing function
analog function real hypsmooth;
    input x, c;
    real x, c;
    begin
        hypsmooth = 0.5 * (x + sqrt(x * x + 4.0 * c * c));
    end
endfunction

// Hyperbolic smoothing with a maximum value
analog function real hypmax;
    input x, xmin, c;
    real x, xmin, c;
    begin
        hypmax=(xmin + 0.5 * (x - xmin - c + sqrt((x - xmin - c) * (x - xmin - c) - 4.0 * xmin * c)));
    end
endfunction

// ln(1 + exp(x)) function
analog function real ln_one_plus_exp;
    input x; real x;
    begin
        if (x > 37) begin
            ln_one_plus_exp = x;
        end else if (x < -37) begin
            ln_one_plus_exp = exp(x);
        end else begin
            ln_one_plus_exp = ln(1.0 + exp(x));
        end
    end
endfunction

// Pure instance parameters
`IPRoz( L                 ,1.0e-5                                   ,"m"   `LS                               ,"Length" )
`IPRoz( W                 ,1.0e-5                                   ,"m"   `LS                               ,"Total width including fingers" )
`IPIco( NF                ,1                                        ,""            ,1           ,inf         ,"Number of fingers" )
`IPRcz( NRS               ,1.0                                      ,""                                      ,"Number of squares in source" )
`IPRcz( NRD               ,1.0                                      ,""                                      ,"Number of squares in drain" )
`IPRnb( VFBSDOFF          ,0.0                                      ,"V"                                     ,"Flatband voltage offset parameter" )
`IPIcc( MINZ              ,0                                        ,""            ,0           ,1           ,"Minimize either drain or source" )
`IPIcc( RGATEMOD          ,0                                        ,""            ,0           ,3           ,"Gate resistance model selector" )
`IPIcc( GEOMOD            ,0                                        ,""            ,0           ,10          ,"Geometry-dependent parasitics model" )
`IPIcc( RGEOMOD           ,0                                        ,""            ,0           ,8           ,"Geometry-dependent source/drain resistance,  0: RSH-based, 1: Holistic" )
`IPRnb( SA                ,0.0                                      ,"m"   `LS                               ,"Distance between OD edge from poly from one side" )
`IPRnb( SB                ,0.0                                      ,"m"   `LS                               ,"Distance between OD edge from poly from other side" )
`IPRnb( SD                ,0.0                                      ,"m"   `LS                               ,"Distance between neighboring fingers" )
`IPRoo( SCA               ,0.0                                      ,""            ,-inf        ,inf         ,"Integral of the first distribution function for scattered well dopants" )
`IPRoo( SCB               ,0.0                                      ,""            ,-inf        ,inf         ,"Integral of second distribution function for scattered well dopants" )
`IPRoo( SCC               ,0.0                                      ,""            ,-inf        ,inf         ,"Integral of third distribution function for scattered well dopants" )
`IPRoo( SC                ,0.0                                      ,"m"   `LS     ,-inf        ,inf         ,"Distance to a single well edge; if <= 0.0, turn off WPE" )
`IPRcz( AS                ,0.0                                      ,"m^2" `QS                               ,"Source-to-substrate junction area" )
`IPRcz( AD                ,0.0                                      ,"m^2" `QS                               ,"Drain-to-substrate junction area" )
`IPRcz( PS                ,0.0                                      ,"m"   `LS                               ,"Source-to-substrate junction perimeter" )
`IPRcz( PD                ,0.0                                      ,"m"   `LS                               ,"Drain-to-substrate junction perimeter" )

// Both model and instance parameters
`BPRnb( XGW               ,0.0                                      ,"m"   `LS                               ,"Distance from gate contact center to device edge" )
`BPIcc( NGCON             ,1                                        ,""            ,1           ,2           ,"Number of gate contacts" )
`BPRnb( DTEMP             ,0.0                                      ,"K"                                     ,"Offset of device temperature" )
`BPRnb( MULU0             ,1.0                                      ,"m^2/(V*s)"                             ,"Multiplication factor for low field mobility" )
`BPRnb( DELVTO            ,0.0                                      ,"V"                                     ,"Zero bias threshold voltage variation" )
`BPRcz( IDS0MULT          ,1.0                                      ,""                                      ,"Variability in drain current for miscellaneous reasons" )
`BPIcc( EDGEFET           ,0                                        ,""            ,0           ,1           ,"0: Edge FET Model OFF, 1: Edge FET Model ON" )
`BPIcc( SSLMOD            ,0                                        ,""            ,0           ,1           ,"Sub-surface leakage drain current, 0: Turn off  1: Turn on" )

// Pure model parameters
`MPIcc( SOIMOD            ,0                                        ,""            ,0           ,1           ,"0: PDSOI mode,  1: DDSOI mode" )
`MPIty( TYPE              ,`ntype                                   ,""                                      ,"N-type = 1, P-type = -1" )
`MPIcc( CVMOD             ,0                                        ,""            ,0           ,1           ,"0: Consistent I-V/C-V, 1: Different I-V/C-V" )
`MPIcc( COVMOD            ,0                                        ,""            ,0           ,1           ,"0: Use bias-independent overlap capacitances,  1: Use bias-dependent overlap capacitances" )
`MPIcc( RDSMOD            ,0                                        ,""            ,0           ,2           ,"0: Internal bias dependent and external bias independent S/D resistance model, 1: External S/D resistance model, 2: Internal S/D resistance model" )
`MPIcc( WPEMOD            ,0                                        ,""            ,0           ,1           ,"Model flag" )
`MPIcc( ASYMMOD           ,0                                        ,""            ,0           ,1           ,"0: Asymmetry model turned off - forward mode parameters used,  1: Asymmetry model turned on" )
`MPIcc( GIDLMOD           ,0                                        ,""            ,0           ,1           ,"0: Turn off GIDL current,  1: Turn on GIDL current" )
`MPIcc( IGCMOD            ,0                                        ,""            ,0           ,1           ,"0: Turn off Igc, Igs and Igd, 1: Turn on Igc, Igs and Igd" )
`MPIcc( IGBMOD            ,0                                        ,""            ,0           ,1           ,"0: Turn off Igb, 1: Turn on Igb" )
`MPIcc( TNOIMOD           ,0                                        ,""            ,0           ,1           ,"Thermal noise model selector" )
`IPIcc( TNODEOUT          ,0                                        ,""            ,0           ,1           ,"Flag indicating external temperature node" )
`MPIcc( SHMOD             ,0                                        ,""            ,0           ,1           ,"0: Self heating model OFF, 1: Self heating model ON" )
`MPIcc( MOBSCALE          ,0                                        ,""            ,0           ,1           ,"Mobility scaling model, 0: Old Model,  1: New Model" )
`MPIcc( BODYMOD           ,0                                        ,""            ,0           ,2           ,"Flag for body contact mode 0: Floating body,  1: linear 2: non-linear (bias-dependent RB)" )
`MPIcc( IIIMOD            ,0                                        ,""            ,0           ,2           ,"Flag for III selector" )

`MPIcc( MODAGBCP2         ,0                                        ,""            ,0           ,1           ,"0: AGBCP2 OFF, 1: AGBCP2 ON" )
`MPIcc( PDEMOD            ,0                                        ,""            ,0           ,1           ,"0: PDE OFF, 1: PDE ON - for DD model" )
`MPIcc( FBODY1            ,0                                        ,""            ,0           ,1           ,"0: Extrinsic S/D substrate charge ON, 1: PExtrinsic S/D substrate charge OFF"  )
`MPRoz( TEMPH             ,700                                      ,"K"                                     ,"Maximum device temperature in Kelvin before the simulation gives a warning" )
// Device parameters
`MPRoz( LLONG             ,1.0e-5                                   ,"m"                                     ,"L of extracted long channel device" )
`MPRoz( LMLT              ,1.0                                      ,""                                      ,"Length shrinking parameter" )
`MPRoz( WMLT              ,1.0                                      ,""                                      ,"Width shrinking parameter" )
`MPRnb( XL                ,0.0                                      ,"m"                                     ,"L offset for channel length due to mask/etch effect" )
`MPRoz( WWIDE             ,1.0e-5                                   ,"m"                                     ,"W of extracted wide channel device" )
`MPRnb( XW                ,0.0                                      ,"m"                                     ,"W offset for channel width due to mask/etch effect" )
`MPRnb( LINT              ,0.0                                      ,"m"                                     ,"Delta L for I-V" )
`MPRnb( LL                ,0.0                                      ,"m^(1+LLN)"                             ,"Length reduction parameter" )
`MPRnb( LW                ,0.0                                      ,"m^(1+LWN)"                             ,"Length reduction parameter" )
`MPRnb( LWL               ,0.0                                      ,"m^(1+LLN+LWN)"                         ,"Length reduction parameter" )
`MPRnb( LLN               ,1.0                                      ,""                                      ,"Length reduction parameter" )
`MPRnb( LWN               ,1.0                                      ,""                                      ,"Length reduction parameter" )
`MPRnb( WINT              ,0.0                                      ,"m"                                     ,"Delta W for I-V" )
`MPRnb( WL                ,0.0                                      ,"m^(1+WLN)"                             ,"Width reduction parameter" )
`MPRnb( WW                ,0.0                                      ,"m^(1+WWN)"                             ,"Width reduction parameter" )
`MPRnb( WWL               ,0.0                                      ,"m^(1+WWN+WLN)"                         ,"Width reduction parameter" )
`MPRnb( WLN               ,1.0                                      ,""                                      ,"Width reduction parameter" )
`MPRnb( WWN               ,1.0                                      ,""                                      ,"Width reduction parameter" )
`MPRnb( DLC               ,0.0                                      ,"m"                                     ,"Delta L for C-V" )
`MPRnb( LLC               ,0.0                                      ,"m^(1+LLN)"                             ,"Length reduction parameter" )
`MPRnb( LWC               ,0.0                                      ,"m^(1+LWN)"                             ,"Length reduction parameter" )
`MPRnb( LWLC              ,0.0                                      ,"m^(1+LWN+LLN)"                         ,"Length reduction parameter" )
`MPRnb( DWC               ,0.0                                      ,"m"                                     ,"Delta W for C-V" )
`MPRnb( WLC               ,0.0                                      ,"m^(1+WLN)"                             ,"Width reduction parameter" )
`MPRnb( WWC               ,0.0                                      ,"m^(1+WWN)"                             ,"Width reduction parameter" )
`MPRnb( WWLC              ,0.0                                      ,"m^(1+WWN+WLN)"                         ,"Width reduction parameter" )
`MPRoo( TSI               ,40e-9                                    ,"m"           ,0.0         ,inf         ,"Silicon-on-insulator thickness" )
`MPRoo( TBOX              ,200e-9                                   ,"m"           ,0.0         ,inf         ,"Back gate oxide thickness in meters" )
`MPRoo( TOXE              ,3.0e-9                                   ,"m"           ,0.0         ,inf         ,"Effective gate dielectric thickness relative to SiO2" )
`MPRoo( TOXP              ,TOXE                                     ,"m"           ,0.0         ,inf         ,"Physical gate dielectric thickness. If not given, TOXP is calculated from TOXE and DTOX" )
`MPRnb( DTOX              ,0.0                                      ,"m"                                     ,"Difference between effective dielectric thickness" )
`MPRnb( NDEP              ,1e24                                     ,"1/m^3"                                 ,"Channel doping concentration for I-V" )
`MPRnb( NDEPL1            ,0.0                                      ,"m"                                     ,"Length dependence coefficient of NDEP" )
`MPRoz( NDEPLEXP1         ,1.0                                      ,""                                      ,"Length dependence exponent coefficient of NDEP" )
`MPRnb( NDEPL2            ,0.0                                      ,"m"                                     ,"Length dependence of NDEP - For Short Channel Devices" )
`MPRoz( NDEPLEXP2         ,2.0                                      ,""                                      ,"Length dependence exponent coefficient of NDEP" )
`MPRnb( NDEPW             ,0.0                                      ,"m"                                     ,"Width dependence coefficient of NDEP" )
`MPRoz( NDEPWEXP          ,1.0                                      ,""                                      ,"Width dependence exponent coefficient of NDEP" )
`MPRnb( NDEPWL            ,0.0                                      ,"m^2"                                   ,"Width-length dependence coefficient of NDEP" )
`MPRoz( NDEPWLEXP         ,1.0                                      ,""                                      ,"Width-length dependence exponent coefficient of NDEP" )
`MPRnb( LNDEP             ,0.0                                      ,"1/m^2"                                 ,"Length dependence of NDEP" )
`MPRnb( WNDEP             ,0.0                                      ,"1/m^2"                                 ,"Width dependence of NDEP" )
`MPRnb( PNDEP             ,0.0                                      ,"1/m"                                   ,"Area dependence of NDEP" )
`MPRnb( NDEPCV            ,NDEP                                     ,"1/m^3"                                 ,"Channel doping concentration for C-V" )
`MPRnb( NDEPCVL1          ,NDEPL1                                   ,"m"                                     ,"Length dependence coefficient of NDEPCV" )
`MPRoz( NDEPCVLEXP1       ,NDEPLEXP1                                ,""                                      ,"Length dependence exponent coefficient of NDEPCV" )
`MPRnb( NDEPCVL2          ,NDEPL2                                   ,"m"                                     ,"Length dependence coefficient of NDEPCV - For Short Channel Devices" )
`MPRoz( NDEPCVLEXP2       ,NDEPLEXP2                                ,""                                      ,"Length dependence exponent coefficient of NDEPCV" )
`MPRnb( NDEPCVW           ,NDEPW                                    ,"m"                                     ,"Width dependence coefficient of NDEPCV" )
`MPRoz( NDEPCVWEXP        ,NDEPWEXP                                 ,""                                      ,"Width dependence exponent coefficient of NDEPCV" )
`MPRnb( NDEPCVWL          ,NDEPWL                                   ,"m^2"                                   ,"Width-length dependence coefficient of NDEPCV" )
`MPRoz( NDEPCVWLEXP       ,NDEPWLEXP                                ,""                                      ,"Width-length dependence exponent coefficient of NDEPCV" )
`MPRnb( LNDEPCV           ,LNDEP                                    ,"1/m^2"                                 ,"Length dependence  of NDEP for C-V" )
`MPRnb( WNDEPCV           ,WNDEP                                    ,"1/m^2"                                 ,"Width dependence of NDEP for C-V" )
`MPRnb( PNDEPCV           ,PNDEP                                    ,"1/m"                                   ,"Area dependence of NDEP for C-V" )
`MPRnb( NGATE             ,5e25                                     ,"1/m^3"                                 ,"Gate doping concentration" )
`MPRnb( LNGATE            ,0.0                                      ,"1/m^2"                                 ,"Length dependence of NGATE" )
`MPRnb( WNGATE            ,0.0                                      ,"1/m^2"                                 ,"Width dependence of NGATE" )
`MPRnb( PNGATE            ,0.0                                      ,"1/m"                                   ,"Area dependence of NGATE" )
`MPRoz( NI0SUB            ,1.1e16                                   ,"1/m^3"                                 ,"Intrinsic carrier concentration of the substrate at 300.15K" )
`MPRoo( BG0SUB            ,1.17                                     ,"eV"          ,0.0         ,inf         ,"Bandgap of substrate at 300.15K" )
`MPRoo( EPSRSUB           ,11.9                                     ,""            ,0.0         ,inf         ,"Relative dielectric constant of the channel material" )
`MPRoo( EPSROX            ,3.9                                      ,""            ,0.0         ,inf         ,"Relative dielectric constant of the gate dielectric" )
`MPRnb( XJ                ,1.5e-7                                   ,"m"                                     ,"S/D junction depth" )
`MPRnb( LXJ               ,0.0                                      ,"m^2"                                   ,"Length dependence of XJ" )
`MPRnb( WXJ               ,0.0                                      ,"m^2"                                   ,"Width dependence of XJ" )
`MPRnb( PXJ               ,0.0                                      ,"m^3"                                   ,"Area dependence of XJ" )
`MPRnb( VFB               ,-0.5                                     ,"V"                                     ,"Flatband voltage" )
`MPRnb( LVFB              ,0.0                                      ,"V*m"                                   ,"Length dependence of VFB" )
`MPRnb( WVFB              ,0.0                                      ,"V*m"                                   ,"Width dependence of VFB" )
`MPRnb( PVFB              ,0.0                                      ,"V*m^2"                                 ,"Area dependence of VFB" )
`MPRnb( VFBB              ,0.0                                      ,"V"                                     ,"Flatband voltage for back gate" )
`MPRnb( LVFBB             ,0.0                                      ,"V*m"                                   ,"Length dependence of VFBB" )
`MPRnb( WVFBB             ,0.0                                      ,"V*m"                                   ,"Width dependence of VFBB" )
`MPRnb( PVFBB             ,0.0                                      ,"V*m^2"                                 ,"Area dependence of VFBB" )
`MPRnb( VFBL              ,0.0                                      ,"m"                                     ,"Length dependence coefficient of VFBCV" )
`MPRoz( VFBLEXP           ,1.0                                      ,""                                      ,"Length dependence exponent coefficient of VFBCV" )
`MPRnb( VFBW              ,0.0                                      ,"m"                                     ,"Width dependence coefficient of VFBCV" )
`MPRoz( VFBWEXP           ,1.0                                      ,""                                      ,"Width dependence exponent coefficient of VFBCV" )
`MPRnb( VFBWL             ,0.0                                      ,"m^2"                                   ,"Width-length dependence coefficient of VFBCV" )
`MPRoz( VFBWLEXP          ,1.0                                      ,""                                      ,"Width-length dependence coefficient of VFBCV" )
`MPRnb( VFBCV             ,VFB                                      ,"V"                                     ,"Flatband voltage for C-V" )
`MPRnb( LVFBCV            ,LVFB                                     ,"V*m"                                   ,"Length dependence of VFBCV" )
`MPRnb( WVFBCV            ,WVFB                                     ,"V*m"                                   ,"Width dependence of VFBCV" )
`MPRnb( PVFBCV            ,PVFB                                     ,"V*m^2"                                 ,"Area dependence of VFBCV" )
`MPRnb( VFBCVL            ,VFBL                                     ,"m"                                     ,"Length dependence coefficient of VFBCV" )
`MPRoz( VFBCVLEXP         ,VFBLEXP                                  ,""                                      ,"Length dependence exponent coefficient of VFBCV" )
`MPRnb( VFBCVW            ,VFBW                                     ,"m"                                     ,"Width dependence coefficient of VFBCV" )
`MPRoz( VFBCVWEXP         ,VFBWEXP                                  ,""                                      ,"Width dependence exponent coefficient of VFBCV" )
`MPRnb( VFBCVWL           ,VFBWL                                    ,"m^2"                                   ,"Width-length dependence coefficient of VFBCV" )
`MPRoz( VFBCVWLEXP        ,VFBWLEXP                                 ,""                                      ,"Width-length dependence coefficient of VFBCV" )
`MPRnb( DELVFBACC         ,0.0                                      ,""                                      ,"VFB shift in the accumulation region, valid for CVMOD = 1 only" )
`MPRnb( VFBBCV            ,VFBB                                     ,"V"                                     ,"Flatband voltage for back gate CVMOD=1" )
`MPRnb( LVFBBCV           ,LVFBB                                    ,"V*m"                                   ,"Length dependence of VFBBCV" )
`MPRnb( WVFBBCV           ,WVFBB                                    ,"V*m"                                   ,"Width dependence of VFBBCV" )
`MPRnb( PVFBBCV           ,PVFBB                                    ,"V*m^2"                                 ,"Area dependence of VFBBCV" )

//AGBCP2 related Capacitance
`MPRnb( VFBAGBCP2         ,VFB                                      ,"V"                                     ,"Flatband voltage for AGBCP2 C-V" )
`MPRoo( NDEPAGBCP2        ,NDEP                                     ,"1/m^3"       ,0           ,inf         ,"Channel doping concentration for AGBCP2" )

// Short channel effects
`MPRnb( NSD               ,1e26                                     ,"1/m^3"                                 ,"S/D doping concentration" )
`MPRnb( LNSD              ,0.0                                      ,"1/m^2"                                 ,"Length dependence of NSD" )
`MPRnb( WNSD              ,0.0                                      ,"1/m^2"                                 ,"Width dependence of NSD" )
`MPRnb( PNSD              ,0.0                                      ,"1/m"                                   ,"Area dependence of NSD" )
`MPRnb( DVTP0             ,0.0                                      ,"m"                                     ,"DITS" )
`MPRnb( LDVTP0            ,0.0                                      ,"m^2"                                   ,"Length dependence of DVTP0" )
`MPRnb( WDVTP0            ,0.0                                      ,"m^2"                                   ,"Width dependence of DVTP0" )
`MPRnb( PDVTP0            ,0.0                                      ,"m^3"                                   ,"Area dependence of DVTP0" )
`MPRnb( DVTP1             ,0.0                                      ,"1/V"                                   ,"DITS" )
`MPRnb( LDVTP1            ,0.0                                      ,"m/V"                                   ,"Length dependence of DVTP1" )
`MPRnb( WDVTP1            ,0.0                                      ,"m/V"                                   ,"Width dependence of DVTP1" )
`MPRnb( PDVTP1            ,0.0                                      ,"m^2/V"                                 ,"Area dependence of DVTP1" )
`MPRnb( DVTP2             ,0.0                                      ,"m*V"                                   ,"DITS" )
`MPRnb( LDVTP2            ,0.0                                      ,"V*m^2"                                 ,"Length dependence of DVTP2" )
`MPRnb( WDVTP2            ,0.0                                      ,"V*m^2"                                 ,"Width dependence of DVTP2" )
`MPRnb( PDVTP2            ,0.0                                      ,"V*m^3"                                 ,"Area dependence of DVTP2" )
`MPRnb( DVTP3             ,0.0                                      ,""                                      ,"DITS" )
`MPRnb( LDVTP3            ,0.0                                      ,"m"                                     ,"Length dependence of DVTP3" )
`MPRnb( WDVTP3            ,0.0                                      ,"m"                                     ,"Width dependence of DVTP3" )
`MPRnb( PDVTP3            ,0.0                                      ,"m^2"                                   ,"Area dependence of DVTP3" )
`MPRnb( DVTP4             ,0.0                                      ,"1/V"                                   ,"DITS" )
`MPRnb( LDVTP4            ,0.0                                      ,"m/V"                                   ,"Length dependence of DVTP4" )
`MPRnb( WDVTP4            ,0.0                                      ,"m/V"                                   ,"Width dependence of DVTP4" )
`MPRnb( PDVTP4            ,0.0                                      ,"m^2/V"                                 ,"Area dependence of DVTP4" )
`MPRnb( DVTP5             ,0.0                                      ,"V"                                     ,"DITS" )
`MPRnb( LDVTP5            ,0.0                                      ,"m*V"                                   ,"Length dependence of DVTP5" )
`MPRnb( WDVTP5            ,0.0                                      ,"m*V"                                   ,"Width dependence of DVTP5" )
`MPRnb( PDVTP5            ,0.0                                      ,"m^2*V"                                 ,"Area dependence of DVTP5" )
`MPRnb( DVBD0             ,0.0                                      ,""                                      ,"coupling from Vd to Vbs for improved dVbi model" )
`MPRnb( LDVBD0            ,0.0                                      ,"m"                                     ,"Length dependence of DVBD0" )
`MPRnb( WDVBD0            ,0.0                                      ,"m"                                     ,"Width dependence of DVBD0" )
`MPRnb( PDVBD0            ,0.0                                      ,"m^2"                                   ,"Area dependence of DVBD0" )

`MPRnb( DVBD1             ,0.0                                      ,""                                      ,"coupling from Vd to Vbs for improved dVbi model" )
`MPRnb( LDVBD1            ,0.0                                      ,"m"                                     ,"Length dependence of DVBD1" )
`MPRnb( WDVBD1            ,0.0                                      ,"m"                                     ,"Width dependence of DVBD1" )
`MPRnb( PDVBD1            ,0.0                                      ,"m^2"                                   ,"Area dependence of DVBD1" )

`MPRnb( VSCE              ,0.0                                      ,""                                      ,"coupling from Vd to Vbs for improved dVbi model" )
`MPRnb( LVSCE             ,0.0                                      ,"m"                                     ,"Length dependence of DVBD1" )
`MPRnb( WVSCE             ,0.0                                      ,"m"                                     ,"Width dependence of DVBD1" )
`MPRnb( PVSCE             ,0.0                                      ,"m^2"                                   ,"Area dependence of DVBD1" )
`MPRnb( CDSBS1            ,1.0                                      ,""                                      ,"coupling from Vd to Vbs for improved dVbi model" )
`MPRnb( LCDSBS1           ,0.0                                      ,"m"                                     ,"Length dependence of CDSBS" )
`MPRnb( WCDSBS1           ,0.0                                      ,"m"                                     ,"Width dependence of CDSBS" )
`MPRnb( PCDSBS1           ,0.0                                      ,"m^2"                                   ,"Area dependence of CDSBS" )
`MPRnb( CDSBS             ,0.0                                      ,""                                      ,"coupling from Vd to Vbs for improved dVbi model" )
`MPRnb( LCDSBS            ,0.0                                      ,"m"                                     ,"Length dependence of CDSBS" )
`MPRnb( WCDSBS            ,0.0                                      ,"m"                                     ,"Width dependence of CDSBS" )
`MPRnb( PCDSBS            ,0.0                                      ,"m^2"                                   ,"Area dependence of CDSBS" )
`MPRnb( PHIN              ,0.045                                    ,"V"                                     ,"Non-uniform vertical doping effect on surface potential" )
`MPRnb( LPHIN             ,0.0                                      ,"m*V"                                   ,"Length dependence of PHIN" )
`MPRnb( WPHIN             ,0.0                                      ,"m*V"                                   ,"Width dependence of PHIN" )
`MPRnb( PPHIN             ,0.0                                      ,"m^2*V"                                 ,"Area dependence of PHIN" )
`MPRnb( ETA0              ,0.08                                     ,""                                      ,"DIBL coefficient" )
`MPRnb( LETA0             ,0.0                                      ,"m"                                     ,"Length dependence of ETA0" )
`MPRnb( WETA0             ,0.0                                      ,"m"                                     ,"Width dependence of ETA0" )
`MPRnb( PETA0             ,0.0                                      ,"m^2"                                   ,"Area dependence of ETA0" )
`MPRnb( ETA0R             ,ETA0                                     ,""                                      ,"DIBL coefficient" )
`MPRnb( LETA0R            ,LETA0                                    ,"m"                                     ,"Length dependence of ETA0R" )
`MPRnb( WETA0R            ,WETA0                                    ,"m"                                     ,"Width dependence of ETA0R" )
`MPRnb( PETA0R            ,PETA0                                    ,"m^2"                                   ,"Area dependence of ETA0R" )
`MPRnb( DSUB              ,1.0                                      ,""                                      ,"Length scaling exponent for DIBL" )
`MPRnb( ETAB              ,-0.07                                    ,"1/V"                                   ,"Body bias coefficient for subthreshold DIBL effect" )
`MPRoz( ETABEXP           ,1.0                                      ,""                                      ,"Exponent coefficient of ETAB" )
`MPRnb( LETAB             ,0.0                                      ,"m/V"                                   ,"Length dependence of ETAB" )
`MPRnb( WETAB             ,0.0                                      ,"m/V"                                   ,"Width dependence of ETAB" )
`MPRnb( PETAB             ,0.0                                      ,"m^2/V"                                 ,"Area dependence of ETAB" )

`MPRnb( K1                ,0.0                                      ,"V^0.5"                                 ,"First-order body-bias Vth shift due to vertical non-uniform doping" )
`MPRnb( K1L               ,0.0                                      ,""                                      ,"length dependence coefficient of K1" )
`MPRoz( K1LEXP            ,1.0                                      ,""                                      ,"Length dependence exponent coefficient of K1" )
`MPRnb( K1W               ,0.0                                      ,""                                      ,"Width dependence coefficient of K1" )
`MPRoz( K1WEXP            ,1.0                                      ,""                                      ,"Width dependence exponent coefficient of K1" )
`MPRnb( K1WL              ,0.0                                      ,""                                      ,"Width-length dependence coefficient of K1" )
`MPRoz( K1WLEXP           ,1.0                                      ,""                                      ,"Width-length dependence exponent coefficient of K1" )
`MPRnb( LK1               ,0.0                                      ,"m*V^0.5"                               ,"Length dependence of K1" )
`MPRnb( WK1               ,0.0                                      ,"m*V^0.5"                               ,"Width dependence of K1" )
`MPRnb( PK1               ,0.0                                      ,"m^2*V^0.5"                             ,"Area dependence of K1" )
`MPRnb( K2                ,0.0                                      ,"V"                                     ,"Vth shift due to vertical non-uniform doping" )
`MPRnb( K2L               ,0.0                                      ,"m^K2LEXP"                              ,"Length dependence coefficient of K2" )
`MPRoz( K2LEXP            ,1.0                                      ,""                                      ,"Length dependence exponent coefficient of K2" )
`MPRnb( K2W               ,0.0                                      ,"m^K2WEXP"                              ,"Width dependence coefficient of K2" )
`MPRoz( K2WEXP            ,1.0                                      ,""                                      ,"Width dependence exponent coefficient of K2" )
`MPRnb( K2WL              ,0.0                                      ,"m^(2*K2WLEXP)"                         ,"Width-length dependence coefficient of K2" )
`MPRoz( K2WLEXP           ,1.0                                      ,""                                      ,"Width-length dependence exponent coefficient of K2" )
`MPRnb( LK2               ,0.0                                      ,"V*m"                                     ,"Length dependence of K2" )
`MPRnb( WK2               ,0.0                                      ,"V*m"                                     ,"Width dependence of K2" )
`MPRnb( PK2               ,0.0                                      ,"V*m^2"                                   ,"Area dependence of K2" )

// Quantum mechanical effects
`MPRcz( ADOS              ,0.0                                      ,""                                      ,"Quantum mechanical effect pre-factor switch in inversion" )
`MPRcz( BDOS              ,1.0                                      ,""                                      ,"Charge centroid parameter - slope of C-V curve under QME in inversion" )
`MPRoz( QM0               ,1.0e-3                                   ,""                                      ,"Charge centroid parameter - starting point for QME in inversion" )
`MPRcz( ETAQM             ,0.54                                     ,""                                      ,"Bulk charge coefficient for charge centroid in inversion" )

// Sub-threshold swing factor
`MPRnb( CIT               ,0.0                                      ,"F/m^2"                                 ,"Parameter for interface traps" )
`MPRnb( LCIT              ,0.0                                      ,"F/m"                                   ,"Length dependence of CIT" )
`MPRnb( WCIT              ,0.0                                      ,"F/m"                                   ,"Width dependence of CIT" )
`MPRnb( PCIT              ,0.0                                      ,"F"                                     ,"Area dependence of CIT" )
`MPRnb( NFACTOR           ,0.0                                      ,""                                      ,"Subthreshold slope factor" )
`MPRnb( NFACTORL          ,0.0                                      ,"m^NFACTORLEXP"                         ,"Length dependence coefficient of NFACTOR" )
`MPRoz( NFACTORLEXP       ,1.0                                      ,""                                      ,"Length dependence exponent coefficient of NFACTOR" )
`MPRnb( NFACTORW          ,0.0                                      ,"m^NFACTORWEXP"                         ,"Width dependence coefficient of NFACTOR" )
`MPRoz( NFACTORWEXP       ,1.0                                      ,""                                      ,"Width dependence exponent coefficient of NFACTOR" )
`MPRnb( NFACTORWL         ,0.0                                      ,"m^(2*NFACTORWLEXP)"                    ,"Width-length dependence coefficient of NFACTOR" )
`MPRoz( NFACTORWLEXP      ,1.0                                      ,""                                      ,"Width-length dependence exponent coefficient of NFACTOR" )
`MPRnb( LNFACTOR          ,0.0                                      ,"m"                                     ,"Length dependence of NFACTOR" )
`MPRnb( WNFACTOR          ,0.0                                      ,"m"                                     ,"Width dependence of NFACTOR" )
`MPRnb( PNFACTOR          ,0.0                                      ,"m^2"                                   ,"Area dependence of NFACTOR" )
`MPRnb( ASCL              ,0.0                                      ,""                                      ,"Parameter for back-gate dependent scale length" )
`MPRnb( LASCL             ,0.0                                      ,"m"                                     ,"L-term of ASCL" )
`MPRnb( WASCL             ,0.0                                      ,"m"                                     ,"W-term of ASCL" )
`MPRnb( PASCL             ,0.0                                      ,"m^2"                                   ,"P-term of ASCL" )
`MPRnb( BSCL              ,0.0                                      ,""                                      ,"Parameter for back-gate dependent scale length" )
`MPRnb( LBSCL             ,0.0                                      ,"m"                                     ,"L-term of BSCL" )
`MPRnb( WBSCL             ,0.0                                      ,"m"                                     ,"W-term of BSCL" )
`MPRnb( PBSCL             ,0.0                                      ,"m^2"                                   ,"P-term of BSCL" )
`MPRnb( DVT1              ,1.0                                      ,""                                      ,"SCE coefficient" )
`MPRnb( LDVT1             ,0.0                                      ,"m"                                     ,"L-term of DVT1" )
`MPRnb( WDVT1             ,0.0                                      ,"m"                                     ,"W-term of DVT1" )
`MPRnb( PDVT1             ,0.0                                      ,"m^2"                                   ,"P-term of DVT1" )
`MPRnb( CDSCD             ,0.0                                      ,"F/m^2/V"                               ,"Drain bias sensitivity of subthreshold slope" )
`MPRnb( LCDSCD            ,0.0                                      ,"F/m/V"                                 ,"Length dependence of CDSCD" )
`MPRnb( WCDSCD            ,0.0                                      ,"F/m/V"                                 ,"Width dependence of CDSCD" )
`MPRnb( PCDSCD            ,0.0                                      ,"F/V"                                   ,"Area dependence of CDSCD" )
`MPRnb( CDSC              ,1e-9                                     ,"F/m^2/V"                               ,"Coupling capacitance between S/D and channel" )
`MPRnb( LCDSC             ,0.0                                      ,"F/m/V"                                 ,"Length dependence of CDSCD" )
`MPRnb( WCDSC             ,0.0                                      ,"F/m/V"                                 ,"Width dependence of CDSCD" )
`MPRnb( PCDSC             ,0.0                                      ,"F/V"                                   ,"Area dependence of CDSCD" )

`MPRnb( CSECSED           ,0.0                                      ,"F/(m^2*V^2)"                           ,"Substrate-bias sensitivity of CDSCD" )
`MPRnb( CBCBD             ,0.0                                      ,"F/(m^2*V^2)"                           ,"Body bias sensitivity of CDSCD" )
`MPRnb( CSECSE0           ,0.0                                      ,"F/(m^2*V)"                             ,"Substrate-bias  sensitivity of SS for long channel" )
`MPRnb( CSECSE0P          ,0.0                                      ,"F/(m^2*V^2)"                           ,"Substrate-bias  sensitivity of SS for long channel" )
`MPRnb( CSECSE            ,0.0                                      ,"F/(m^2*V)"                             ,"Substrate-bias  sensitivity of SS for long channel" )
`MPRnb( LCSECSE           ,0.0                                      ,"F/m/V"                                 ,"Length dependence of CDSCD" )
`MPRnb( WCSECSE           ,0.0                                      ,"F/m/V"                                 ,"Width dependence of CDSCD" )
`MPRnb( PCSECSE           ,0.0                                      ,"F/V"                                   ,"Area dependence of CDSCD" )
`MPRnb( CSECSEP           ,0.0                                      ,"F/(m^2*V)"                             ,"Substrate-bias  sensitivity of SS for long channel" )
`MPRnb( CBCB              ,0.0                                      ,"F/(m^2*V)"                             ,"Substrate-bias  sensitivity of SS for long channel" )
`MPRnb( LCBCB             ,0.0                                      ,"F/m/V"                                 ,"Length dependence of CDSCD" )
`MPRnb( WCBCB             ,0.0                                      ,"F/m/V"                                 ,"Width dependence of CDSCD" )
`MPRnb( PCBCB             ,0.0                                      ,"F/V"                                   ,"Area dependence of CDSCD" )

`MPRnb( CBCBP             ,0.0                                      ,"F/(m^2*V)"                             ,"Substrate-bias  sensitivity of SS for long channel" )

`MPRnb( CBCB0             ,0.0                                      ,"F/(m^2*V)"                             ,"Body-bias  sensitivity of SS for long channel" )
`MPRnb( CBCB0P            ,0.0                                      ,"F/(m^2*V^2)"                           ,"Body-bias  sensitivity of SS for long channel" )
`MPRnb( CDSCDL            ,0.0                                      ,"m^CDSCDLEXP"                           ,"Length dependence coefficient of CDSCD" )
`MPRoz( CDSCDLEXP         ,1.0                                      ,""                                      ,"Length dependence exponent coefficient of CDSCD" )
`MPRnb( CDSCDR            ,CDSCD                                    ,"F/m^2/V"                               ,"Drain bias sensitivity of subthreshold slope" )
`MPRnb( LCDSCDR           ,LCDSCD                                   ,"F/m/V"                                 ,"Length dependence of CDSCDR" )
`MPRnb( WCDSCDR           ,WCDSCD                                   ,"F/m/V"                                 ,"Width dependence of CDSCDR" )
`MPRnb( PCDSCDR           ,PCDSCD                                   ,"F/V"                                   ,"Area dependence of CDSCDR" )
`MPRnb( CDSCB             ,0.0                                      ,"F/m^2/V"                               ,"Body-bias sensitivity of subthreshold slope" )
`MPRnb( CDSCBL            ,0.0                                      ,"m^CDSCBLEXP"                           ,"Length dependence coefficient of CDSCB" )
`MPRoz( CDSCBLEXP         ,1.0                                      ,""                                      ,"Length dependence exponent coefficient of CDSCB" )
`MPRnb( LCDSCB            ,0.0                                      ,"F/m/V"                                 ,"Length dependence of CDSCB" )
`MPRnb( WCDSCB            ,0.0                                      ,"F/m/V"                                 ,"Width dependence of CDSCB" )
`MPRnb( PCDSCB            ,0.0                                      ,"F/V"                                   ,"Area dependence of CDSCB" )
`MPRnb( VBSA              ,0.0                                      ,"V"                                                                   ,"vbsa offset voltage" )
// Drain saturation voltage
`MPRnb( VSAT              ,1e5                                      ,"m/s"                                   ,"Saturation velocity" )
`MPRnb( LVSAT             ,0.0                                      ,"m^2/s"                                 ,"Length dependence of VSAT" )
`MPRnb( WVSAT             ,0.0                                      ,"m^2/s"                                 ,"Width dependence of VSAT" )
`MPRnb( PVSAT             ,0.0                                      ,"m^3/s"                                 ,"Area dependence of VSAT" )
`MPRnb( VSATL             ,0.0                                      ,"m^VSATLEXP"                            ,"Length dependence coefficient of VSAT" )
`MPRoz( VSATLEXP          ,1.0                                      ,""                                      ,"Length dependence exponent coefficient of VSAT" )
`MPRnb( VSATW             ,0.0                                      ,"m^VSATWEXP"                            ,"Width dependence coefficient of VSAT" )
`MPRoz( VSATWEXP          ,1.0                                      ,""                                      ,"Width dependence exponent coefficient of VSAT" )
`MPRnb( VSATWL            ,0.0                                      ,"m^(2*VSATWLEXP)"                       ,"Width-length dependence coefficient of VSAT" )
`MPRoz( VSATWLEXP         ,1.0                                      ,""                                      ,"Width-length dependence exponent coefficient of of VSAT" )
`MPRnb( VSATR             ,VSAT                                     ,"m/s"                                   ,"Saturation velocity" )
`MPRnb( LVSATR            ,LVSAT                                    ,"m^2/s"                                 ,"Length dependence of VSATR" )
`MPRnb( WVSATR            ,WVSAT                                    ,"m^2/s"                                 ,"Width dependence of VSATR" )
`MPRnb( PVSATR            ,PVSAT                                    ,"m^3/s"                                 ,"Area dependence of VSATR" )
`MPRnb( DELTA             ,0.125                                    ,""                                      ,"Smoothing function factor for Vdsat" )
`MPRnb( LDELTA            ,0.0                                      ,"m"                                     ,"Length dependence of DELTA" )
`MPRnb( WDELTA            ,0.0                                      ,"m"                                     ,"Width dependence of DELTA" )
`MPRnb( PDELTA            ,0.0                                      ,"m^2"                                   ,"Area dependence of DELTA" )
`MPRnb( DELTAL            ,0.0                                      ,"m^DELTALEXP"                           ,"Length dependence coefficient of DELTA" )
`MPRoz( DELTALEXP         ,1.0                                      ,""                                      ,"Length dependence exponent coefficient of DELTA" )
`MPRnb( VSATCV            ,VSAT                                     ,"m/s"                                   ,"VSAT parameter for C-V" )
`MPRnb( LVSATCV           ,LVSAT                                    ,"m^2/s"                                 ,"Length dependence of VSATCV" )
`MPRnb( WVSATCV           ,WVSAT                                    ,"m^2/s"                                 ,"Width dependence of VSATCV" )
`MPRnb( PVSATCV           ,PVSAT                                    ,"m^3/s"                                 ,"Area dependence of VSATCV" )
`MPRnb( VSATCVL           ,VSATL                                    ,"m^VSATLEXP"                            ,"Length dependence coefficient of VSATCV" )
`MPRoz( VSATCVLEXP        ,VSATLEXP                                 ,""                                      ,"Length dependence exponent coefficient of VSATCV" )
`MPRnb( VSATCVW           ,VSATW                                    ,"m^VSATWEXP"                            ,"Width dependence coefficient of VSATCV" )
`MPRoz( VSATCVWEXP        ,VSATWEXP                                 ,""                                      ,"Width dependence exponent coefficient of VSATCV" )
`MPRnb( VSATCVWL          ,VSATWL                                   ,"m^(2*VSATWLEXP)"                       ,"Width-length dependence coefficient of VSATCV" )
`MPRoz( VSATCVWLEXP       ,VSATWLEXP                                ,""                                      ,"Width-length dependence exponent coefficient of VSATCV" )
`MPRnb( THESAT            ,0.3                                      ,""                                      ,"Saturation velocity dependent parameter" )
`MPRnb( LTHESAT           ,0.0                                      ,"m"                                     ,"Length dependence of THESAT" )
`MPRnb( WTHESAT           ,0.0                                      ,"m"                                     ,"Width dependence of THESAT" )
`MPRnb( PTHESAT           ,0.0                                      ,"m^2"                                   ,"Area dependence of THESAT" )
`MPRnb( THESATCV          ,THESAT                                   ,""                                      ,"Saturation velocity dependent parameter for decoupled CV" )
`MPRnb( LTHESATCV         ,LTHESAT                                  ,"m"                                     ,"Length dependence of THESATCV for decoupled CV" )
`MPRnb( WTHESATCV         ,WTHESAT                                  ,"m"                                     ,"Width dependence of THESATCV for decoupled CV" )
`MPRnb( PTHESATCV         ,PTHESAT                                  ,"m^2"                                   ,"Area dependence of THESATCV for decoupled CV" )
`MPRnb( LPE1              ,0.0                                      ,""                                      ,"Equivalent length of pocket region at zero bias" )
`MPRnb( LLPE1             ,0.0                                      ,"m"                                     ,"Length dependence of LPE0" )
`MPRnb( WLPE1             ,0.0                                      ,"m"                                     ,"Width dependence of LPE0" )
`MPRnb( PLPE1             ,0.0                                      ,"m^2"                                   ,"Area dependence of LPE0" )

// Mobility degradation
`MPRoo( UP1               ,0.0                                      ,""            ,-inf        ,inf         ,"Mobility channel length coefficient" )
`MPRex( LP1               ,1.0e-8                                   ,"m"           ,0.0                      ,"Mobility channel length exponential coefficient" )
`MPRoo( UP2               ,0.0                                      ,""            ,-inf        ,inf         ,"Mobility channel length coefficient" )
`MPRex( LP2               ,1.0e-8                                   ,"m"           ,0.0                      ,"Mobility channel length exponential coefficient" )
`MPRnb( U0                ,67.0e-3                                  ,"m^2/V/s"                               ,"Low Field mobility." )
`MPRnb( U0L               ,0.0                                      ,"m^U0LEXP"                              ,"Length dependence coefficient of U0L" )
`MPRoz( U0LEXP            ,1.0                                      ,""                                      ,"Length dependence exponent coefficient of U0L" )
`MPRnb( LU0               ,0.0                                      ,"m^3/V/s"                               ,"Length dependence of U0" )
`MPRnb( WU0               ,0.0                                      ,"m^3/V/s"                               ,"Width dependence of U0" )
`MPRnb( PU0               ,0.0                                      ,"m^4/V/s"                               ,"Area dependence of U0" )
`MPRnb( U0R               ,U0                                       ,"m^2/V/s"                               ,"Reverse-mode Low Field mobility." )
`MPRnb( LU0R              ,LU0                                      ,"m^3/V/s"                               ,"Length dependence of U0R" )
`MPRnb( WU0R              ,WU0                                      ,"m^3/V/s"                               ,"Width dependence of U0R" )
`MPRnb( PU0R              ,PU0                                      ,"m^4/V/s"                               ,"Area dependence of U0R" )
`MPRnb( ETAMOB            ,1.0                                      ,""                                      ,"Effective field parameter (should be kept close to 1)" )
`MPRnb( UA                ,0.001                                    ,"(m/V)^EU"                              ,"Mobility reduction coefficient" )
`MPRnb( UAL               ,0.0                                      ,"m^UALEXP"                              ,"Length dependence coefficient of  UA" )
`MPRoz( UALEXP            ,1.0                                      ,""                                      ,"Length dependence exponent coefficient of  UA" )
`MPRnb( UAW               ,0.0                                      ,"m^UAWEXP"                              ,"Width dependence coefficient of UA" )
`MPRoz( UAWEXP            ,1.0                                      ,""                                      ,"Width dependence exponent coefficient of UA" )
`MPRnb( UAWL              ,0.0                                      ,"m^UAWLEXP"                             ,"Width-length dependence coefficient of UA" )
`MPRoz( UAWLEXP           ,1.0                                      ,""                                      ,"Width-length dependence coefficient of UA" )
`MPRnb( LUA               ,0.0                                      ,"m*(m/V)^EU"                            ,"Length dependence of UA" )
`MPRnb( WUA               ,0.0                                      ,"m*(m/V)^EU"                            ,"Width dependence of UA" )
`MPRnb( PUA               ,0.0                                      ,"m^2*(m/V)^EU"                          ,"Area dependence of UA" )
`MPRnb( UAR               ,UA                                       ,"(m/V)^EU"                              ,"Reverse-mode mobility reduction coefficient" )
`MPRnb( LUAR              ,LUA                                      ,"m*(m/V)^EU"                            ,"Length dependence of UAR" )
`MPRnb( WUAR              ,WUA                                      ,"m*(m/V)^EU"                            ,"Width dependence of UAR" )
`MPRnb( PUAR              ,PUA                                      ,"m^2*(m/V)^EU"                          ,"Area dependence of UAR" )
`MPRnb( EU                ,1.5                                      ,""                                      ,"Mobility reduction exponent" )
`MPRnb( LEU               ,0.0                                      ,"m"                                     ,"Length dependence of EU" )
`MPRnb( WEU               ,0.0                                      ,"m"                                     ,"Width dependence of EU" )
`MPRnb( PEU               ,0.0                                      ,"m^2"                                   ,"Area dependence of EU" )
`MPRnb( EUL               ,0.0                                      ,"m^EULEXP"                              ,"Length dependence coefficient of EU" )
`MPRoz( EULEXP            ,1.0                                      ,""                                      ,"Length dependence exponent coefficient of EU" )
`MPRnb( EUW               ,0.0                                      ,"m^EUWEXP"                              ,"Width dependence coefficient of EU" )
`MPRoz( EUWEXP            ,1.0                                      ,""                                      ,"Width dependence exponent coefficient of EU" )
`MPRnb( EUWL              ,0.0                                      ,"m^EUWLEXP"                             ,"Width-length dependence coefficient of EU" )
`MPRoz( EUWLEXP           ,1.0                                      ,""                                      ,"Width-length dependence coefficient of EU" )
`MPRnb( UD                ,0.001                                    ,""                                      ,"Coulomb scattering parameter" )
`MPRnb( UDL               ,0.0                                      ,"m^UDLEXP"                              ,"Length dependence coefficient of UD" )
`MPRoz( UDLEXP            ,1.0                                      ,""                                      ,"Length dependence exponent coefficient of UD" )
`MPRnb( LUD               ,0.0                                      ,"m"                                     ,"Length dependence of UD" )
`MPRnb( WUD               ,0.0                                      ,"m"                                     ,"Width dependence of UD" )
`MPRnb( PUD               ,0.0                                      ,"m^2"                                   ,"Area dependence of UD" )
`MPRnb( UDR               ,UD                                       ,""                                      ,"Reverse-mode Coulomb scattering parameter" )
`MPRnb( LUDR              ,LUD                                      ,"m"                                     ,"Length dependence of UDR" )
`MPRnb( WUDR              ,WUD                                      ,"m"                                     ,"Width dependence of UDR" )
`MPRnb( PUDR              ,PUD                                      ,"m^2"                                   ,"Area dependence of UDR" )
`MPRnb( UDB               ,0.0                                      ,""                                      ,"Coulomb scattering parameter" )
`MPRnb( UDBL              ,0.0                                      ,"m^UDLEXP"                              ,"Length dependence coefficient of UD" )
`MPRoz( UDBLEXP           ,1.0                                      ,""                                      ,"Length dependence exponent coefficient of UD" )
`MPRnb( LUDB              ,0.0                                      ,"m"                                     ,"Length dependence of UD" )
`MPRnb( WUDB              ,0.0                                      ,"m"                                     ,"Width dependence of UD" )
`MPRnb( PUDB              ,0.0                                      ,"m^2"                                   ,"Area dependence of UD" )
`MPRnb( UDBR              ,UDB                                      ,""                                      ,"Reverse-mode Coulomb scattering parameter" )
`MPRnb( LUDBR             ,LUDB                                     ,"m"                                     ,"Length dependence of UDR" )
`MPRnb( WUDBR             ,WUDB                                     ,"m"                                     ,"Width dependence of UDR" )
`MPRnb( PUDBR             ,PUDB                                     ,"m^2"                                   ,"Area dependence of UDR" )

`MPRnb( UCS               ,2.0                                      ,""                                      ,"Coulomb scattering parameter" )
`MPRnb( LUCS              ,0.0                                      ,"m"                                     ,"Length dependence of UCS" )
`MPRnb( WUCS              ,0.0                                      ,"m"                                     ,"Width dependence of UCS" )
`MPRnb( PUCS              ,0.0                                      ,"m^2"                                   ,"Area dependence of UCS" )
`MPRnb( UCSR              ,UCS                                      ,""                                      ,"Reverse-mode Coulomb scattering parameter" )
`MPRnb( LUCSR             ,LUCS                                     ,"m"                                     ,"Length dependence of UCSR" )
`MPRnb( WUCSR             ,WUCS                                     ,"m"                                     ,"Width dependence of UCSR" )
`MPRnb( PUCSR             ,PUCS                                     ,"m^2"                                   ,"Area dependence of UCSR" )
`MPRnb( UC                ,0.0                                      ,"(m/V)^EU/V"                            ,"Mobility reduction with body bias" )
`MPRnb( UCL               ,0.0                                      ,"m^UCLEXP"                              ,"Length dependence coefficient of UC" )
`MPRoz( UCLEXP            ,1.0                                      ,""                                      ,"Length dependence exponent coefficient of UC" )
`MPRnb( UCW               ,0.0                                      ,"m^UCWEXP"                              ,"Width dependence coefficient of UC" )
`MPRoz( UCWEXP            ,1.0                                      ,""                                      ,"Width dependence exponent coefficient of UC" )
`MPRnb( UCWL              ,0.0                                      ,"m^(2*UCWLEXP)"                         ,"Width-length dependence coefficient of UC" )
`MPRoz( UCWLEXP           ,1.0                                      ,""                                      ,"Width-length dependence exponent coefficient of UC" )
`MPRnb( LUC               ,0.0                                      ,"m*(m/V)^EU/V"                          ,"Length dependence of UC" )
`MPRnb( WUC               ,0.0                                      ,"m*(m/V)^EU/V"                          ,"Width dependence of UC" )
`MPRnb( PUC               ,0.0                                      ,"m^2*(m/V)^EU/V"                        ,"Area dependence of UC" )
`MPRnb( UCR               ,UC                                       ,"(m/V)^EU/V"                            ,"Reverse-mode mobility reduction with body bias" )
`MPRnb( LUCR              ,LUC                                      ,"m*(m/V)^EU/V"                          ,"Length dependence of UCR" )
`MPRnb( WUCR              ,WUC                                      ,"m*(m/V)^EU/V"                          ,"Width dependence of UCR" )
`MPRnb( PUCR              ,PUC                                      ,"m^2*(m/V)^EU/V"                        ,"Area dependence of UCR" )

// Channel length modulation
`MPRnb( PCLM              ,0.003                                    ,""                                      ,"CLM pre-factor" )
`MPRnb( PCLML             ,0.0                                      ,"m^PCLMLEXP"                            ,"Length dependence coefficient of PCLM" )
`MPRoz( PCLMLEXP          ,1.0                                      ,""                                      ,"Length dependence exponent coefficient of PCLM" )
`MPRnb( LPCLM             ,0.0                                      ,"m"                                     ,"Length dependence of PCLM" )
`MPRnb( WPCLM             ,0.0                                      ,"m"                                     ,"Width dependence of PCLM" )
`MPRnb( PPCLM             ,0.0                                      ,"m^2"                                   ,"Area dependence of PCLM" )
`MPRnb( PCLMR             ,PCLM                                     ,""                                      ,"Reverse-mode CLM pre-factor" )
`MPRnb( LPCLMR            ,LPCLM                                    ,"m"                                     ,"Length dependence of PCLMR" )
`MPRnb( WPCLMR            ,WPCLM                                    ,"m"                                     ,"Width dependence of PCLMR" )
`MPRnb( PPCLMR            ,PPCLM                                    ,"m^2"                                   ,"Area dependence of PCLMR" )
`MPRnb( PCLMG             ,0.0                                      ,"V"                                     ,"CLM pre-factor gate voltage dependence" )
`MPRnb( PCLMCV            ,PCLM                                     ,""                                      ,"CLM parameter for C-V" )
`MPRnb( PCLMCVL           ,PCLML                                    ,"m^PCLMLEXP"                            ,"Length dependence coefficient of PCLMCV" )
`MPRoz( PCLMCVLEXP        ,PCLMLEXP                                 ,""                                      ,"Length dependence exponent coefficient of PCLMCV" )
`MPRnb( LPCLMCV           ,LPCLM                                    ,"m"                                     ,"Length dependence of PCLMCV" )
`MPRnb( WPCLMCV           ,WPCLM                                    ,"m"                                     ,"Width dependence of PCLMCV" )
`MPRnb( PPCLMCV           ,PPCLM                                    ,"m^2"                                   ,"Area dependence of PCLMCV" )
`MPRnb( PSCBE1            ,4.24e8                                   ,"V/m"                                   ,"Substrate current body-effect coefficient" )
`MPRnb( LPSCBE1           ,0.0                                      ,"V"                                     ,"Length dependence of PSCBE1" )
`MPRnb( WPSCBE1           ,0.0                                      ,"V"                                     ,"Width dependence of PSCBE1" )
`MPRnb( PPSCBE1           ,0.0                                      ,"V*m"                                   ,"Area dependence of PSCBE1" )
`MPRnb( PSCBE2            ,1.0e-8                                   ,"m/V"                                   ,"Substrate current body-effect coefficient" )
`MPRnb( LPSCBE2           ,0.0                                      ,"m^2/V"                                 ,"Length dependence of PSCBE2" )
`MPRnb( WPSCBE2           ,0.0                                      ,"m^2/V"                                 ,"Width dependence of PSCBE2" )
`MPRnb( PPSCBE2           ,0.0                                      ,"m^3/V"                                 ,"Area dependence of PSCBE2" )
`MPRnb( PDITS             ,0.0                                      ,"1/V"                                   ,"Coefficient for drain-induced Vth shift" )
`MPRnb( LPDITS            ,0.0                                      ,"m/V"                                   ,"Length dependence of PDITS" )
`MPRnb( WPDITS            ,0.0                                      ,"m/V"                                   ,"Width dependence of PDITS" )
`MPRnb( PPDITS            ,0.0                                      ,"m^2/V"                                 ,"Area dependence of PDITS" )
`MPRcz( PDITSL            ,0.0                                      ,"1/m"                                   ,"L dependence of drain-induced Vth shift" )
`MPRnb( PDITSD            ,0.0                                      ,"1/V"                                   ,"Vds dependence of drain-induced Vth shift" )
`MPRnb( LPDITSD           ,0.0                                      ,"m/V"                                   ,"Length dependence of PDITSD" )
`MPRnb( WPDITSD           ,0.0                                      ,"m/V"                                   ,"Width dependence of PDITSD" )
`MPRnb( PPDITSD           ,0.0                                      ,"m^2/V"                                 ,"Area dependence of PDITSD" )

// S/D series resistances
`MPRcz( RSH               ,0.0                                      ,"ohm/square"                            ,"Source-drain sheet resistances" )
`MPRnb( PRWG              ,1.0                                      ,"1/V"                                   ,"Gate bias dependence of S/D extension resistances" )
`MPRnb( LPRWG             ,0.0                                      ,"m/V"                                   ,"Length dependence of PRWG" )
`MPRnb( WPRWG             ,0.0                                      ,"m/V"                                   ,"Width dependence of PRWG" )
`MPRnb( PPRWG             ,0.0                                      ,"m^2/V"                                 ,"Area dependence of PRWG" )
`MPRnb( PRWB              ,0.0                                      ,"1/V"                                   ,"Body bias dependence of resistances" )
`MPRnb( LPRWB             ,0.0                                      ,"m/V"                                   ,"Length dependence of PRWB" )
`MPRnb( WPRWB             ,0.0                                      ,"m/V"                                   ,"Width dependence of PRWB" )
`MPRnb( PPRWB             ,0.0                                      ,"m^2/V"                                 ,"Area dependence of PRWB" )
`MPRnb( PRWBL             ,0.0                                      ,"m^PRWBLEXP"                            ,"Length dependence coefficient of PPRWB" )
`MPRoz( PRWBLEXP          ,1.0                                      ,""                                      ,"Length dependence exponent coefficient of PPRWB" )
`MPRnb( WR                ,1.0                                      ,""                                      ,"W dependence parameter of S/D extension resistances" )
`MPRnb( LWR               ,0.0                                      ,"m"                                     ,"Length dependence of WR" )
`MPRnb( WWR               ,0.0                                      ,"m"                                     ,"Width dependence of WR" )
`MPRnb( PWR               ,0.0                                      ,"m^2"                                   ,"Area dependence of WR" )
`MPRnb( RSWMIN            ,0.0                                      ,"ohm*um^WR"                             ,"Source resistance per unit width at high Vgs (RDSMOD = 1)" )
`MPRnb( LRSWMIN           ,0.0                                      ,"ohm*um^WR*m"                           ,"Length dependence of RSWMIN" )
`MPRnb( WRSWMIN           ,0.0                                      ,"ohm*um^WR*m"                           ,"Width dependence of RSWMIN" )
`MPRnb( PRSWMIN           ,0.0                                      ,"ohm*um^WR*m^2"                         ,"Area dependence of RSWMIN" )
`MPRnb( RSW               ,10.0                                     ,"ohm*um^WR"                             ,"Zero bias source resistance (RDSMOD = 1)" )
`MPRnb( LRSW              ,0.0                                      ,"ohm*um^WR*m"                           ,"Length dependence of RSW" )
`MPRnb( WRSW              ,0.0                                      ,"ohm*um^WR*m"                           ,"Width dependence of RSW" )
`MPRnb( PRSW              ,0.0                                      ,"ohm*um^WR*m^2"                         ,"Area dependence of RSW" )
`MPRnb( RSWL              ,0.0                                      ,"m^RSWLEXP"                             ,"Geometrical scaling of RSW (RDSMOD = 1)" )
`MPRoz( RSWLEXP           ,1.0                                      ,""                                      ,"Geometrical scaling of RSW (RDSMOD = 1)" )
`MPRnb( RDWMIN            ,RSWMIN                                   ,"ohm*um^WR"                             ,"Drain resistance per unit width at high Vgs (RDSMOD = 1)" )
`MPRnb( LRDWMIN           ,LRSWMIN                                  ,"ohm*um^WR*m"                           ,"Length dependence of RDWMIN" )
`MPRnb( WRDWMIN           ,WRSWMIN                                  ,"ohm*um^WR*m"                           ,"Width dependence of RDWMIN" )
`MPRnb( PRDWMIN           ,PRSWMIN                                  ,"ohm*um^WR*m^2"                         ,"Area dependence of RDWMIN" )
`MPRnb( RDW               ,RSW                                      ,"ohm*um^WR"                             ,"Zero bias drain resistance (RDSMOD = 1)" )
`MPRnb( LRDW              ,LRSW                                     ,"ohm*um^WR*m"                           ,"Length dependence of RDW" )
`MPRnb( WRDW              ,WRSW                                     ,"ohm*um^WR*m"                           ,"Width dependence of RDW" )
`MPRnb( PRDW              ,PRSW                                     ,"ohm*um^WR*m^2"                         ,"Area dependence of RDW" )
`MPRnb( RDWL              ,RSWL                                     ,"m^RDWLEXP"                             ,"Geometrical scaling of RDW (RDSMOD = 1)" )
`MPRoz( RDWLEXP           ,RSWLEXP                                  ,""                                      ,"Geometrical scaling of RDW (RDSMOD = 1)" )
`MPRnb( RDSWMIN           ,0.0                                      ,"ohm*um^WR"                             ,"S/D Resistance per unit width at high Vgs (RDSMOD = 0 and RDSMOD = 2)" )
`MPRnb( LRDSWMIN          ,0.0                                      ,"ohm*um^WR*m"                           ,"Length dependence of RDSWMIN" )
`MPRnb( WRDSWMIN          ,0.0                                      ,"ohm*um^WR*m"                           ,"Width dependence of RDSWMIN" )
`MPRnb( PRDSWMIN          ,0.0                                      ,"ohm*um^WR*m^2"                         ,"Area dependence of RDSWMIN" )
`MPRnb( RDSW              ,20.0                                     ,"ohm*um^WR"                             ,"Zero bias resistance (RDSMOD = 0 and RDSMOD = 2)" )
`MPRnb( RDSWL             ,0.0                                      ,"m^RDSWLEXP"                            ,"Geometrical scaling of RDSW (RDSMOD = 0 and RDSMOD = 2)" )
`MPRoz( RDSWLEXP          ,1.0                                      ,""                                      ,"Geometrical scaling of RDSW (RDSMOD = 0 and RDSMOD = 2)" )
`MPRnb( LRDSW             ,0.0                                      ,"ohm*um^WR*m"                           ,"Length dependence of RDSW" )
`MPRnb( WRDSW             ,0.0                                      ,"ohm*um^WR*m"                           ,"Width dependence of RDSW" )
`MPRnb( PRDSW             ,0.0                                      ,"ohm*um^WR*m^2"                         ,"Area dependence of RDSW" )

// Velocity saturation
`MPRnb( PSAT              ,1.0                                      ,""                                      ,"Gmsat variation with gate bias" )
`MPRnb( LPSAT             ,0.0                                      ,"m"                                     ,"Length dependence of PSAT" )
`MPRnb( WPSAT             ,0.0                                      ,"m"                                     ,"Width dependence of PSAT" )
`MPRnb( PPSAT             ,0.0                                      ,"m^2"                                   ,"Area dependence of PSAT" )
`MPRnb( PSATCV            ,PSAT                                     ,""                                      ,"Gmsat variation with gate bias for CVMOD=1" )
`MPRnb( LPSATCV           ,LPSAT                                    ,"m"                                     ,"Length dependence of PSATCV" )
`MPRnb( WPSATCV           ,WPSAT                                    ,"m"                                     ,"Width dependence of PSATCV" )
`MPRnb( PPSATCV           ,PPSAT                                    ,"m^2"                                   ,"Area dependence of PSATCV" )
`MPRnb( PSATL             ,0.0                                      ,"m^PSATLEXP"                            ,"Length dependence coefficient of PSATL" )
`MPRoz( PSATLEXP          ,1.0                                      ,""                                      ,"Length dependence exponent coefficient of PSATLEXP" )
`MPRnb( PSATLCV           ,PSATL                                    ,"m^PSATLEXP"                            ,"Length dependence coefficient of PSATLCV" )
`MPRoz( PSATLEXPCV        ,PSATLEXP                                 ,""                                      ,"Length dependence exponent coefficient of PSATLEXPCV" )
`MPRnb( PSATB             ,0.0                                      ,"1/V"                                   ,"Body bias effect on Idsat" )
`MPRnb( PSATE             ,0.0                                      ,"1/V"                                   ,"Substrate bias effect on Idsat for DDSOI" )
`MPRnb( PSATBCV           ,PSATB                                    ,"1/V"                                   ,"Body bias effect on decoupled CV" )
`MPRnb( PSATECV           ,PSATE                                    ,"1/V"                                   ,"Substrate bias effect for decoupled CV" )
`MPRnb( PSATR             ,PSAT                                     ,""                                      ,"Reverse-mode Gmsat variation with gate bias" )
`MPRnb( LPSATR            ,LPSAT                                    ,"m"                                     ,"Length dependence of PSATR" )
`MPRnb( WPSATR            ,WPSAT                                    ,"m"                                     ,"Width dependence of PSATR" )
`MPRnb( PPSATR            ,PPSAT                                    ,"m^2"                                   ,"Area dependence of PSATR" )
`MPRnb( LPSATB            ,0.0                                      ,"m/V"                                   ,"Length dependence of PSATB" )
`MPRnb( WPSATB            ,0.0                                      ,"m/V"                                   ,"Width dependence of PSATB" )
`MPRnb( PPSATB            ,0.0                                      ,"m^2/V"                                 ,"Area dependence of PSATB" )
`MPRnb( LPSATE            ,0.0                                      ,"m/V"                                   ,"Length dependence of PSATE" )
`MPRnb( WPSATE            ,0.0                                      ,"m/V"                                   ,"Width dependence of PSATE" )
`MPRnb( PPSATE            ,0.0                                      ,"m^2/V"                                 ,"Area dependence of PSATE" )
`MPRnb( LPSATBCV          ,LPSATB                                   ,"m/V"                                   ,"Length dependence of PSATBCV" )
`MPRnb( WPSATBCV          ,WPSATB                                   ,"m/V"                                   ,"Width dependence of PSATBCV" )
`MPRnb( PPSATBCV          ,PPSATB                                   ,"m^2/V"                                 ,"Area dependence of PSATBCV" )
`MPRnb( LPSATECV          ,LPSATE                                   ,"m/V"                                   ,"Length dependence of PSATECV" )
`MPRnb( WPSATECV          ,WPSATE                                   ,"m/V"                                   ,"Width dependence of PSATECV" )
`MPRnb( PPSATECV          ,PPSATE                                   ,"m^2/V"                                 ,"Area dependence of PSATECV" )
`MPRoz( PSATX             ,1.0                                      ,""                                      ,"Fine tuning of PTWG effect" )
`MPRnb( PTWG              ,0.0                                      ,""                                      ,"Idsat variation with gate bias" )
`MPRnb( LPTWG             ,0.0                                      ,"m"                                     ,"Length dependence of PTWG" )
`MPRnb( WPTWG             ,0.0                                      ,"m"                                     ,"Width dependence of PTWG" )
`MPRnb( PPTWG             ,0.0                                      ,"m^2"                                   ,"Area dependence of PTWG" )
`MPRnb( PTWGL             ,0.0                                      ,"m^PTWGLEXP"                            ,"Length dependence coefficient of PTWG" )
`MPRoz( VP                ,0.05                                     ,""                                      ,"parameter for CLM dependence on VSAT, DD Model" )
`MPRnb( ALP               ,0.01                                     ,""                                      ,"parameter for CLM dependence on VSAT, DD Model" )
`MPRoz( VPCV              ,VP                                       ,""                                      ,"parameter for CLM dependence on VSATCV for decoupled CVMOD" )
`MPRnb( ALPCV             ,ALP                                      ,""                                      ,"parameter for CLM dependence on VSATCV for decoupled CVMOD" )
`MPRoz( PTWGLEXP          ,1.0                                      ,""                                      ,"Length dependence exponent coefficient of PTWG" )
`MPRnb( PTWGR             ,PTWG                                     ,""                                      ,"Reverse-mode Idsat variation with gate bias" )
`MPRnb( LPTWGR            ,LPTWG                                    ,"m"                                     ,"Length dependence of PTWGR" )
`MPRnb( WPTWGR            ,WPTWG                                    ,"m"                                     ,"Width dependence of PTWGR" )
`MPRnb( PPTWGR            ,PPTWG                                    ,"m^2"                                   ,"Area dependence of PTWGR" )
`MPRnb( KSATIV            ,1.0                                      ,""                                      ,"Parameter for Vdsat")
`MPRnb( LKSATIV           ,0.0                                      ,"m"                                     ,"Length dependence of KVSATIV" )
`MPRnb( WKSATIV           ,0.0                                      ,"m"                                     ,"Width dependence of KVSATIV" )
`MPRnb( PKSATIV           ,0.0                                      ,"m^2"                                   ,"Area dependence of KVSATIV" )
`MPRnb( KSATCV            ,KSATIV                                   ,""                                      ,"Parameter for Vdsat for decoupled CVMOD")
`MPRnb( LKSATCV           ,LKSATIV                                  ,"m"                                     ,"Length dependence of KVSATCV" )
`MPRnb( WKSATCV           ,WKSATIV                                  ,"m"                                     ,"Width dependence of KSATCV" )
`MPRnb( PKSATCV           ,PKSATIV                                  ,"m^2"                                   ,"Area dependence of KSATCV" )

// Velocity non-saturation effect
`MPRnb( A1                ,0.0                                      ,"1/V^2"                                 ,"Non-saturation effect parameter for strong inversion region" )
`MPRnb( LA1               ,0.0                                      ,"m/V^2"                                 ,"Length dependence of A1" )
`MPRnb( WA1               ,0.0                                      ,"m/V^2"                                 ,"Width dependence of A1" )
`MPRnb( PA1               ,0.0                                      ,"m^2/V^2"                               ,"Area dependence of A1" )
`MPRnb( A11               ,0.0                                      ,""                                      ,"Temperature dependence of A1" )
`MPRnb( LA11              ,0.0                                      ,"m"                                     ,"Length dependence of A11" )
`MPRnb( WA11              ,0.0                                      ,"m"                                     ,"Width dependence of A11" )
`MPRnb( PA11              ,0.0                                      ,"m^2"                                   ,"Area dependence of A11" )
`MPRnb( A2                ,0.0                                      ,"1/V"                                   ,"Non-saturation effect parameter for moderate inversion region" )
`MPRnb( LA2               ,0.0                                      ,"m/V"                                   ,"Length dependence of A2" )
`MPRnb( WA2               ,0.0                                      ,"m/V"                                   ,"Width dependence of A2" )
`MPRnb( PA2               ,0.0                                      ,"m^2/V"                                 ,"Area dependence of A2" )
`MPRnb( A21               ,0.0                                      ,""                                      ,"Temperature dependence of A2" )
`MPRnb( LA21              ,0.0                                      ,"m"                                     ,"Length dependence of A21" )
`MPRnb( WA21              ,0.0                                      ,"m"                                     ,"Width dependence of A21" )
`MPRnb( PA21              ,0.0                                      ,"m^2"                                   ,"Area dependence of A21" )

// Output conductance
`MPRnb( PDIBLC            ,0.0                                      ,""                                      ,"Parameter for DIBL effect on Rout" )
`MPRnb( PDIBLCL           ,0.0                                      ,"m^PDIBLCLEXP"                          ,"Length dependence coefficient of PDIBLC" )
`MPRoz( PDIBLCLEXP        ,1.0                                      ,""                                      ,"Length dependence exponent coefficient of PDIBLC" )
`MPRnb( LPDIBLC           ,0.0                                      ,"m"                                     ,"Length dependence of PDIBLC" )
`MPRnb( WPDIBLC           ,0.0                                      ,"m"                                     ,"Width dependence of PDIBLC" )
`MPRnb( PPDIBLC           ,0.0                                      ,"m^2"                                   ,"Area dependence of PDIBLC" )
`MPRnb( PDIBLCR           ,PDIBLC                                   ,""                                      ,"Reverse-mode parameter for DIBL effect on Rout" )
`MPRnb( LPDIBLCR          ,LPDIBLC                                  ,"m"                                     ,"Length dependence of PDIBLCR" )
`MPRnb( WPDIBLCR          ,WPDIBLC                                  ,"m"                                     ,"Width dependence of PDIBLCR" )
`MPRnb( PPDIBLCR          ,PPDIBLC                                  ,"m^2"                                   ,"Area dependence of PDIBLCR" )
`MPRnb( PDIBLCB           ,0.0                                      ,"1/V"                                   ,"Parameter for DIBL effect on Rout" )
`MPRnb( LPDIBLCB          ,0.0                                      ,"m/V"                                   ,"Length dependence of PDIBLCB" )
`MPRnb( WPDIBLCB          ,0.0                                      ,"m/V"                                   ,"Width dependence of PDIBLCB" )
`MPRnb( PPDIBLCB          ,0.0                                      ,"m^2/V"                                 ,"Area dependence of PDIBLCB" )
`MPRnb( PVAG              ,1.0                                      ,""                                      ,"Vg dependence of early voltage" )
`MPRnb( LPVAG             ,0.0                                      ,"m"                                     ,"Length dependence of PVAG" )
`MPRnb( WPVAG             ,0.0                                      ,"m"                                     ,"Width dependence of PVAG" )
`MPRnb( PPVAG             ,0.0                                      ,"m^2"                                   ,"Area dependence of PVAG" )
`MPRnb( FPROUT            ,0.0                                      ,"V/m^0.5"                               ,"Gds degradation factor due to pocket implants" )
`MPRnb( FPROUTL           ,0.0                                      ,"m^FPROUTLEXP"                          ,"Length dependence coefficient of FPROUT" )
`MPRoz( FPROUTLEXP        ,1.0                                      ,""                                      ,"Length dependence exponent coefficient of FPROUT" )
`MPRnb( LFPROUT           ,0.0                                      ,"V*m^0.5"                               ,"Length dependence of FPROUT" )
`MPRnb( WFPROUT           ,0.0                                      ,"V*m^0.5"                               ,"Width dependence of FPROUT" )
`MPRnb( PFPROUT           ,0.0                                      ,"V*m^1.5"                               ,"Area dependence of FPROUT" )

// BJT Parameters
`IPIcc( BJTOFF            ,0.0                                      ,""            ,0           ,1           ,"BJT on/off flag" )
`MPRnb( VABJT             ,10.0                                     ,"V"                                     ,"Early voltage for bipolar current" )
`MPRnb( LVABJT            ,0.0                                      ,"V*m"                                   ,"Length dependence of vabjt" )
`MPRnb( WVABJT            ,0.0                                      ,"V*m"                                   ,"Width dependence of vabjt" )
`MPRnb( PVABJT            ,0.0                                      ,"V*m^2"                                 ,"Cross-term dependence of vabjt" )

`MPRnb( AELY              ,0.0                                      ,"V/m"                                   ,"Channel length dependency of early voltage for bipolar current" )
`MPRnb( LAELY             ,0.0                                      ,"V"                                     ,"Length dependence of aely" )
`MPRnb( WAELY             ,0.0                                      ,"V"                                     ,"Width dependence of aely" )
`MPRnb( PAELY             ,0.0                                      ,"V*m"                                   ,"Cross-term dependence of aely" )

`MPRnb( AHLI              ,0.0                                      ,""                                      ,"High level injection parameter for bipolar current" )
`MPRnb( AHLID             ,AHLI                                     ,""                                      ,"High level injection parameter for bipolar current" )
`MPRnb( LAHLI             ,0.0                                      ,"m"                                     ,"Length dependence of ahli" )
`MPRnb( LAHLID            ,LAHLI                                    ,"m"                                     ,"Length dependence of ahlid" )
`MPRnb( WAHLI             ,0.0                                      ,"m"                                     ,"Width dependence of ahli" )
`MPRnb( WAHLID            ,WAHLI                                    ,"m"                                     ,"Width dependence of ahlid" )
`MPRnb( PAHLI             ,0.0                                      ,"m^2"                                   ,"X-term dependence of ahli" )
`MPRnb( PAHLID            ,PAHLI                                    ,"m^2"                                   ,"X-term dependence of ahlid" )

`MPRnb( XBJT              ,1.0                                      ,""                                      ,"Temperature coefficient for Isbjt" )
`MPRnb( LXBJT             ,0.0                                      ,"m"                                     ,"Length dependence of xbjt" )
`MPRnb( WXBJT             ,0.0                                      ,"m"                                     ,"Width dependence of xbjt" )
`MPRnb( PXBJT             ,0.0                                      ,"m^2"                                   ,"Cross-term dependence of xbjt" )

`MPRnb( NDIODE            ,1.0                                      ,""                                      ,"Diode non-ideality factor" )
`MPRnb( LNDIODE           ,0.0                                      ,"m"                                     ,"Length dependence of ndiode" )
`MPRnb( WNDIODE           ,0.0                                      ,"m"                                     ,"Width dependence of ndiode" )
`MPRnb( PNDIODE           ,0.0                                      ,"m^2"                                   ,"Cross-term dependence of ndiode" )

`MPRnb( ISBJT             ,0.0                                      ,"A/m^2"                                 ,"BJT injection saturation current" )
`MPRnb( PISBJT            ,0.0                                      ,"A"                                     ,"Cross-term dependence of isbjt" )
`MPRnb( WISBJT            ,0.0                                      ,"A/m"                                   ,"Width dependence of isbjt" )
`MPRnb( LISBJT            ,0.0                                      ,"A/m"                                   ,"Length dependence of isbjt" )

`MPRnb( IDBJT             ,ISBJT                                    ,"A/m^2"                                 ,"BJT injection saturation current" )
`MPRnb( LIDBJT            ,LISBJT                                   ,"A/m"                                   ,"Length dependence of idbjt" )
`MPRnb( WIDBJT            ,WISBJT                                   ,"A/m"                                   ,"Width dependence of idbjt" )
`MPRnb( PIDBJT            ,PISBJT                                   ,"A"                                     ,"Cross-term dependence of idbjt" )

`MPRnb( NBJT              ,1.0                                      ,""                                      ,"Power coefficient of channel length dependency for bipolar current" )
`MPRnb( LNBJT             ,0.0                                      ,"m"                                     ,"Length dependence of nbjt" )
`MPRnb( LLBJT0            ,0.0                                      ,"m^2"                                   ,"Length dependence of lbjt0" )

`MPRnb( WNBJT             ,0.0                                      ,"m"                                     ,"Width dependence of nbjt" )
`MPRnb( WLBJT0            ,0.0                                      ,"m^2"                                   ,"Width dependence of lbjt0" )

`MPRnb( PNBJT             ,0.0                                      ,"m^2"                                   ,"Cross-term dependence of nbjt" )
`MPRnb( PLBJT0            ,0.0                                      ,"m^3"                                   ,"Cross-term dependence of lbjt0" )
`MPRnb( LBJT0             ,0.20e-6                                  ,"m"                                     ,"Reference channel length for bipolar current" )

`MPRoo( LN                ,2e-6                                     ,"m"           ,0           ,inf         ,"Electron/hole diffusion length" )

// Impact ionization current
`MPRnb( VDSATII0          ,0.9                                      ,""                                      ,"Nominal drain saturation voltage at threshold for impact ionization current" )
`MPRnb( LVDSATII0         ,0.0                                      ,"m"                                     ,"Length dependence of vdsatii0" )
`MPRnb( WVDSATII0         ,0.0                                      ,"m"                                     ,"Width dependence of vdsatii0" )
`MPRnb( PVDSATII0         ,0.0                                      ,"m^2"                                   ,"Cross-term dependence of vdsatii0" )
`MPRnb( TII               ,0.0                                      ,""                                      ,"Temperature dependent parameter for impact ionization" )
`MPRnb( ALPHA0            ,0.0                                      ,"m/V"                                   ,"substrate current model parameter" )
`MPRnb( ALPHA0L           ,0.0                                      ,"m^ALPHA0LEXP"                          ,"Length dependence coefficient of ALPHA0" )
`MPRoz( ALPHA0LEXP        ,1.0                                      ,""                                      ,"Length dependence exponent coefficient of ALPHA0" )
`MPRnb( LALPHA0           ,0.0                                      ,"m^2/V"                                 ,"Length dependence of ALPHA0" )
`MPRnb( WALPHA0           ,0.0                                      ,"m^2/V"                                 ,"Width dependence of ALPHA0" )
`MPRnb( PALPHA0           ,0.0                                      ,"m^3/V"                                 ,"Area dependence of ALPHA0" )

`MPRnb( BETA0             ,0.0                                      ,"1/V"                                   ,"First Vds dependent parameter of impact ionization current" )
`MPRnb( LBETA0            ,0.0                                      ,"m/V"                                   ,"Length dependence of BETA0" )
`MPRnb( WBETA0            ,0.0                                      ,"m/V"                                   ,"Width dependence of BETA0" )
`MPRnb( PBETA0            ,0.0                                      ,"m^2/V"                                 ,"Area dependence of BETA0" )

`MPRnb( BETA1             ,0.0                                      ,""                                      ,"Second Vds dependent parameter of impact ionization current" )
`MPRnb( LBETA1            ,0.0                                      ,"m"                                     ,"Length dependence of BETA0" )
`MPRnb( WBETA1            ,0.0                                      ,"m"                                     ,"Width dependence of BETA0" )
`MPRnb( PBETA1            ,0.0                                      ,"m^2"                                   ,"Area dependence of BETA0" )

`MPRnb( BETA2             ,0.1                                      ,"V"                                     ,"Third Vds dependent parameter of impact ionization current" )
`MPRnb( LBETA2            ,0.0                                      ,"V*m"                                   ,"Length dependence of BETA0" )
`MPRnb( WBETA2            ,0.0                                      ,"V*m"                                   ,"Width dependence of BETA0" )
`MPRnb( PBETA2            ,0.0                                      ,"V*m^2"                                 ,"Area dependence of BETA0" )

`MPRnb( LII               ,0.0                                      ,""                                      ,"Channel length dependent parameter at threshold for impact ionization current" )
`MPRnb( LLII              ,0.0                                      ,"m"                                     ,"Length dependence of LII" )
`MPRnb( WLII              ,0.0                                      ,"m"                                     ,"Width dependence of LII" )
`MPRnb( PLII              ,0.0                                      ,"m^2"                                   ,"Area dependence of LII" )

`MPRnb( SII0              ,0.5                                      ,""                                      ,"First Vgs dependent parameter for impact ionization current" )
`MPRnb( LSII0             ,0.0                                      ,"m"                                     ,"Length dependence of SII0" )
`MPRnb( WSII0             ,0.0                                      ,"m"                                     ,"Width dependence of SII0" )
`MPRnb( PSII0             ,0.0                                      ,"m^2"                                   ,"Area dependence of SII0" )

`MPRnb( SII1              ,0.1                                      ,""                                      ,"Second Vgs dependent parameter for impact ionization current" )
`MPRnb( LSII1             ,0.0                                      ,"m"                                     ,"Length dependence of SII1" )
`MPRnb( WSII1             ,0.0                                      ,"m"                                     ,"Width dependence of SII1" )
`MPRnb( PSII1             ,0.0                                      ,"m^2"                                   ,"Area dependence of SII1" )

`MPRnb( SII2              ,0.0                                      ,""                                      ,"Third Vgs dependent parameter for impact ionization current" )
`MPRnb( LSII2             ,0.0                                      ,"m"                                     ,"Length dependence of SII2" )
`MPRnb( WSII2             ,0.0                                      ,"m"                                     ,"Width dependence of SII2" )
`MPRnb( PSII2             ,0.0                                      ,"m^2"                                   ,"Area dependence of SII2" )

`MPRnb( SIID              ,0.0                                      ,""                                      ,"Vds dependent parameter of drain saturation voltage for impact ionization current" )
`MPRnb( LSIID             ,0.0                                      ,"m"                                     ,"Length dependence of SIID" )
`MPRnb( WSIID             ,0.0                                      ,"m"                                     ,"Width dependence of SIID" )
`MPRnb( PSIID             ,0.0                                      ,"m^2"                                   ,"Area dependence of SIID" )

`MPRnb( ESATII            ,1e7                                      ,"V/m"                                   ,"Saturation electric field for impact ionization" )
`MPRnb( LESATII           ,0.0                                      ,"V"                                     ,"Length dependence of ESATII" )
`MPRnb( WESATII           ,0.0                                      ,"V"                                     ,"Width dependence of ESATII" )
`MPRnb( PESATII           ,0.0                                      ,"m*V"                                   ,"Area dependence of SESATII" )

`MPRoz(IIMOD2CLAMP1       ,0.1                                      ,"V"                                     ,"Clamp1 of SII1 * Vg term in IIMOD = 2")
`MPRoz(IIMOD2CLAMP2       ,0.1                                      ,"V"                                     ,"Clamp2 of SII0 * Vg term in IIMOD = 2")
`MPRoz(IIMOD2CLAMP3       ,0.1                                      ,"V"                                     ,"Clamp3 of ratio term in IIMOD = 2")

`MPRnb( FBJTII            ,0.0                                      ,""                                      ,"Fraction of bipolar current affecting the impact ionization" )
`MPRnb( LFBJTII           ,0.0                                      ,"m"                                     ,"Length dependence of fbjtii" )
`MPRnb( WFBJTII           ,0.0                                      ,"m"                                     ,"Width dependence of fbjtii" )
`MPRnb( PFBJTII           ,0.0                                      ,"m^2"                                   ,"Cross-term dependence of fbjtii" )

`MPRnb( EBJTII            ,0.0                                      ,""                                      ,"Impact ionization parameter for BJT part" )
`MPRnb( CBJTII            ,0.0                                      ,"m"                                     ,"Length scaling parameter for II BJT part" )
`MPRnb( ABJTII            ,0.0                                      ,"1/V"                                   ,"Exponent factor for avalanche current" )

`MPRnb( LABJTII           ,0.0                                      ,"m/V"                                   ,"Length dependence of abjtii" )
`MPRnb( LCBJTII           ,0.0                                      ,"m^2"                                   ,"Length dependence of cbjtii" )
`MPRnb( LEBJTII           ,0.0                                      ,"m"                                     ,"Length dependence of ebjtii" )

`MPRnb( WABJTII           ,0.0                                      ,"m/V"                                   ,"Width dependence of abjtii" )
`MPRnb( WCBJTII           ,0.0                                      ,"m^2"                                   ,"Width dependence of cbjtii" )
`MPRnb( WEBJTII           ,0.0                                      ,"m"                                     ,"Width dependence of ebjtii" )

`MPRnb( PABJTII           ,0.0                                      ,"m^2/V"                                 ,"Cross-term dependence of abjtii" )
`MPRnb( PCBJTII           ,0.0                                      ,"m^3"                                   ,"Cross-term dependence of cbjtii" )
`MPRnb( PEBJTII           ,0.0                                      ,"m^2"                                   ,"Cross-term dependence of ebjtii" )

`MPRnb( VBCI              ,0.0                                      ,"V"                                     ,"Internal B-C built-in potential" )
`MPRnb( LVBCI             ,0.0                                      ,"V*m"                                   ,"Length dependence of vbci" )
`MPRnb( WVBCI             ,0.0                                      ,"V*m"                                   ,"Width dependence of vbci" )
`MPRnb( PVBCI             ,0.0                                      ,"V*m^2"                                 ,"Cross-term dependence of vbci" )
`MPRnb( TVBCI             ,0.0                                      ,""                                      ,"Temperature coefficient for VBCI" )

`MPRnb( MBJTII            ,0.4                                      ,""                                      ,"Internal B-C grading coefficient" )
`MPRnb( LMBJTII           ,0.0                                      ,"m"                                     ,"Length dependence of mbjtii" )
`MPRnb( WMBJTII           ,0.0                                      ,"m"                                     ,"Width dependence of mbjtii" )
`MPRnb( PMBJTII           ,0.0                                      ,"m^2"                                   ,"Cross-term dependence of mbjtii" )

// Gate dielectric tunneling current model parameters
//BSIM-SOI
`MPRoo( VECB              ,0.026                                    ,""            ,0.0         ,inf         ,"Vaux parameter for conduction-band electron tunneling" )
`MPRoo( VEVB              ,0.075                                    ,""            ,0.0         ,inf         ,"Vaux parameter for valence-band electron tunneling" )

`MPRnb( ALPHAGB1          ,0.35                                     ,"1/V"                                   ,"First Vox dependent parameter for gate current in inversion" )
`MPRnb( LALPHAGB1         ,0.0                                      ,"m/V"                                   ,"Length dependence of alphagb1" )
`MPRnb( WALPHAGB1         ,0.0                                      ,"m/V"                                   ,"Width dependence of alphagb1" )
`MPRnb( PALPHAGB1         ,0.0                                      ,"m^2/V"                                 ,"Cross-term dependence of alphagb1" )
`MPRnb( ALPHAGB1_T        ,0.0                                      ,""                                      ,"Temperature coefficient of ALPHAGB1" )
`MPRnb( LALPHAGB1_T       ,0.0                                      ,"m"                                     ,"Length dependence of ALPHAGB1_T" )
`MPRnb( WALPHAGB1_T       ,0.0                                      ,"m"                                     ,"Width dependence of ALPHAGB1_T" )
`MPRnb( PALPHAGB1_T       ,0.0                                      ,"m^2"                                   ,"Cross-term dependence of ALPHAGB1_T" )

`MPRnb( BETAGB1           ,0.03                                     ,"1/V^2"                                 ,"Second Vox dependent parameter for gate current in inversion" )
`MPRnb( LBETAGB1          ,0.0                                      ,"m/V^2"                                 ,"Length dependence of betagb1" )
`MPRnb( WBETAGB1          ,0.0                                      ,"m/V^2"                                 ,"Width dependence of betagb1" )
`MPRnb( PBETAGB1          ,0.0                                      ,"m^2/V^2"                               ,"Cross-term dependence of betagb1" )

`MPRnb( ALPHAGB2          ,0.43                                     ,"1/V"                                   ,"First Vox dependent parameter for gate current in accumulation" )
`MPRnb( LALPHAGB2         ,0.0                                      ,"m/V"                                   ,"Length dependence of aigbcp2" )
`MPRnb( WALPHAGB2         ,0.0                                      ,"m/V"                                   ,"Width dependence of alphagb2" )
`MPRnb( PALPHAGB2         ,0.0                                      ,"m^2/V"                                 ,"Cross-term dependence of alphagb2" )
`MPRnb( ALPHAGB2_T        ,0.0                                      ,""                                      ,"Temperature coefficient of ALPHAGB2" )
`MPRnb( LALPHAGB2_T       ,0.0                                      ,"m"                                     ,"Length dependence of ALPHAGB2_T" )
`MPRnb( WALPHAGB2_T       ,0.0                                      ,"m"                                     ,"Width dependence of ALPHAGB2_T" )
`MPRnb( PALPHAGB2_T       ,0.0                                      ,"m^2"                                   ,"Cross-term dependence of alphagb2_t" )

`MPRnb( BETAGB2           ,0.05                                     ,"1/V^2"                                 ,"Second Vox dependent parameter for gate current in accumulation" )
`MPRnb( LBETAGB2          ,0.0                                      ,"m/V^2"                                 ,"Length dependence of betagb2" )
`MPRnb( WBETAGB2          ,0.0                                      ,"m/V^2"                                 ,"Width dependence of betagb2" )
`MPRnb( PBETAGB2          ,0.0                                      ,"m^2/V^2"                               ,"Cross-term dependence of betagb2" )

`MPRnb( VGB2              ,17                                       ,"V"                                     ,"Third Vox dependent parameter for gate current in accumulation" )
`MPRnb( VGB1              ,300                                      ,"V"                                     ,"Third Vox dependent parameter for gate current in inversion" )

`MPRnb( AGB1              ,3.7622e-7                                ,""                                      ,"'A' for Igb1 Tunneling current model" )
`MPRnb( BGB1              ,-3.1051e10                               ,""                                      ,"'B' for Igb1 Tunneling current model" )
`MPRnb( AGB2              ,4.9758e-7                                ,""                                      ,"'A' for Igb2 Tunneling current model" )
`MPRnb( BGB2              ,-2.357e10                                ,""                                      ,"'B' for Igb2 Tunneling current model" )
`MPRnb( AGBC2N            ,3.4254e-7                                ,""                                      ,"NMOS 'A' for tunneling current model" )
`MPRnb( AGBC2P            ,4.9723e-7                                ,""                                      ,"PMOS 'A' for tunneling current model" )
`MPRnb( BGBC2N            ,1.1665e12                                ,""                                      ,"NMOS 'B' for tunneling current model" )
`MPRnb( BGBC2P            ,7.4567e11                                ,""                                      ,"PMOS 'B' for tunneling current model" )
`MPRnb( EIGBINV           ,1.1                                      ,"V"                                     ,"Parameter for the Si bandgap for Igbinv" )
`MPRnb( AIGC              ,((TYPE == `ntype) ? 1.36e-2 : 9.8e-3)    ,"(F*s^2/g)^0.5/m"                       ,"Parameter for Igc" )
`MPRnb( BIGC              ,((TYPE == `ntype) ? 1.71e-3 : 7.59e-4)   ,"(F*s^2/g)^0.5/m/V"                     ,"Parameter for Igc" )
`MPRnb( CIGC              ,((TYPE == `ntype) ? 0.075 : 0.03)        ,"1/V"                                   ,"Parameter for Igc" )
`MPRnb( AIGS              ,((TYPE == `ntype) ? 1.36e-2 : 9.8e-3)    ,"(F*s^2/g)^0.5/m"                       ,"Parameter for Igs" )
`MPRnb( AIGS1             ,0.0                                      ,""                                      ,"Temperature coefficient of AIGD" )
`MPRnb( BIGS              ,((TYPE == `ntype) ? 1.71e-3 : 7.59e-4)   ,"(F*s^2/g)^0.5/m/V"                     ,"Parameter for Igs" )
`MPRnb( CIGS              ,((TYPE == `ntype) ? 0.075 : 0.03)        ,"1/V"                                   ,"Parameter for Igs" )
`MPRnb( AIGD              ,((TYPE == `ntype) ? 1.36e-2 : 9.8e-3)    ,"(F*s^2/g)^0.5/m"                       ,"Parameter for Igd" )
`MPRnb( AIGD1             ,0.0                                      ,""                                      ,"Temperature coefficient of AIGD" )
`MPRnb( BIGD              ,((TYPE == `ntype) ? 1.71e-3 : 7.59e-4)   ,"(F*s^2/g)^0.5/m/V"                     ,"Parameter for Igd" )
`MPRnb( CIGD              ,((TYPE == `ntype) ? 0.075 : 0.03)        ,"1/V"                                   ,"Parameter for Igd" )
`MPRnb( DLCIG             ,LINT                                     ,"m"                                     ,"Delta L for Ig model" )
`MPRnb( DLCIGD            ,DLCIG                                    ,"m"                                     ,"Delta L for Ig model" )
`MPRnb( POXEDGE           ,1.0                                      ,""                                      ,"Factor for the gate edge Tox" )
`MPRnb( NTOX              ,1.0                                      ,""                                      ,"Exponent for Tox ratio" )
`MPRoz( TOXREF            ,3.0e-9                                   ,"m"                                     ,"Target tox value" )
`MPRcc( PIGCD             ,1.0                                      ,""            ,-50.0       ,50.0        ,"Igc, S/D partition parameter" )
`MPRnb( AIGCL             ,0.0                                      ,"m"                                     ,"Length dependence coefficient of AIGC" )
`MPRnb( AIGCW             ,0.0                                      ,"m"                                     ,"Width dependence coefficient of AIGC" )
`MPRnb( AIGC1             ,0.0                                      ,""                                      ,"Temperature coefficient of AIGC" )
`MPRnb( AIGSL             ,0.0                                      ,"m"                                     ,"Length dependence coefficient of AIGS" )
`MPRnb( AIGSW             ,0.0                                      ,"m"                                     ,"Width dependence coefficient of AIGS" )
`MPRnb( AIGDL             ,0.0                                      ,"m"                                     ,"Length dependence coefficient of AIGD" )
`MPRnb( AIGDW             ,0.0                                      ,"m"                                     ,"Width dependence coefficient of AIGD" )
`MPRnb( PIGCDL            ,0.0                                      ,"m"                                     ,"Length dependence coefficient of PIGCD" )
`MPRnb( LEIGBINV          ,0.0                                      ,"m*V"                                   ,"Length dependence of EIGBINV" )
`MPRnb( WEIGBINV          ,0.0                                      ,"m*V"                                   ,"Width dependence of EIGBINV" )
`MPRnb( PEIGBINV          ,0.0                                      ,"m^2*V"                                 ,"Area dependence of EIGBINV" )
`MPRnb( LAIGC             ,0.0                                      ,"(F*s^2/g)^0.5"                         ,"Length dependence of AIGC" )
`MPRnb( LAIGC1            ,0.0                                      ,"m"                                     ,"Length dependence of AIGC1" )
`MPRnb( WAIGC             ,0.0                                      ,"(F*s^2/g)^0.5"                         ,"Width dependence of AIGC" )
`MPRnb( WAIGC1            ,0.0                                      ,"m"                                     ,"Width dependence of AIGC1" )
`MPRnb( PAIGC             ,0.0                                      ,"m*(F*s^2/g)^0.5"                       ,"Area dependence of AIGC" )
`MPRnb( PAIGC1            ,0.0                                      ,"m^2"                                   ,"Cross-term dependence of AIGC1" )
`MPRnb( LBIGC             ,0.0                                      ,"(F*s^2/g)^0.5/V"                       ,"Length dependence of BIGC" )
`MPRnb( WBIGC             ,0.0                                      ,"(F*s^2/g)^0.5/V"                       ,"Width dependence of BIGC" )
`MPRnb( PBIGC             ,0.0                                      ,"m*(F*s^2/g)^0.5/V"                     ,"Area dependence of BIGC" )
`MPRnb( LCIGC             ,0.0                                      ,"m/V"                                   ,"Length dependence of CIGC" )
`MPRnb( WCIGC             ,0.0                                      ,"m/V"                                   ,"Width dependence of CIGC" )
`MPRnb( PCIGC             ,0.0                                      ,"m^2/V"                                 ,"Area dependence of CIGC" )
`MPRnb( LAIGS             ,0.0                                      ,"(F*s^2/g)^0.5"                         ,"Length dependence of AIGS" )
`MPRnb( LAIGS1            ,0.0                                      ,"m"                                     ,"Length dependence of AIGS1" )
`MPRnb( WAIGS             ,0.0                                      ,"(F*s^2/g)^0.5"                         ,"Width dependence of AIGS" )
`MPRnb( WAIGS1            ,0.0                                      ,"m"                                     ,"Width dependence of AIGS1" )
`MPRnb( PAIGS             ,0.0                                      ,"m*(F*s^2/g)^0.5"                       ,"Area dependence of AIGS" )
`MPRnb( PAIGS1            ,0.0                                      ,"m^2"                                   ,"Cross-term dependence of AIGS1" )
`MPRnb( LBIGS             ,0.0                                      ,"(F*s^2/g)^0.5/V"                       ,"Length dependence of BIGS" )
`MPRnb( WBIGS             ,0.0                                      ,"(F*s^2/g)^0.5/V"                       ,"Width dependence of BIGS" )
`MPRnb( PBIGS             ,0.0                                      ,"m*(F*s^2/g)^0.5/V"                     ,"Area dependence of BIGS" )
`MPRnb( LCIGS             ,0.0                                      ,"m/V"                                   ,"Length dependence of CIGS" )
`MPRnb( WCIGS             ,0.0                                      ,"m/V"                                   ,"Width dependence of CIGS" )
`MPRnb( PCIGS             ,0.0                                      ,"m^2/V"                                 ,"Area dependence of CIGS" )
`MPRnb( LAIGD             ,0.0                                      ,"(F*s^2/g)^0.5"                         ,"Length dependence of AIGD" )
`MPRnb( LAIGD1            ,0.0                                      ,"m"                                     ,"Length dependence of AIGD1" )
`MPRnb( WAIGD             ,0.0                                      ,"(F*s^2/g)^0.5"                         ,"Width dependence of AIGD" )
`MPRnb( WAIGD1            ,0.0                                      ,"m"                                     ,"Width dependence of AIGD1" )
`MPRnb( PAIGD             ,0.0                                      ,"m*(F*s^2/g)^0.5"                       ,"Area dependence of AIGD" )
`MPRnb( PAIGD1            ,0.0                                      ,"m^2"                                   ,"Cross-term dependence of AIGD1" )
`MPRnb( LBIGD             ,0.0                                      ,"(F*s^2/g)^0.5/V"                       ,"Length dependence of BIGD" )
`MPRnb( WBIGD             ,0.0                                      ,"(F*s^2/g)^0.5/V"                       ,"Width dependence of BIGD" )
`MPRnb( PBIGD             ,0.0                                      ,"m*(F*s^2/g)^0.5/V"                     ,"Area dependence of BIGD" )
`MPRnb( LCIGD             ,0.0                                      ,"m/V"                                   ,"Length dependence of CIGD" )
`MPRnb( WCIGD             ,0.0                                      ,"m/V"                                   ,"Width dependence of CIGD" )
`MPRnb( PCIGD             ,0.0                                      ,"m^2/V"                                 ,"Area dependence of CIGD" )
`MPRnb( LPOXEDGE          ,0.0                                      ,"m"                                     ,"Length dependence of POXEDGE" )
`MPRnb( WPOXEDGE          ,0.0                                      ,"m"                                     ,"Width dependence of POXEDGE" )
`MPRnb( PPOXEDGE          ,0.0                                      ,"m^2"                                   ,"Area dependence of POXEDGE" )
`MPRnb( LDLCIG            ,0.0                                      ,"m^2"                                   ,"Length dependence of DLCIG" )
`MPRnb( WDLCIG            ,0.0                                      ,"m^2"                                   ,"Width dependence of DLCIG" )
`MPRnb( PDLCIG            ,0.0                                      ,"m^3"                                   ,"Area dependence of DLCIG" )
`MPRnb( LDLCIGD           ,0.0                                      ,"m^2"                                   ,"Length dependence of DLCIGD" )
`MPRnb( WDLCIGD           ,0.0                                      ,"m^2"                                   ,"Width dependence of DLCIGD" )
`MPRnb( PDLCIGD           ,0.0                                      ,"m^3"                                   ,"Area dependence of DLCIGD" )
`MPRnb( LNTOX             ,0.0                                      ,"m"                                     ,"Length dependence of NTOX" )
`MPRnb( WNTOX             ,0.0                                      ,"m"                                     ,"Width dependence of NTOX" )
`MPRnb( PNTOX             ,0.0                                      ,"m^2"                                   ,"Area dependence of NTOX" )

//Gate current in accumulation in AGBCP2 region
`MPRnb( AIGBCP2           ,0.043                                    ,"1/V^2"                                 ,"First Vgp dependent parameter for gate current in accumulation in AGBCP2 region" )
`MPRnb( AIGBCP2_T         ,0.0                                      ,""                                      ,"Temperature coefficient of AIGBCP2"  )
`MPRnb( BIGBCP2           ,0.0054                                   ,"1/V^2"                                 ,"Second Vgp dependent parameter for gate current in accumulation in AGBCP2 region" )
`MPRnb( CIGBCP2           ,0.0075                                   ,"1/V^2"                                 ,"Third Vgp dependent parameter for gate current in accumulation in AGBCP2 region" )

`MPRnb( LAIGBCP2          ,0.0                                      ,"m/V^2"                                 ,"Length dependence of aigbcp2" )
`MPRnb( LAIGBCP2_T        ,0.0                                      ,"m"                                     ,"Length dependence of AIGBCP2_T" )
`MPRnb( LBIGBCP2          ,0.0                                      ,"m/V^2"                                 ,"Length dependence of bigbcp2" )
`MPRnb( LCIGBCP2          ,0.0                                      ,"m/V^2"                                 ,"Length dependence of cigbcp2" )

`MPRnb( WAIGBCP2          ,0.0                                      ,"m/V^2"                                 ,"Width dependence of aigbcp2" )
`MPRnb( WAIGBCP2_T        ,0.0                                      ,"m"                                     ,"Width dependence of AIGBCP2_T" )
`MPRnb( WBIGBCP2          ,0.0                                      ,"m/V^2"                                 ,"Width dependence of bigbcp2" )
`MPRnb( WCIGBCP2          ,0.0                                      ,"m/V^2"                                 ,"Width dependence of cigbcp2" )

`MPRnb( PAIGBCP2          ,0.0                                      ,"m^2/V^2"                               ,"Cross-term dependence of aigbcp2" )
`MPRnb( PAIGBCP2_T        ,0.0                                      ,"m^2"                                   ,"Cross-term dependence of AIGBCP2_T" )
`MPRnb( PBIGBCP2          ,0.0                                      ,"m^2/V^2"                               ,"Cross-term dependence of bigbcp2" )
`MPRnb( PCIGBCP2          ,0.0                                      ,"m^2/V^2"                               ,"Cross-term dependence of cigbcp2" )

// GIDL and GISL currents
`MPRnb( AGIDL             ,0.0                                      ,"V/m"                                   ,"Pre-exponential coefficient for GIDL" )
`MPRnb( AGIDLL            ,0.0                                      ,"m"                                     ,"Length dependence coefficient of AGIDL" )
`MPRnb( AGIDLW            ,0.0                                      ,"m"                                     ,"Width dependence coefficient of AGIDL" )
`MPRnb( LAGIDL            ,0.0                                      ,"V"                                     ,"Length dependence of AGIDL" )
`MPRnb( WAGIDL            ,0.0                                      ,"V"                                     ,"Width dependence of AGIDL" )
`MPRnb( PAGIDL            ,0.0                                      ,"V*m"                                   ,"Area dependence of AGIDL" )
`MPRnb( BGIDL             ,2.3e9                                    ,"V/m"                                   ,"Exponential coefficient for GIDL" )
`MPRnb( BGIDL1            ,0.0                                      ,"V/m"                                   ,"Temperature coefficient of BGIDL" )
`MPRnb( LBGIDL            ,0.0                                      ,"V"                                     ,"Length dependence of BGIDL" )
`MPRnb( WBGIDL            ,0.0                                      ,"V"                                     ,"Width dependence of BGIDL" )
`MPRnb( PBGIDL            ,0.0                                      ,"V*m"                                   ,"Area dependence of BGIDL" )
`MPRnb( LBGIDL1           ,0.0                                      ,"V"                                     ,"Length dependence of bgidl1" )
`MPRnb( WBGIDL1           ,0.0                                      ,"V"                                     ,"Width dependence of bgidl1" )
`MPRnb( PBGIDL1           ,0.0                                      ,"V*m"                                   ,"Cross-term dependence of bgidl1" )
`MPRnb( CGIDL             ,0.5                                      ,"V/m"                                   ,"Exponential coefficient for GIDL" )
`MPRnb( LCGIDL            ,0.0                                      ,"V"                                     ,"Length dependence of CGIDL" )
`MPRnb( WCGIDL            ,0.0                                      ,"V"                                     ,"Width dependence of CGIDL" )
`MPRnb( PCGIDL            ,0.0                                      ,"V*m"                                   ,"Area dependence of CGIDL" )
`MPRnb( EGIDL             ,0.8                                      ,"V"                                     ,"Band bending parameter for GIDL" )
`MPRnb( LEGIDL            ,0.0                                      ,"V*m"                                   ,"Length dependence of EGIDL" )
`MPRnb( WEGIDL            ,0.0                                      ,"V*m"                                   ,"Width dependence of EGIDL" )
`MPRnb( PEGIDL            ,0.0                                      ,"V*m^2"                                 ,"Area dependence of EGIDL" )
`MPRnb( AGISL             ,AGIDL                                    ,"V/m"                                   ,"Pre-exponential coefficient for GISL" )
`MPRnb( AGISLL            ,AGIDLL                                   ,"m"                                     ,"Length dependence coefficient of AGISL" )
`MPRnb( AGISLW            ,AGIDLW                                   ,"m"                                     ,"Width dependence coefficient of AGISL" )
`MPRnb( LAGISL            ,LAGIDL                                   ,"V"                                     ,"Length dependence of AGISL" )
`MPRnb( WAGISL            ,WAGIDL                                   ,"V"                                     ,"Width dependence of AGISL" )
`MPRnb( PAGISL            ,PAGIDL                                   ,"V*m"                                   ,"Area dependence of AGISL" )
`MPRnb( BGISL             ,BGIDL                                    ,"V/m"                                   ,"Exponential coefficient for GISL" )
`MPRnb( BGISL1            ,BGIDL1                                   ,"V/m"                                   ,"Temperature coefficient of BGISL" )
`MPRnb( LBGISL            ,LBGIDL                                   ,"V"                                     ,"Length dependence of BGISL" )
`MPRnb( WBGISL            ,WBGIDL                                   ,"V"                                     ,"Width dependence of BGISL" )
`MPRnb( PBGISL            ,PBGIDL                                   ,"V*m"                                   ,"Area dependence of BGISL" )
`MPRnb( LBGISL1           ,LBGIDL1                                  ,"V"                                     ,"Length dependence of bgisl1" )
`MPRnb( WBGISL1           ,WBGIDL1                                  ,"V"                                     ,"Width dependence of bgisl" )
`MPRnb( PBGISL1           ,PBGIDL1                                  ,"V*m"                                   ,"Cross-term dependence of bgisl1" )
`MPRnb( CGISL             ,CGIDL                                    ,"V/m"                                   ,"Exponential coefficient for GISL" )
`MPRnb( LCGISL            ,LCGIDL                                   ,"V"                                     ,"Length dependence of CGISL" )
`MPRnb( WCGISL            ,WCGIDL                                   ,"V"                                     ,"Width dependence of CGISL" )
`MPRnb( PCGISL            ,PCGIDL                                   ,"V*m"                                   ,"Area dependence of CGISL" )
`MPRnb( EGISL             ,EGIDL                                    ,"V"                                     ,"Band bending parameter for GISL" )
`MPRnb( LEGISL            ,LEGIDL                                   ,"V*m"                                   ,"Length dependence of EGISL" )
`MPRnb( WEGISL            ,WEGIDL                                   ,"V*m"                                   ,"Width dependence of EGISL" )
`MPRnb( PEGISL            ,PEGIDL                                   ,"V*m^2"                                 ,"Area dependence of EGISL" )

//MOD=1
`MPRnb( RGIDL             ,1.0                                      ,""                                      ,"GIDL vg parameter" )
`MPRnb( LRGIDL            ,0.0                                      ,"m"                                     ,"Length dependence of rgidl" )
`MPRnb( WRGIDL            ,0.0                                      ,"m"                                     ,"Width dependence of rgidl" )
`MPRnb( PRGIDL            ,0.0                                      ,"m^2"                                   ,"Cross-term dependence of rgidl" )

`MPRnb( KGIDL             ,0.0                                      ,"V"                                     ,"GIDL vb parameter" )
`MPRnb( LKGIDL            ,0.0                                      ,"V*m"                                   ,"Length dependence of kgidl" )
`MPRnb( WKGIDL            ,0.0                                      ,"V*m"                                   ,"Width dependence of kgidl" )
`MPRnb( PKGIDL            ,0.0                                      ,"V*m^2"                                 ,"Cross-term dependence of kgidl" )

`MPRnb( FGIDL             ,0.0                                      ,""                                      ,"GIDL vb parameter" )
`MPRnb( LFGIDL            ,0.0                                      ,"m"                                     ,"Length dependence of fgidl" )
`MPRnb( WFGIDL            ,0.0                                      ,"m"                                     ,"Width dependence of fgidl" )
`MPRnb( PFGIDL            ,0.0                                      ,"m^2"                                   ,"Cross-term dependence of fgidl" )

`MPRnb( RGISL             ,RGIDL                                    ,""                                      ,"GISL vg parameter" )
`MPRnb( LRGISL            ,LRGIDL                                   ,"m"                                     ,"Length dependence of rgisl" )
`MPRnb( WRGISL            ,WRGIDL                                   ,"m"                                     ,"Width dependence of rgisl" )
`MPRnb( PRGISL            ,PRGIDL                                   ,"m^2"                                   ,"Cross-term dependence of rgisl" )

`MPRnb( KGISL             ,KGIDL                                    ,"V"                                     ,"GISL vb parameter" )
`MPRnb( LKGISL            ,LKGIDL                                   ,"V*m"                                   ,"Length dependence of kgisl" )
`MPRnb( WKGISL            ,WKGIDL                                   ,"V*m"                                   ,"Width dependence of kgisl" )
`MPRnb( PKGISL            ,PKGIDL                                   ,"V*m^2"                                 ,"Cross-term dependence of kgisl" )

`MPRnb( FGISL             ,FGIDL                                    ,""                                      ,"GISL vb parameter" )
`MPRnb( LFGISL            ,LFGIDL                                   ,"m"                                     ,"Length dependence of fgisl" )
`MPRnb( WFGISL            ,WFGIDL                                   ,"m"                                     ,"Width dependence of fgisl" )
`MPRnb( PFGISL            ,PFGIDL                                   ,"m^2"                                   ,"Cross-term dependence of fgisl" )

// Overlap capacitance and fringing capacitance
`MPRnb( CF                ,0.0                                      ,"F/m"                                   ,"Outer fringe capacitance" )
`MPRnb( LCF               ,0.0                                      ,"F"                                     ,"Length dependence of CF" )
`MPRnb( WCF               ,0.0                                      ,"F"                                     ,"Width dependence of CF" )
`MPRnb( PCF               ,0.0                                      ,"F*m"                                   ,"Area dependence of CF" )
`MPRco( CFRCOEFF          ,1.0                                      ,"F/m"         ,1.0         ,inf         ,"Coefficient for outer fringe capacitance" )
`MPRcz( CGSO              ,0.0                                      ,"F/m"                                   ,"Gate-to-source overlap capacitance" )
`MPRcz( CGDO              ,0.0                                      ,"F/m"                                   ,"Gate-to-drain overlap capacitance" )
`MPRcz( CGBO              ,0.0                                      ,"F/m"                                   ,"Gate-to-body overlap capacitance" )
`MPRnb( CGSL              ,0.0                                      ,"F/m"                                   ,"Overlap capacitance between gate and lightly-doped source region" )
`MPRnb( LCGSL             ,0.0                                      ,"F"                                     ,"Length dependence of CGSL" )
`MPRnb( WCGSL             ,0.0                                      ,"F"                                     ,"Width dependence of CGSL" )
`MPRnb( PCGSL             ,0.0                                      ,"F*m"                                   ,"Area dependence of CGSL" )
`MPRnb( CGDL              ,0.0                                      ,"F/m"                                   ,"Overlap capacitance between gate and lightly-doped drain region" )
`MPRnb( LCGDL             ,0.0                                      ,"F"                                     ,"Length dependence of CGDL" )
`MPRnb( WCGDL             ,0.0                                      ,"F"                                     ,"Width dependence of CGDL" )
`MPRnb( PCGDL             ,0.0                                      ,"F*m"                                   ,"Area dependence of CGDL" )
`MPRnb( CKAPPAS           ,0.6                                      ,"V"                                     ,"Coefficient of bias-dependent overlap capacitance for the source side" )
`MPRnb( LCKAPPAS          ,0.0                                      ,"m*V"                                   ,"Length dependence of CKAPPAS" )
`MPRnb( WCKAPPAS          ,0.0                                      ,"m*V"                                   ,"Width dependence of CKAPPAS" )
`MPRnb( PCKAPPAS          ,0.0                                      ,"m^2*V"                                 ,"Area dependence of CKAPPAS" )
`MPRnb( CKAPPAD           ,0.6                                      ,"V"                                     ,"Coefficient of bias-dependent overlap capacitance for the drain side" )
`MPRnb( LCKAPPAD          ,0.0                                      ,"m*V"                                   ,"Length dependence of CKAPPAD" )
`MPRnb( WCKAPPAD          ,0.0                                      ,"m*V"                                   ,"Width dependence of CKAPPAD" )
`MPRnb( PCKAPPAD          ,0.0                                      ,"m^2*V"                                 ,"Area dependence of CKAPPAD" )
`MPRoz( CKAPPAD1          ,1.0e6                                    ,""                                      ,"Parameter for tuning CGD" )
`MPRoz( CKAPPAD2          ,1.0                                      ,""                                      ,"Parameter for tuning CGD" )
`MPRoz( CKAPPAS1          ,1.0e6                                    ,""                                      ,"Parameter for tuning CGD" )
`MPRoz( CKAPPAS2          ,1.0                                      ,""                                      ,"Parameter for tuning CGD" )

// Layout-dependent parasitics model parameters (resistance only)
`MPRcz( DMCG              ,0.0                                      ,"m"                                     ,"Distance of mid-contact to gate edge" )
`MPRcz( DMCI              ,DMCG                                     ,"m"                                     ,"Distance of mid-contact to isolation" )
`MPRcz( DMDG              ,0.0                                      ,"m"                                     ,"Distance of mid-diffusion to gate edge" )
`MPRcz( DMCGT             ,0.0                                      ,"m"                                     ,"Distance of mid-contact to gate edge in test" )
`MPRnb( XGL               ,0.0                                      ,"m"                                     ,"Variation in Ldrawn" )
`MPRcz( RSHG              ,0.1                                      ,"ohm"                                   ,"Gate sheet resistance" )

// Junction capacitance
`MPRcz( CJS               ,5.0e-4                                   ,"F/m^2"                                 ,"Unit area source-side junction capacitance at zero bias" )
`MPRcz( CJD               ,CJS                                      ,"F/m^2"                                 ,"Unit area drain-side junction capacitance at zero bias" )
`MPRcz( CJSWS             ,5.0e-10                                  ,"F/m"                                   ,"Unit length source-side side-wall junction capacitance at zero bias" )
`MPRcz( CJSWD             ,CJSWS                                    ,"F/m"                                   ,"Unit length drain-side side-wall junction capacitance at zero bias" )
`MPRcz( CJSWGS            ,0.0                                      ,"F/m"                                   ,"Unit length source-side gate side-wall junction capacitance at zero bias" )
`MPRcz( CJSWGD            ,CJSWGS                                   ,"F/m"                                   ,"Unit length drain-side gate side-wall junction capacitance at zero bias" )
`MPRnb( PBS               ,1.0                                      ,"V"                                     ,"Source-side bulk junction built-in potential" )
`MPRnb( PBD               ,PBS                                      ,"V"                                     ,"Drain-side bulk junction built-in potential" )
`MPRnb( PBSWS             ,1.0                                      ,"V"                                     ,"Built-in potential for Source-side side-wall junction capacitance" )
`MPRnb( PBSWD             ,PBSWS                                    ,"V"                                     ,"Built-in potential for Drain-side side-wall junction capacitance" )
`MPRnb( PBSWGS            ,PBSWS                                    ,"V"                                     ,"Built-in potential for Source-side gate side-wall junction capacitance" )
`MPRnb( PBSWGD            ,PBSWGS                                   ,"V"                                     ,"Built-in potential for Drain-side gate side-wall junction capacitance" )
`MPRnb( MJS               ,0.5                                      ,""                                      ,"Source bottom junction capacitance grading coefficient" )
`MPRnb( MJD               ,MJS                                      ,""                                      ,"Drain bottom junction capacitance grading coefficient" )
`MPRnb( MJSWS             ,0.33                                     ,""                                      ,"Source side-wall junction capacitance grading coefficient" )
`MPRnb( MJSWD             ,MJSWS                                    ,""                                      ,"Drain side-wall junction capacitance grading coefficient" )
`MPRnb( MJSWGS            ,MJSWS                                    ,""                                      ,"Source-side gate side-wall junction capacitance grading coefficient" )
`MPRnb( MJSWGD            ,MJSWGS                                   ,""                                      ,"Drain-side gate side-wall junction capacitance grading coefficient" )

`MPRnb( TT                ,1e-12                                    ,"s"                                     ,"Diffusion capacitance transit time coefficient" )
`MPRnb( LDIF0             ,1.0                                      ,""                                      ,"Channel-length dependency coefficient of diffusion cap" )
`MPRnb( NDIF              ,-1.0                                     ,""                                      ,"Power coefficient of channel length dependency for diffusion capacitance" )
`MPRnb( LNDIF             ,0.0                                      ,"m"                                     ,"Length dependence of ndif" )
`MPRnb( WNDIF             ,0.0                                      ,"m"                                     ,"Width dependence of ndif" )
`MPRnb( PNDIF             ,0.0                                      ,"m^2"                                   ,"Cross-term dependence of ndif" )

// Diode parameters
`MPRoo( VTM00             ,0.026                                    ,"V"           ,0.0         ,1           ,"Hard coded 25 degC thermal voltage" )
`MPIcc( PERMOD            ,1                                        ,""            ,0           ,1           ,"Whether PS/PD (when given) include gate-edge perimeter" )
`MPRnb( DWJ               ,DWC                                      ,"m"                                     ,"Delta W for S/D junctions" )

`MPRnb( XDIF              ,XBJT                                     ,""                                      ,"Temperature coefficient for Isdif" )
`MPRnb( LXDIF             ,0.0                                      ,"m"                                     ,"Length dependence of xdif" )
`MPRnb( WXDIF             ,0.0                                      ,"m"                                     ,"Width dependence of xdif" )
`MPRnb( PXDIF             ,0.0                                      ,"m^2"                                   ,"Crss-term dependence of xdif" )

`MPRnb( ISDIF             ,1e-7                                     ,"A/m^2"                                 ,"Body to source/drain injection saturation current" )
`MPRnb( IDDIF             ,ISDIF                                    ,"A/m^2"                                 ,"Body to source/drain injection saturation current" )
`MPRnb( LISDIF            ,0.0                                      ,"A/m"                                   ,"Length dependence of isdif" )
`MPRnb( LIDDIF            ,LISDIF                                   ,"A/m"                                   ,"Length dependence of iddif" )
`MPRnb( WISDIF            ,0.0                                      ,"A/m"                                   ,"Width dependence of isdif" )
`MPRnb( WIDDIF            ,WISDIF                                   ,"A/m"                                   ,"Width dependence of iddif" )
`MPRnb( PISDIF            ,0.0                                      ,"A"                                     ,"Cross-term dependence of isdif" )
`MPRnb( PIDDIF            ,PISDIF                                   ,"A"                                     ,"Cross-term dependence of iddif" )

`MPRnb( NRECF0            ,2.0                                      ,""                                      ,"Recombination non-ideality factor at forward bias" )
`MPRnb( LNRECF0           ,0.0                                      ,"m"                                     ,"Length dependence of nrecf0" )
`MPRnb( WNRECF0           ,0.0                                      ,"m"                                     ,"Width dependence of nrecf0" )
`MPRnb( PNRECF0           ,0.0                                      ,"m^2"                                   ,"Cross-term dependence of nrecf0" )

`MPRnb( NRECR0            ,10.0                                     ,""                                      ,"Recombination non-ideality factor at reversed bias" )
`MPRnb( LNRECR0           ,0.0                                      ,"m"                                     ,"Length dependence of nrecr0" )
`MPRnb( WNRECR0           ,0.0                                      ,"m"                                     ,"Width dependence of nrecr0" )
`MPRnb( PNRECR0           ,0.0                                      ,"m^2"                                   ,"Cross-term dependence of nrecr0" )

`MPRnb( XREC              ,1.0                                      ,""                                      ,"Temperature coefficient for Isrec" )
`MPRnb( LXREC             ,0.0                                      ,"m"                                     ,"Length dependence of xrec" )
`MPRnb( WXREC             ,0.0                                      ,"m"                                     ,"Width dependence of xrec" )
`MPRnb( PXREC             ,0.0                                      ,"m^2"                                   ,"cross-section dependence of xrec" )

`MPRnb( ISREC             ,1e-5                                     ,"A/m^2"                                 ,"Recombination in depletion saturation current" )
`MPRnb( IDREC             ,ISREC                                    ,"A/m^2"                                 ,"Recombination in depletion saturation current" )
`MPRnb( LISREC            ,0.0                                      ,"A/m"                                   ,"Length dependence of isrec" )
`MPRnb( LIDREC            ,LISREC                                   ,"A/m"                                   ,"Length dependence of idrec" )
`MPRnb( WISREC            ,0.0                                      ,"A/m"                                   ,"Width dependence of isrec" )
`MPRnb( WIDREC            ,WISREC                                   ,"A/m"                                   ,"Width dependence of idrec" )
`MPRnb( PISREC            ,0.0                                      ,"A"                                     ,"Cross-term dependence of isrec" )
`MPRnb( PIDREC            ,PISREC                                   ,"A"                                     ,"Cross-term dependence of idrec" )

`MPRnb( NTRECF            ,0.0                                      ,""                                      ,"Temperature coefficient for Nrecf" )
`MPRnb( NTRECR            ,0.0                                      ,""                                      ,"Temperature coefficient for Nrecr" )
`MPRnb( LNTRECF           ,0.0                                      ,"m"                                     ,"Length dependence of ntrecf" )
`MPRnb( LNTRECR           ,0.0                                      ,"m"                                     ,"Length dependence of ntrecr" )
`MPRnb( WNTRECF           ,0.0                                      ,"m"                                     ,"Width dependence of ntrecf" )
`MPRnb( WNTRECR           ,0.0                                      ,"m"                                     ,"Width dependence of ntrecr" )
`MPRnb( PNTRECF           ,0.0                                      ,"m^2"                                   ,"Cross-term dependence of ntrecf" )
`MPRnb( PNTRECR           ,0.0                                      ,"m^2"                                   ,"Cross-term dependence of ntrecr" )

`MPRnb( ISTUN             ,1e-8                                     ,"A/m^2"                                 ,"Reverse tunneling saturation current" )
`MPRnb( IDTUN             ,ISTUN                                    ,"A/m^2"                                 ,"Reverse tunneling saturation current" )
`MPRnb( LISTUN            ,0.0                                      ,"A/m"                                   ,"Length dependence of istun" )
`MPRnb( LIDTUN            ,LISTUN                                   ,"A/m"                                   ,"Length dependence of idtun" )
`MPRnb( WISTUN            ,0.0                                      ,"A/m"                                   ,"Width dependence of istun" )
`MPRnb( WIDTUN            ,WISTUN                                   ,"A/m"                                   ,"Width dependence of idtun" )
`MPRnb( PISTUN            ,0.0                                      ,"A"                                     ,"Cross-term dependence of istun" )
`MPRnb( PIDTUN            ,PISTUN                                   ,"A"                                     ,"Cross-term dependence of idtun" )

`MPRnb( XTUN              ,0.0                                      ,""                                      ,"Temperature coefficient for Istun" )
`MPRnb( XTUND             ,XTUN                                     ,""                                      ,"Temperature coefficient for Idtun" )
`MPRnb( LXTUN             ,0.0                                      ,"m"                                     ,"Length dependence of xtun" )
`MPRnb( LXTUND            ,LXTUN                                    ,"m"                                     ,"Length dependence of xtund" )
`MPRnb( WXTUN             ,0.0                                      ,"m"                                     ,"Width dependence of xtun" )
`MPRnb( WXTUND            ,WXTUN                                    ,"m"                                     ,"Width dependence of xtund" )
`MPRnb( PXTUN             ,0.0                                      ,"m^2"                                   ,"Cross-term dependence of xtun" )
`MPRnb( PXTUND            ,PXTUN                                    ,"m^2"                                   ,"Cross-term dependence of xtund" )

`MPRnb( NTUN              ,10.0                                     ,""                                      ,"Reverse tunneling non-ideality factor" )
`MPRnb( NTUND             ,NTUN                                     ,""                                      ,"Reverse tunneling non-ideality factor" )
`MPRnb( LNTUN             ,0.0                                      ,"m"                                     ,"Length dependence of ntun" )
`MPRnb( LNTUND            ,LNTUN                                    ,"m"                                     ,"Length dependence of ntund" )
`MPRnb( WNTUN             ,0.0                                      ,"m"                                     ,"Width dependence of ntun" )
`MPRnb( WNTUND            ,WNTUN                                    ,"m"                                     ,"Width dependence of ntund" )
`MPRnb( PNTUN             ,0.0                                      ,"m^2"                                   ,"Cross-term dependence of ntun" )
`MPRnb( PNTUND            ,PNTUN                                    ,"m^2"                                   ,"Cross-term dependence of ntund" )

`MPRnb( VTUN0             ,0.0                                      ,"V"                                     ,"Voltage dependent parameter for tunneling current" )
`MPRnb( VTUN0D            ,VTUN0                                    ,"V"                                     ,"Voltage dependent parameter for tunneling current" )
`MPRnb( LVTUN0            ,0.0                                      ,"V*m"                                   ,"Length dependence of vtun0" )
`MPRnb( LVTUN0D           ,LVTUN0                                   ,"V*m"                                   ,"Length dependence of vtun0d" )
`MPRnb( WVTUN0            ,0.0                                      ,"V*m"                                   ,"Width dependence of vtun0" )
`MPRnb( WVTUN0D           ,WVTUN0                                   ,"V*m"                                   ,"Width dependence of vtun0d" )
`MPRnb( PVTUN0            ,0.0                                      ,"V*m^2"                                 ,"Cross-term dependence of vtun0" )
`MPRnb( PVTUN0D           ,PVTUN0                                   ,"V*m^2"                                 ,"Cross-term dependence of vtun0d" )

`MPRnb( VREC0             ,0.0                                      ,"V"                                     ,"Voltage dependent parameter for recombination current" )
`MPRnb( VREC0D            ,VREC0                                    ,"V"                                     ,"Voltage dependent parameter for recombination current" )
`MPRnb( LVREC0            ,0.0                                      ,"V*m"                                   ,"Length dependence of vrec0" )
`MPRnb( LVREC0D           ,LVREC0                                   ,"V*m"                                   ,"Length dependence of vrec0d" )
`MPRnb( WVREC0            ,0.0                                      ,"V*m"                                   ,"Width dependence of vrec0" )
`MPRnb( WVREC0D           ,WVREC0                                   ,"V*m"                                   ,"Width dependence of vrec0d" )
`MPRnb( PVREC0            ,0.0                                      ,"V*m^2"                                 ,"Cross-term dependence of vrec0" )
`MPRnb( PVREC0D           ,PVREC0                                   ,"V*m^2"                                 ,"Cross-term dependence of vrec0d" )

// High-speed/RF model parameters
`MPRcz( XRCRG1            ,12.0                                     ,""                                      ,"1st fitting parameter the bias-dependent Rg" )
`MPRcz( XRCRG2            ,1.0                                      ,""                                      ,"2nd fitting parameter the bias-dependent Rg" )

// Flicker noise
`MPRoc( EF                ,1.0                                      ,""            ,0.0         ,2.0         ,"Flicker noise frequency exponent" )
`MPRnb( EM                ,4.1e7                                    ,"V/m"                                   ,"Saturation field" )
`MPRnb( NOIA              ,6.250e40                                 ,"s^(1-EF)/(eV)^1/m^3"                   ,"Flicker noise parameter A" )
`MPRnb( NOIB              ,3.125e25                                 ,"s^(1-EF)/(eV)^1/m"                     ,"Flicker noise parameter B" )
`MPRnb( NOIC              ,8.750e8                                  ,"s^(1-EF)*m/(eV)^1"                     ,"Flicker noise parameter C" )
`MPRnb( LINTNOI           ,0.0                                      ,"m"                                     ,"Length reduction parameter offset" )
`MPRcz( NOIA1             ,0.0                                      ,""                                      ,"Flicker noise fitting parameter in strong inversion" )
`MPRoz( NOIAX             ,1.0                                      ,""                                      ,"Flicker noise fitting parameter in strong inversion for high VDS" )

// Thermal noise
`MPRcz( NTNOI             ,1.0                                      ,""                                      ,"Noise factor for short-channel devices for TNOIMOD = 0 only" )
`MPRnb( RNOIA             ,0.577                                    ,""                                      ,"Noise parameter for TNOIMOD = 1" )
`MPRnb( RNOIB             ,0.5164                                   ,""                                      ,"Noise parameter for TNOIMOD = 1" )
`MPRnb( RNOIC             ,0.395                                    ,""                                      ,"Noise parameter for TNOIMOD = 1" )
`MPRoo( TNOIA             ,1.5                                      ,""            ,-inf        ,inf         ,"Noise parameter for TNOIMOD = 1" )
`MPRoo( TNOIB             ,3.5                                      ,""            ,-inf        ,inf         ,"Noise parameter for TNOIMOD = 1" )
`MPRoo( TNOIC             ,0.0                                      ,""            ,-inf        ,inf         ,"Noise correlation coefficient for TNOIMOD = 1" )

// Floating body excess noise
`MPRco( NOIF              ,1.0                                      ,""            ,0           ,inf         ,"Floating body excess noise ideality factor" )

// Binning parameters
`MPIcc( BINUNIT           ,1                                        ,""            ,0           ,1           ,"Unit of L and W for Binning, 1: micro-meter, 0: default" )
`MPRnb( DLBIN             ,0.0                                      ,""                                      ,"Length reduction parameter for binning" )
`MPRnb( DWBIN             ,0.0                                      ,""                                      ,"Width reduction parameter for binning" )

// Temperature dependence parameters
`MPRnb( TNOM              ,27.0                                     ,"degC"                                  ,"Temperature at which the model was extracted" )
`MPRnb( TBGASUB           ,4.73e-4                                  ,"eV/K"                                  ,"Bandgap temperature coefficient" )
`MPRnb( TBGBSUB           ,636.0                                    ,"K"                                     ,"Bandgap temperature coefficient" )
`MPRnb( TNFACTOR          ,0.0                                      ,""                                      ,"Temperature exponent for NFACTOR" )
`MPRnb( UTE               ,-1.5                                     ,""                                      ,"Mobility temperature exponent" )
`MPRnb( LUTE              ,0.0                                      ,"m"                                     ,"Length dependence of UTE" )
`MPRnb( WUTE              ,0.0                                      ,"m"                                     ,"Width dependence of UTE" )
`MPRnb( PUTE              ,0.0                                      ,"m^2"                                   ,"Area dependence of UTE" )
`MPRnb( UTEL              ,0.0                                      ,"m"                                     ,"Length scaling parameter for UTE" )
`MPRnb( UA1               ,1.0e-3                                   ,"m/V"                                   ,"Temperature coefficient for UA" )
`MPRnb( LUA1              ,0.0                                      ,"m^2/V"                                 ,"Length dependence of UA1" )
`MPRnb( WUA1              ,0.0                                      ,"m^2/V"                                 ,"Width dependence of UA1" )
`MPRnb( PUA1              ,0.0                                      ,"m^3/V"                                 ,"Area dependence of UA1" )
`MPRnb( UA1L              ,0.0                                      ,"m"                                     ,"Length scaling parameter for UA1" )
`MPRnb( UC1               ,0.056e-9                                 ,"1.0/K"                                   ,"Temperature coefficient for UC" )
`MPRnb( LUC1              ,0.0                                      ,"m/K"                                   ,"Length dependence of UC1" )
`MPRnb( WUC1              ,0.0                                      ,"m/K"                                   ,"Width dependence of UC1" )
`MPRnb( PUC1              ,0.0                                      ,"m^2/K"                                 ,"Area dependence of UC1" )
`MPRnb( UD1               ,0.0                                      ,"1/m^2"                                 ,"Temperature coefficient for UD" )
`MPRnb( LUD1              ,0.0                                      ,"1/m"                                   ,"Length dependence of UD1" )
`MPRnb( WUD1              ,0.0                                      ,"1/m"                                   ,"Width dependence of UD1" )
`MPRnb( PUD1              ,0.0                                      ,""                                      ,"Area dependence of UD1" )
`MPRnb( UDB1              ,0.0                                      ,"1/m^2"                                 ,"Temperature coefficient for UDB" )
`MPRnb( LUDB1             ,0.0                                      ,"1/m"                                   ,"Length dependence of UDB1" )
`MPRnb( WUDB1             ,0.0                                      ,"1/m"                                   ,"Width dependence of UDB1" )
`MPRnb( PUDB1             ,0.0                                      ,""                                      ,"Area dependence of UDB1" )
`MPRnb( EBA               ,0.0                                      ,""                                      ,"Back-gate bias-dependent mobility parameter" )

`MPRnb( UD1L              ,0.0                                      ,"m"                                     ,"Length scaling parameter for UD1" )
`MPRnb( UDB1L             ,0.0                                      ,"m"                                     ,"Length scaling parameter for UD1" )
`MPRnb( EU1               ,0.0                                      ,""                                      ,"Temperature coefficient for EU" )
`MPRnb( LEU1              ,0.0                                      ,"m"                                     ,"Length dependence of EU1" )
`MPRnb( WEU1              ,0.0                                      ,"m"                                     ,"Width dependence of EU1" )
`MPRnb( PEU1              ,0.0                                      ,"m^2"                                   ,"Area dependence of EU1" )
`MPRnb( UCSTE             ,-4.775e-3                                ,""                                      ,"Temperature coefficient for UCS" )
`MPRnb( LUCSTE            ,0.0                                      ,"m"                                     ,"Length dependence of UCSTE" )
`MPRnb( WUCSTE            ,0.0                                      ,"m"                                     ,"Width dependence of UCSTE" )
`MPRnb( PUCSTE            ,0.0                                      ,"m^2"                                   ,"Area dependence of UCSTE" )
`MPRnb( TETA0             ,0.0                                      ,""                                      ,"Temperature coefficient for ETA0" )
`MPRnb( PRT               ,0.0                                      ,""                                      ,"Temperature coefficient for resistance" )
`MPRnb( LPRT              ,0.0                                      ,"m"                                     ,"Length dependence of PRT" )
`MPRnb( WPRT              ,0.0                                      ,"m"                                     ,"Width dependence of PRT" )
`MPRnb( PPRT              ,0.0                                      ,"m^2"                                   ,"Area dependence of PRT" )
`MPRnb( AT                ,-1.56e-3                                 ,"m/s"                                   ,"Temperature coefficient for saturation velocity" )
`MPRnb( LAT               ,0.0                                      ,"m^2/s"                                 ,"Length dependence of AT" )
`MPRnb( WAT               ,0.0                                      ,"m^2/s"                                 ,"Width dependence of AT" )
`MPRnb( PAT               ,0.0                                      ,"m^3/s"                                 ,"Area dependence of AT" )
`MPRnb( ATL               ,0.0                                      ,"m"                                     ,"Length Scaling parameter for AT" )
`MPRnb( TDELTA            ,0.0                                      ,"1/K"                                   ,"Temperature coefficient for DELTA" )
`MPRnb( PTWGT             ,0.0                                      ,"1/K"                                   ,"Temperature coefficient for PTWG" )
`MPRnb( LPTWGT            ,0.0                                      ,"m/K"                                   ,"Length dependence of PTWGT" )
`MPRnb( WPTWGT            ,0.0                                      ,"m/K"                                   ,"Width dependence of PTWGT" )
`MPRnb( PPTWGT            ,0.0                                      ,"m^2/K"                                 ,"Area dependence of PTWGT" )
`MPRnb( PTWGTL            ,0.0                                      ,"m/K"                                   ,"Length scaling parameter for PTWGT" )
`MPRnb( KT1               ,-0.11                                    ,"V"                                     ,"Temperature coefficient for Vth" )
`MPRoz( KT1EXP            ,1.0                                      ,""                                      ,"Temperature coefficient for Vth" )
`MPRnb( KT1L              ,0.0                                      ,"V*m"                                   ,"Temperature coefficient for Vth" )
`MPRnb( LKT1              ,0.0                                      ,"V*m"                                   ,"Length dependence of KT1" )
`MPRnb( WKT1              ,0.0                                      ,"V*m"                                   ,"Width dependence of KT1" )
`MPRnb( PKT1              ,0.0                                      ,"V*m^2"                                 ,"Area dependence of KT1" )
`MPRnb( KT2               ,0.022                                    ,""                                      ,"Temperature coefficient for Vth" )
`MPRnb( LKT2              ,0.0                                      ,"m"                                     ,"Length dependence of KT2" )
`MPRnb( WKT2              ,0.0                                      ,"m"                                     ,"Width dependence of KT2" )
`MPRnb( PKT2              ,0.0                                      ,"m^2"                                   ,"Area dependence of KT2" )
`MPRnb( IIT               ,0.0                                      ,""                                      ,"Temperature coefficient for BETA0" )
`MPRnb( LIIT              ,0.0                                      ,"m"                                     ,"Length dependence of IIT" )
`MPRnb( WIIT              ,0.0                                      ,"m"                                     ,"Width dependence of IIT" )
`MPRnb( PIIT              ,0.0                                      ,"m^2"                                   ,"Area dependence of IIT" )
`MPRnb( IGT               ,2.5                                      ,""                                      ,"Gate current temperature dependence" )
`MPRnb( LIGT              ,0.0                                      ,"m"                                     ,"Length dependence of IGT" )
`MPRnb( WIGT              ,0.0                                      ,"m"                                     ,"Width dependence of IGT" )
`MPRnb( PIGT              ,0.0                                      ,"m^2"                                   ,"Area dependence of IGT" )
`MPRnb( TCJ               ,0.0                                      ,"1/K"                                   ,"Temperature coefficient for CJS/CJD" )
`MPRnb( TCJSW             ,0.0                                      ,"1/K"                                   ,"Temperature coefficient for CJSWS/CJSWD" )
`MPRnb( TCJSWG            ,0.0                                      ,"1/K"                                   ,"Temperature coefficient for CJSWGS/CJSWGD" )
`MPRnb( TPB               ,0.0                                      ,"V/K"                                   ,"Temperature coefficient for PBS/PBD" )
`MPRnb( TPBSW             ,0.0                                      ,"V/K"                                   ,"Temperature coefficient for PBSWS/PBSWD" )
`MPRnb( TPBSWG            ,0.0                                      ,"V/K"                                   ,"Temperature coefficient for PBSWGS/PBSWGD" )

// Self heating parameters
`MPRco( RTH0              ,0.0                                      ,"m*K/W"       ,0.0         ,inf         ,"Thermal resistance" )
`MPRco( CTH0              ,1.0e-5                                   ,"s*W/(m*K)"   ,0.0         ,inf         ,"Thermal capacitance" )
`MPRnb( WTH0              ,0.0                                      ,"m"                                     ,"Width dependence coefficient for Rth and Cth" )

// Stress related parameters
`MPRoz( SAREF             ,1.0e-6                                   ,"m"                                     ,"Reference distance between OD edge from Poly from one side" )
`MPRoz( SBREF             ,1.0e-6                                   ,"m"                                     ,"Reference distance between OD edge from Poly from other side" )
`MPRcz( WLOD              ,0.0                                      ,"m"                                     ,"Width parameter for stress effect" )
`MPRnb( KU0               ,0.0                                      ,"m"                                     ,"Mobility degradation/enhancement parameter for stress effect" )
`MPRnb( KVSAT             ,0.0                                      ,"m"                                     ,"Saturation velocity degradation/enhancement parameter for stress effect" )
`MPRnb( TKU0              ,0.0                                      ,""                                      ,"Temperature coefficient for KU0" )
`MPRnb( LKU0              ,0.0                                      ,"m^LLODKU0"                             ,"Length dependence of KU0" )
`MPRnb( WKU0              ,0.0                                      ,"m^WLODKU0"                             ,"Width dependence of KU0" )
`MPRnb( PKU0              ,0.0                                      ,"m^(LLODKU0+WLODKU0)"                   ,"Cross-term dependence of KU0" )
`MPRnb( LLODKU0           ,0.0                                      ,""                                      ,"Length parameter for U0 stress effect" )
`MPRnb( WLODKU0           ,0.0                                      ,""                                      ,"Width parameter for U0 stress effect" )
`MPRnb( KVTH0             ,0.0                                      ,"V*m"                                   ,"Threshold shift parameter for stress effect" )
`MPRnb( LKVTH0            ,0.0                                      ,"m^LLODKU0"                             ,"Length dependence of KVTH0" )
`MPRnb( WKVTH0            ,0.0                                      ,"m^WLODKU0"                             ,"Width dependence of KVTH0" )
`MPRnb( PKVTH0            ,0.0                                      ,"m^(LLODKU0+WLODKU0)"                   ,"Cross-term dependence of KVTH0" )
`MPRnb( LLODVTH           ,0.0                                      ,""                                      ,"Length parameter for Vth stress effect" )
`MPRnb( WLODVTH           ,0.0                                      ,""                                      ,"Width parameter for Vth stress effect" )
`MPRnb( STK2              ,0.0                                      ,"m"                                     ,"K2 shift factor related to Vth change" )
`MPRnb( LODK2             ,0.0                                      ,""                                      ,"K2 shift modification factor for stress effect" )
`MPRnb( STETA0            ,0.0                                      ,"m"                                     ,"ETA0 shift related to Vth0 change" )
`MPRnb( LODETA0           ,0.0                                      ,""                                      ,"ETA0 modification factor for stress effect" )

// Well proximity parameters
`MPRnb( WEB               ,0.0                                      ,""                                      ,"Coefficient for SCB (> 0)" )
`MPRnb( WEC               ,0.0                                      ,""                                      ,"Coefficient for SCC (> 0)" )
`MPRnb( KVTH0WE           ,0.0                                      ,""                                      ,"Threshold shift factor for well proximity effect" )
`MPRnb( LKVTH0WE          ,0.0                                      ,"m"                                     ,"Length dependence of KVTH0WE" )
`MPRnb( WKVTH0WE          ,0.0                                      ,"m"                                     ,"Width dependence of KVTH0WE" )
`MPRnb( PKVTH0WE          ,0.0                                      ,"m^2"                                   ,"Area dependence of KVTH0WE" )
`MPRnb( K2WE              ,0.0                                      ,""                                      ,"K2 shift factor for well proximity effect" )
`MPRnb( LK2WE             ,0.0                                      ,"m"                                     ,"Length dependence of K2WE" )
`MPRnb( WK2WE             ,0.0                                      ,"m"                                     ,"Width dependence of K2WE" )
`MPRnb( PK2WE             ,0.0                                      ,"m^2"                                   ,"Area dependence of K2WE" )
`MPRnb( KU0WE             ,0.0                                      ,""                                      ,"Mobility degradation factor for well proximity effect" )
`MPRnb( LKU0WE            ,0.0                                      ,"m"                                     ,"Length dependence of KU0WE" )
`MPRnb( WKU0WE            ,0.0                                      ,"m"                                     ,"Width dependence of KU0WE" )
`MPRnb( PKU0WE            ,0.0                                      ,"m^2"                                   ,"Area dependence of KU0WE" )
`MPRoo( SCREF             ,1.0e-6                                   ,"m"           ,0.0         ,inf         ,"Reference distance to calculate SCA,SCB and SCC (< 0)" )

// Sub-surface leakage drain current
`MPRnb( SSL0              ,4.0e2                                    ,"A/m"                                   ,"Temperature- and doping-independent parameter for sub-surface leakage drain current" )
`MPRnb( SSL1              ,3.36e8                                   ,"1/m"                                   ,"Temperature- and doping-independent parameter for gate length for sub-surface leakage drain current" )
`MPRnb( SSL2              ,0.185                                    ,""                                      ,"Fitting parameter for sub-surface leakage drain current: barrier height" )
`MPRnb( SSL3              ,0.3                                      ,"V"                                     ,"Fitting parameter for sub-surface leakage drain current: gate voltage effect" )
`MPRnb( SSL4              ,1.4                                      ,"1/V"                                   ,"Fitting parameter for sub-surface leakage drain current: gate voltage effect" )
`MPRnb( SSL5              ,0                                        ,"1/V"                                   ,"Fitting parameter for sub-surface leakage drain current: gate voltage effect")
`MPRnb( SSLEXP1           ,0.490                                    ,""                                      ,"Fitting exponent for SSL doping effect" )
`MPRnb( SSLEXP2           ,1.42                                     ,""                                      ,"Fitting exponent for SSL temperature" )

// Vdsx smoothing
`MPRco( AVDSX             ,20.0                                     ,""            ,5.0         ,100.0       ,"Smoothing parameter in Vdsx in Vbsx" )

// STI edge FET device parameters
`MPRco( WEDGE             ,10.0e-9                                  ,"m"           ,1.0e-9      ,inf         ,"Edge FET width" )
`MPRoo( DGAMMAEDGE        ,0.0                                      ,""            ,-inf        ,inf         ,"Different in body-bias coefficient between Edge-FET and Main-FET" )
`MPRoo( DGAMMAEDGEL       ,0.0                                      ,""            ,-inf        ,inf         ,"L dependence parameter for DGAMMA" )
`MPRoo( DGAMMAEDGELEXP    ,1.0                                      ,""            ,-inf        ,inf         ,"Exponent of L dependence parameter for DGAMMA" )
`MPRoo( DVTEDGE           ,0.0                                      ,""            ,-inf        ,inf         ,"Vth shift for Edge FET" )
`MPRnb( NDEPEDGE          ,1e24                                     ,"1/m^3"                                 ,"Channel doping concentration for EDGEFET" )
`MPRnb( LNDEPEDGE         ,0.0                                      ,"1/m^2"                                 ,"Length dependence of NDEPEDGE" )
`MPRnb( WNDEPEDGE         ,0.0                                      ,"1/m^2"                                 ,"Width dependence of NDEPEDGE" )
`MPRnb( PNDEPEDGE         ,0.0                                      ,"1/m"                                   ,"Area dependence of NDEPEDGE" )
`MPRnb( NFACTOREDGE       ,0.0                                      ,""                                      ,"NFACTOR for Edge FET" )
`MPRnb( LNFACTOREDGE      ,0.0                                      ,"m"                                     ,"Length dependence of NFACTOREDGE" )
`MPRnb( WNFACTOREDGE      ,0.0                                      ,"m"                                     ,"Width dependence of NFACTOREDGE" )
`MPRnb( PNFACTOREDGE      ,0.0                                      ,"m^2"                                   ,"Area dependence of NFACTOREDGE" )
`MPRnb( CITEDGE           ,0.0                                      ,"F/m^2"                                 ,"CIT for Edge FET" )
`MPRnb( LCITEDGE          ,0.0                                      ,"F/m"                                   ,"Length dependence of CITEDGE" )
`MPRnb( WCITEDGE          ,0.0                                      ,"F/m"                                   ,"Width dependence of CITEDGE" )
`MPRnb( PCITEDGE          ,0.0                                      ,"F"                                     ,"Area dependence of CITEDGE" )
`MPRnb( CDSCEDGE          ,1e-9                                     ,"F/m^2/V"                               ,"CDSC for edge FET" )
`MPRnb( LCDSCEDGE         ,0.0                                      ,"F/m/V"                                 ,"Length dependence of CDSCEDGE" )
`MPRnb( WCDSCEDGE         ,0.0                                      ,"F/m/V"                                 ,"Width dependence of CDSCEDGE" )
`MPRnb( PCDSCEDGE         ,0.0                                      ,"F/V"                                   ,"Area dependence of CDSCEDGE" )
`MPRnb( CDSCDEDGE         ,1e-9                                     ,"F/m^2/V"                               ,"CDSCD for edge FET" )
`MPRnb( LCDSCDEDGE        ,0.0                                      ,"F/m/V"                                 ,"Length dependence of CDSCDEDGE" )
`MPRnb( WCDSCDEDGE        ,0.0                                      ,"F/m/V"                                 ,"Width dependence of CDSCDEDGE" )
`MPRnb( PCDSCDEDGE        ,0.0                                      ,"F/V"                                   ,"Area dependence of CDSCDEDGE" )
`MPRnb( CDSCDEDGER        ,1e-9                                     ,"F/m^2/V"                               ,"CDSCDR for edge FET" )
`MPRnb( LCDSCDEDGER       ,0.0                                      ,"F/m/V"                                 ,"Length dependence of CDSCDEDGER" )
`MPRnb( WCDSCDEDGER       ,0.0                                      ,"F/m/V"                                 ,"Width dependence of CDSCDEDGER" )
`MPRnb( PCDSCDEDGER       ,0.0                                      ,"F/V"                                   ,"Area dependence of CDSCDEDGER" )
`MPRnb( CSECSEEDGE        ,0.0                                      ,"F/(m^2*V)"                             ,"CSECSE for edge FET" )
`MPRnb( LCSECSEEDGE       ,0.0                                      ,"F/m/V"                                 ,"Length dependence of CSECSEEDGE" )
`MPRnb( WCSECSEEDGE       ,0.0                                      ,"F/m/V"                                 ,"Width dependence of CSECSEEDGE" )
`MPRnb( PCSECSEEDGE       ,0.0                                      ,"F/V"                                   ,"Area dependence of CSECSEEDGE" )
`MPRnb( CSECSEPEDGE       ,0.0                                      ,"F/(m^2*V)"                             ,"CSECSEP for edge FET" )
`MPRnb( CSECSE0EDGE       ,0.0                                      ,"F/(m^2*V)"                             ,"CSECSE0 for edge FET" )
`MPRnb( CSECSE0PEDGE      ,0.0                                      ,"F/(m^2*V^2)"                           ,"CSECSE0P for edge FET" )
`MPRnb( CSECSEDEDGE       ,0.0                                      ,"F/(m^2*V^2)"                           ,"CSECSED for edge FET" )
`MPRnb( CBCB0EDGE         ,0.0                                      ,"F/(m^2*V)"                             ,"CBCB0 for edge FET" )
`MPRnb( CBCB0PEDGE        ,0.0                                      ,"F/(m^2*V^2)"                           ,"CBCB0P for edge FET" )
`MPRnb( CDSCBEDGE         ,0.0                                      ,"F/m^2/V"                               ,"CDSCB for edge FET" )
`MPRnb( LCDSCBEDGE        ,0.0                                      ,"F/m/V"                                 ,"Length dependence of CDSCBEDGE" )
`MPRnb( WCDSCBEDGE        ,0.0                                      ,"F/m/V"                                 ,"Width dependence of CDSCBEDGE" )
`MPRnb( PCDSCBEDGE        ,0.0                                      ,"F/V"                                   ,"Area dependence of CDSCBEDGE" )
`MPRnb( CBCBPEDGE         ,0.0                                      ,"F/(m^2*V)"                             ,"CBCBP for edge FET" )
`MPRnb( CBCBEDGE          ,0.0                                      ,"F/(m^2*V)"                             ,"CBCB for edge FET" )
`MPRnb( LCBCBEDGE         ,0.0                                      ,"F/m/V"                                 ,"Length dependence of CBCBEDGE" )
`MPRnb( WCBCBEDGE         ,0.0                                      ,"F/m/V"                                 ,"Width dependence of CBCBEDGE" )
`MPRnb( PCBCBEDGE         ,0.0                                      ,"F/V"                                   ,"Area dependence of CBCBEDGE" )
`MPRnb( CBCBDEDGE         ,0.0                                      ,"F/(m^2*V^2)"                           ,"CBCBD for edge FET" )
`MPRnb( K1EDGE            ,0.0                                      ,"V^0.5"                                 ,"K1 for edge FET" )
`MPRnb( K1LEDGE           ,0.0                                      ,""                                      ,"length dependence coefficient of K1EDGE" )
`MPRoz( K1LEXPEDGE        ,1.0                                      ,""                                      ,"Length dependence exponent coefficient of K1EDGE" )
`MPRnb( K1WEDGE           ,0.0                                      ,""                                      ,"Width dependence coefficient of K1EDGE" )
`MPRoz( K1WEXPEDGE        ,1.0                                      ,""                                      ,"Width dependence exponent coefficient of K1EDGE" )
`MPRnb( K1WLEDGE          ,0.0                                      ,""                                      ,"Width-length dependence coefficient of K1EDGE" )
`MPRoz( K1WLEXPEDGE       ,1.0                                      ,""                                      ,"Width-length dependence exponent coefficient of K1EDGE" )
`MPRnb( LK1EDGE           ,0.0                                      ,"m*V^0.5"                               ,"Length dependence of K1EDGE" )
`MPRnb( WK1EDGE           ,0.0                                      ,"m*V^0.5"                               ,"Width dependence of K1EDGE" )
`MPRnb( PK1EDGE           ,0.0                                      ,"m^2*V^0.5"                             ,"Area dependence of K1EDGE" )
`MPRnb( ETA0EDGE          ,0.08                                     ,""                                      ,"DIBL parameter for edge FET" )
`MPRnb( LETA0EDGE         ,0.0                                      ,"m"                                     ,"Length dependence of ETA0EDGE" )
`MPRnb( WETA0EDGE         ,0.0                                      ,"m"                                     ,"Width dependence of ETA0EDGE" )
`MPRnb( PETA0EDGE         ,0.0                                      ,"m^2"                                   ,"Area dependence of ETA0EDGE" )
`MPRnb( ETABEDGE          ,-0.07                                    ,"1/V"                                   ,"ETAB for edge FET" )
`MPRnb( LETABEDGE         ,0.0                                      ,"m/V"                                   ,"Length dependence of ETABEDGE" )
`MPRnb( WETABEDGE         ,0.0                                      ,"m/V"                                   ,"Width dependence of ETABEDGE" )
`MPRnb( PETABEDGE         ,0.0                                      ,"m^2/V"                                 ,"Area dependence of ETABEDGE" )
`MPRnb( KT1EDGE           ,-0.11                                    ,"V"                                     ,"Temperature dependence parameter of threshold voltage for edge FET" )
`MPRnb( LKT1EDGE          ,0.0                                      ,"V*m"                                   ,"Length dependence of KT1EDGE" )
`MPRnb( WKT1EDGE          ,0.0                                      ,"V*m"                                   ,"Width dependence of KT1EDGE" )
`MPRnb( PKT1EDGE          ,0.0                                      ,"V*m^2"                                 ,"Area dependence of KT1EDGE" )
`MPRnb( KT1LEDGE          ,0.0                                      ,"V*m"                                   ,"Temperature dependence parameter of threshold voltage for edge FET" )
`MPRnb( LKT1LEDGE         ,0.0                                      ,"V*m^2"                                 ,"Length dependence of KT1LEDGE" )
`MPRnb( WKT1LEDGE         ,0.0                                      ,"V*m^2"                                 ,"Width dependence of KT1LEDGE" )
`MPRnb( PKT1LEDGE         ,0.0                                      ,"V*m^3"                                 ,"Area dependence of KT1LEDGE" )
`MPRnb( KT2EDGE           ,0.022                                    ,""                                      ,"Temperature dependence parameter of threshold voltage for edge FET" )
`MPRnb( LKT2EDGE          ,0.0                                      ,"m"                                     ,"Length dependence of KT2EDGE" )
`MPRnb( WKT2EDGE          ,0.0                                      ,"m"                                     ,"Width dependence of KT2EDGE" )
`MPRnb( PKT2EDGE          ,0.0                                      ,"m^2"                                   ,"Area dependence of KT2EDGE" )
`MPRnb( KT1EXPEDGE        ,1.0                                      ,""                                      ,"Temperature dependence parameter of threshold voltage for edge device" )
`MPRnb( LKT1EXPEDGE       ,0.0                                      ,"m"                                     ,"Length dependence of KT1EXPEDGE" )
`MPRnb( WKT1EXPEDGE       ,0.0                                      ,"m"                                     ,"Width dependence of KT1EXPEDGE" )
`MPRnb( PKT1EXPEDGE       ,0.0                                      ,"m^2"                                   ,"Area dependence of KT1EXPEDGE" )
`MPRnb( TNFACTOREDGE      ,0.0                                      ,""                                      ,"Temperature dependence parameter of subthreshold slope factor for edge" )
`MPRnb( LTNFACTOREDGE     ,0.0                                      ,"m"                                     ,"Length dependence of TNFACTOREDGE" )
`MPRnb( WTNFACTOREDGE     ,0.0                                      ,"m"                                     ,"Width dependence of TNFACTOREDGE" )
`MPRnb( PTNFACTOREDGE     ,0.0                                      ,"m^2"                                   ,"Area dependence of TNFACTOREDGE" )
`MPRnb( TETA0EDGE         ,0.0                                      ,""                                      ,"Temperature dependence parameter of DIBL parameter for edge FET" )
`MPRnb( LTETA0EDGE        ,0.0                                      ,"m"                                     ,"Length dependence of TETA0EDGE" )
`MPRnb( WTETA0EDGE        ,0.0                                      ,"m"                                     ,"Width dependence of TETA0EDGE" )
`MPRnb( PTETA0EDGE        ,0.0                                      ,"m^2"                                   ,"Area dependence of TETA0EDGE" )
`MPRnb( DVTP0EDGE         ,0.0                                      ,"m"                                     ,"DVTP0 for edge FET" )
`MPRnb( LDVTP0EDGE        ,0.0                                      ,"m^2"                                   ,"Length dependence of DVTP0EDGE" )
`MPRnb( WDVTP0EDGE        ,0.0                                      ,"m^2"                                   ,"Width dependence of DVTP0EDGE" )
`MPRnb( PDVTP0EDGE        ,0.0                                      ,"m^3"                                   ,"Area dependence of DVTP0EDGE" )
`MPRnb( DVTP1EDGE         ,0.0                                      ,"1/V"                                   ,"DVTP1 for edge FET" )
`MPRnb( LDVTP1EDGE        ,0.0                                      ,"m/V"                                   ,"Length dependence of DVTP1EDGE" )
`MPRnb( WDVTP1EDGE        ,0.0                                      ,"m/V"                                   ,"Width dependence of DVTP1EDGE" )
`MPRnb( PDVTP1EDGE        ,0.0                                      ,"m^2/V"                                 ,"Area dependence of DVTP1EDGE" )
`MPRnb( DVTP2EDGE         ,0.0                                      ,"m*V"                                   ,"DVTP2 for edge FET" )
`MPRnb( LDVTP2EDGE        ,0.0                                      ,"V*m^2"                                 ,"Length dependence of DVTP2EDGE" )
`MPRnb( WDVTP2EDGE        ,0.0                                      ,"V*m^2"                                 ,"Width dependence of DVTP2EDGE" )
`MPRnb( PDVTP2EDGE        ,0.0                                      ,"V*m^3"                                 ,"Area dependence of DVTP2EDGE" )
`MPRnb( DVTP3EDGE         ,0.0                                      ,""                                      ,"DVTP3 for edge FET" )
`MPRnb( LDVTP3EDGE        ,0.0                                      ,"m"                                     ,"Length dependence of DVTP3EDGE" )
`MPRnb( WDVTP3EDGE        ,0.0                                      ,"m"                                     ,"Width dependence of DVTP3EDGE" )
`MPRnb( PDVTP3EDGE        ,0.0                                      ,"m^2"                                   ,"Area dependence of DVTP3EDGE" )
`MPRnb( DVTP4EDGE         ,0.0                                      ,"1/V"                                   ,"DVTP4 for edge FET" )
`MPRnb( LDVTP4EDGE        ,0.0                                      ,"m/V"                                   ,"Length dependence of DVTP4EDGE" )
`MPRnb( WDVTP4EDGE        ,0.0                                      ,"m/V"                                   ,"Width dependence of DVTP4EDGE" )
`MPRnb( PDVTP4EDGE        ,0.0                                      ,"m^2/V"                                 ,"Area dependence of DVTP4EDGE" )
`MPRnb( DVTP5EDGE         ,0.0                                      ,"V"                                     ,"DVTP5 for edge FET" )
`MPRnb( LDVTP5EDGE        ,0.0                                      ,"m*V"                                   ,"Length dependence of DVTP5EDGE" )
`MPRnb( WDVTP5EDGE        ,0.0                                      ,"m*V"                                   ,"Width dependence of DVTP5EDGE" )
`MPRnb( PDVTP5EDGE        ,0.0                                      ,"m^2*V"                                 ,"Area dependence of DVTP5EDGE" )
`MPRnb( DVT0EDGE          ,2.2                                      ,""                                      ,"First coefficient of SCE effect on Vth for Edge FET" )
`MPRnb( DVT1EDGE          ,0.53                                     ,""                                      ,"Second coefficient of SCE effect on Vth for Edge FET" )
`MPRnb( DVT2EDGE          ,0.0                                      ,"1/V"                                   ,"Body-bias coefficient for SCE effect for Edge FET" )
`MPRnb( K2EDGE            ,0.0                                      ,"V"                                     ,"K2 for edge FET" )
`MPRnb( K2LEDGE           ,0.0                                      ,"m^K2LEXP"                              ,"Length dependence coefficient of K2EDGE" )
`MPRoz( K2LEXPEDGE        ,1.0                                      ,""                                      ,"Length dependence exponent coefficient of K2EDGE" )
`MPRnb( K2WEDGE           ,0.0                                      ,"m^K2WEXP"                              ,"Width dependence coefficient of K2EDGE" )
`MPRoz( K2WEXPEDGE        ,1.0                                      ,""                                      ,"Width dependence exponent coefficient of K2EDGE" )
`MPRnb( K2WLEDGE          ,0.0                                      ,"m^(2*K2WLEXP)"                         ,"Width-length dependence coefficient of K2EDGE" )
`MPRoz( K2WLEXPEDGE       ,1.0                                      ,""                                      ,"Width-length dependence exponent coefficient of K2EDGE" )
`MPRnb( LK2EDGE           ,0.0                                      ,"V*m"                                   ,"Length dependence of K2EDGE" )
`MPRnb( WK2EDGE           ,0.0                                      ,"V*m"                                   ,"Width dependence of K2EDGE" )
`MPRnb( PK2EDGE           ,0.0                                      ,"V*m^2"                                 ,"Area dependence of K2EDGE" )
`MPRnb( KVTH0EDGE         ,0.0                                      ,"V*m"                                   ,"Threshold Shift parameter for stress effect" )
`MPRnb( LKVTH0EDGE        ,0.0                                      ,"V*m^2"                                 ,"Length dependence of KVTH0EDGE" )
`MPRnb( WKVTH0EDGE        ,0.0                                      ,"V*m^2"                                 ,"Width dependence of KVTH0EDGE" )
`MPRnb( PKVTH0EDGE        ,0.0                                      ,"V*m^3"                                 ,"Area dependence of KVTH0EDGE" )
`MPRnb( KVTH0EDGEWE       ,0.0                                      ,""                                      ,"Threshold Shift parameter due to Well proximity in EDGEFET" )
`MPRnb( LKVTH0EDGEWE      ,0.0                                      ,"m"                                     ,"Length dependence of KVTHOWEEDGE" )
`MPRnb( WKVTH0EDGEWE      ,0.0                                      ,"m"                                     ,"Width dependence of KVTHOWEEDGE" )
`MPRnb( PKVTH0EDGEWE      ,0.0                                      ,"m^2"                                   ,"Area dependence of KVTHOWEEDGE" )
`MPRnb( K2EDGEWE          ,0.0                                      ,""                                      ,"Vth shift due to Vertical Non-uniform doping due to Well proximity in EDGEFET" )
`MPRnb( LK2EDGEWE         ,0.0                                      ,"m"                                     ,"Length dependence of K2WEEDGE" )
`MPRnb( WK2EDGEWE         ,0.0                                      ,"m"                                     ,"Width dependence of K2WEEDGE" )
`MPRnb( PK2EDGEWE         ,0.0                                      ,"m^2"                                   ,"Area dependence of K2WEEDGE" )
`MPRnb( STK2EDGE          ,0.0                                      ,"m"                                     ,"K2 shift factor related to Vth change" )
`MPRnb( LSTK2EDGE         ,0.0                                      ,"m^2"                                   ,"Length dependence of STK2EDGE" )
`MPRnb( WSTK2EDGE         ,0.0                                      ,"m^2"                                   ,"Width dependence of STK2EDGE" )
`MPRnb( PSTK2EDGE         ,0.0                                      ,"m^3"                                   ,"Area dependence of STK2EDGE" )
`MPRnb( STETA0EDGE        ,0.0                                      ,"m"                                     ,"ETA0 shift related to Vth0 change" )
`MPRnb( LSTETA0EDGE       ,0.0                                      ,"m^2"                                   ,"Length dependence of STETA0EDGE" )
`MPRnb( WSTETA0EDGE       ,0.0                                      ,"m^2"                                   ,"Width dependence of STETA0EDGE" )
`MPRnb( PSTETA0EDGE       ,0.0                                      ,"m^3"                                   ,"Area dependence of STETA0EDGE" )
`MPIcc( IGCLAMP           ,1                                        ,""            ,0           ,1           ,"Model flag for Ig clamping" )
`MPRoz( LP                ,1.0e-5                                   ,"m"                                     ,"Length scaling parameter for thermal noise" )
`MPRnb( RNOIK             ,0.0                                      ,""                                      ,"Exponential coefficient for enhanced correlated thermal noise" )
`MPRoo( TNOIK             ,0.0                                      ,"1/m"         ,-inf        ,inf         ,"Empirical parameter for Leff trend of Sid at low Ids" )
`MPRcz( TNOIK2            ,0.1                                      ,"1/m"                                   ,"Empirical parameter for sensitivity of RNOIK" )
`MPRnb( K0                ,0.0                                      ,""                                      ,"Non-saturation effect parameter for strong inversion region" )
`MPRnb( LK0               ,0.0                                      ,"m"                                     ,"Length dependence of K0" )
`MPRnb( WK0               ,0.0                                      ,"m"                                     ,"Width dependence of K0" )
`MPRnb( PK0               ,0.0                                      ,"m^2"                                   ,"Area dependence of K0" )
`MPRnb( K01               ,0.0                                      ,"1/K"                                   ,"Temperature coefficient for K0" )
`MPRnb( LK01              ,0.0                                      ,"m/K"                                   ,"Length dependence of K0" )
`MPRnb( WK01              ,0.0                                      ,"m/K"                                   ,"Width dependence of K0" )
`MPRnb( PK01              ,0.0                                      ,"m^2/K"                                 ,"Area dependence of K0" )
`MPRnb( M0                ,1.0                                      ,""                                      ,"offset of non-saturation effect parameter for strong inversion region" )
`MPRnb( LM0               ,0.0                                      ,"m"                                     ,"Length dependence of M0" )
`MPRnb( WM0               ,0.0                                      ,"m"                                     ,"Width dependence of M0" )
`MPRnb( PM0               ,0.0                                      ,"m^2"                                   ,"Area dependence of M0" )
`MPRnb( M01               ,0.0                                      ,"1/K"                                   ,"Temperature coefficient for M0" )
`MPRnb( LM01              ,0.0                                      ,"m/K"                                   ,"Length dependence of M01" )
`MPRnb( WM01              ,0.0                                      ,"m/K"                                   ,"Width dependence of M01" )
`MPRnb( PM01              ,0.0                                      ,"m^2/K"                                 ,"Area dependence of M01" )

// Flicker noise model parameter for EDGE FET transistor
`MPRoz( NEDGE             ,1                                        ,""                                      ,"Flicker noise parameter for edge fet transistor" )
`MPRcz( NOIA1_EDGE        ,0.0                                      ,""                                      ,"Flicker noise fitting parameter in strong inversion for edge fet transistor" )
`MPRoz( NOIAX_EDGE        ,1.0                                      ,""                                      ,"Flicker noise fitting parameter in strong inversion for edge fet transistor" )

// Flicker noise model parameter for Halo transistor
`MPIcc( FNOIMOD           ,0                                        ,""            ,0           ,1           ,"Flicker noise model selector" )
`MPRoz( LH                ,1.0e-8                                   ,"m"                                     ,"Length of halo transistor" )
`MPRnb( NOIA2             ,NOIA                                     ,"s^(1-EF)/(eV)^1/m^3"                   ,"Flicker noise parameter A for Halo" )
`MPRoz( HNDEP             ,NDEP                                     ,"1/m^3"                                 ,"Halo doping concentration for I-V" )

// To enhance the fitting flexibility for the gm/Id
`MPRnb( C0                ,0.0                                      ,"V"                                     ,"Lateral NUD1 voltage parameter" )
`MPRnb( LC0               ,0.0                                      ,"V*m"                                   ,"Length dependence of C0" )
`MPRnb( WC0               ,0.0                                      ,"V*m"                                   ,"Width dependence of C0" )
`MPRnb( PC0               ,0.0                                      ,"V*m^2"                                 ,"Area dependence of C0" )
`MPRnb( C01               ,0.0                                      ,"1/K"                                   ,"Temperature dependence of lateral NUD1 voltage parameter" )
`MPRnb( LC01              ,0.0                                      ,"m/K"                                   ,"Length dependence of C01" )
`MPRnb( WC01              ,0.0                                      ,"m/K"                                   ,"Width dependence of C01" )
`MPRnb( PC01              ,0.0                                      ,"m^2/K"                                 ,"Area dependence of C01" )
`MPRnb( C0SI              ,1.0                                      ,"V"                                     ,"Correction factor for strong inversion used in Mnud1. After binning it should be within (0 : inf)" )
`MPRnb( LC0SI             ,0.0                                      ,"V*m"                                   ,"Length dependence of C0SI" )
`MPRnb( WC0SI             ,0.0                                      ,"V*m"                                   ,"Width dependence of C0SI" )
`MPRnb( PC0SI             ,0.0                                      ,"V*m^2"                                 ,"Area dependence of C0SI" )
`MPRnb( C0SI1             ,0.0                                      ,"1/K"                                   ,"Temperature dependence of C0SI1" )
`MPRnb( LC0SI1            ,0.0                                      ,"m/K"                                   ,"Length dependence of C0SI1" )
`MPRnb( WC0SI1            ,0.0                                      ,"m/K"                                   ,"Width dependence of C0SI1" )
`MPRnb( PC0SI1            ,0.0                                      ,"m^2/K"                                 ,"Area dependence of C0SI1" )
`MPRnb( C0SISAT           ,0.0                                      ,"V"                                     ,"Correction factor for strong inversion used in Mnud1" )
`MPRnb( LC0SISAT          ,0.0                                      ,"V*m"                                   ,"Length dependence of C0SISAT" )
`MPRnb( WC0SISAT          ,0.0                                      ,"V*m"                                   ,"Width dependence of C0SISAT" )
`MPRnb( PC0SISAT          ,0.0                                      ,"V*m^2"                                 ,"Area dependence of C0SISAT" )
`MPRnb( C0SISAT1          ,0.0                                      ,"1/K"                                   ,"Temperature dependence of C0SISAT1" )
`MPRnb( LC0SISAT1         ,0.0                                      ,"m/K"                                   ,"Length dependence of C0SISAT1" )
`MPRnb( WC0SISAT1         ,0.0                                      ,"m/K"                                   ,"Width dependence of C0SISAT1" )
`MPRnb( PC0SISAT1         ,0.0                                      ,"m^2/K"                                 ,"Area dependence of C0SISAT1" )

// Minimum resistance value
`MPRcz( minr              ,$simparam("minr", 1m)                    ,"Ohm"                                   ,"minr is the value below which the simulator expects elimination of source/drain resistance and it will improve simulation efficiency without significantly altering the results.")

// Flexibility of tuning Cgg in strong inversion
`MPRco( ABULK             ,1.0                                      ,""            ,1.0         ,2.0         ,"For flexibility of tuning Cgg in strong inversion" )

// AbulkIV and AbulkCV parameters //
`MPRnb( A0                ,0.0                                      ,""                                      ,"Coefficient of depletion width dependence in AbulkIV for Id-Vd flexibility" )
`MPRnb( AGS               ,0.0                                      ,""                                      ,"Coefficient of Source Charge dependence in AbulkIV for Id-Vd flexibility" )
`MPRoz( AGS1              ,1.0                                      ,""                                      ,"qs nonlinear term for Id-Vd flexibility" )
`MPRcz( KETA              ,0.0                                      ,""                                      ,"Coefficient of back-bias dependence in AbulkIV for Id-Vd flexibility" )
`MPRnb( A0CV              ,A0                                       ,""                                      ,"Coefficient of depletion width dependence in AbulkCV for Capacitance flexibility" )
`MPRnb( AGSCV             ,AGS                                      ,""                                      ,"Coefficient of Source Charge dependence in AbulkCV for Capacitance flexibility" )
`MPRcz( KETACV            ,KETA                                     ,""                                      ,"Coefficient of back-bias dependence in AbulkCV for Capacitance flexibility" )

//Body contact resistance
`MPRnb( RBODY             ,0.0                                      ,"ohm/square"                            ,"Intrinsic body contact sheet resistance" )
`IPRnb( FRBODY            ,1.0                                      ,""                                      ,"layout dependent body-resistance coefficient" )
`MPRnb( RBSH              ,0.0                                      ,"ohm/square"                            ,"Extrinsic body contact sheet resistance" )
`IPRnb( NRB               ,1.0                                      ,""                                      ,"Number of squares in body" )
`MPRnb( RHALO             ,1e15                                     ,"ohm/m"                                 ,"body halo sheet resistance" )

`MPRnb( UB                ,67.0e-3                                  ,"m^2/V/s"                               ,"Mobility of majority carriers in body." )
`MPRnb( LUB               ,0.0                                      ,"m^3/V/s"                               ,"Length dependence of UB" )
`MPRnb( WUB               ,0.0                                      ,"m^3/V/s"                               ,"Width dependence of UB" )
`MPRnb( PUB               ,0.0                                      ,"m^4/V/s"                               ,"Area dependence of UB" )

`MPRnb( UBTE              ,1.0                                      ,""                                      ,"Mobility temperature exponent" )
`MPRnb( LUBTE             ,0.0                                      ,"m"                                     ,"Length dependence of UBTE" )
`MPRnb( WUBTE             ,0.0                                      ,"m"                                     ,"Width dependence of UBTE" )
`MPRnb( PUBTE             ,0.0                                      ,"m^2"                                   ,"Area dependence of UBTE" )

`MPRnb( NEFF              ,5e24                                     ,"1/m^3"                                 ,"Effective substrate doping" )
`MPRnb( LNEFF             ,0.0                                      ,"1/m^2"                                 ,"Length dependence of NEFF" )
`MPRnb( WNEFF             ,0.0                                      ,"1/m^2"                                 ,"Width dependence of NEFF" )
`MPRnb( PNEFF             ,0.0                                      ,"1/m"                                   ,"Area dependence of NEFF" )

`IPRoo( NSEG              ,1                                        ,""            ,0            ,inf        ,"Number segments for width partitioning" )

`MPRnb( RBODYAGBCP2       ,1e-3                                     ,"ohm"                                   ,"Body resistance for AGBCP2 FET" )

//Change in effective width due to body contact
`IPRnb( NBC               ,0.0                                      ,""                                      ,"Number of body contact isolation edge 1 = TBODY, 2 = HBODY" )
`MPRnb( DWBC              ,0.0                                      ,"m"                                     ,"Width offset for body contact isolation edge" )

//Body contact parasitics
`IPRnb( PDBCP             ,0.0                                      ,"m"   `LS                               ,"Perimeter length for bc parasitics at drain side" )
`IPRnb( PSBCP             ,0.0                                      ,"m"   `LS                               ,"Perimeter length for bc parasitics at source side" )
`IPRnb( AGBCP             ,0.0                                      ,"m^2" `QS                               ,"Gate to body overlap area for bc parasitics" )
`IPRnb( AGBCP2            ,2e-12                                    ,"m^2" `QS                               ,"Parasitic Gate to body overlap area for bc parasitics /* v4.1 improvement on BC" )
`IPRnb( AGBCPD            ,AGBCP                                    ,"m^2" `QS                               ,"Gate to body overlap area for bc parasitics in DC" )
`IPRnb( AEBCP             ,0.0                                      ,"m^2" `QS                               ,"Substrate to body overlap area for bc parasitics" )
`MPRnb( EGGBCP2           ,1.12                                     ,"eV"                                    ,"Bandgap in Agbcp2 region" )

//Substrate (back gate)
`MPRnb( NSUB              ,6.0e22                                   ,"m^-3"                                  ,"Substrate doping concentration with polarity" )
`MPRnb( LNSUB             ,0.0                                      ,"m^-2"                                  ,"Length dependence of nsub" )
`MPRnb( WNSUB             ,0.0                                      ,"m^-2"                                  ,"Width dependence of nsub" )
`MPRnb( PNSUB             ,0.0                                      ,"m^-1"                                  ,"Cross-term dependence of nsub" )
`MPRnb( FBODY             ,1.0                                      ,""                                      ,"Scaling factor for body charge" )

`MPRnb( KB1               ,1.0                                      ,""                                      ,"Scaling factor for backgate charge" )
`MPRnb( LKB1              ,0.0                                      ,"m"                                     ,"Length dependence of kb1" )
`MPRnb( WKB1              ,0.0                                      ,"m"                                     ,"Width dependence of kb1" )
`MPRnb( PKB1              ,0.0                                      ,"m^2"                                   ,"Cross-term dependence of kb1" )
`MPRnb( DLBG              ,0.0                                      ,"m"                                     ,"Length offset fitting parameter for backgate charge" )
`MPRnb( DLCB              ,0.0                                      ,"m"                                     ,"Length offset fitting parameter for body charge" )

//Sidewall Fringing Capacitance
`MPRnb( CSDESW            ,0.0                                      ,"F/m"                                   ,"Source/drain sidewall fringing capacitance per unit length" )

//Extrinsic Bottom S/D to Substrate Charge
`MPRnb( CSDMIN            ,0.0                                      ,"V"                                     ,"Source/drain bottom diffusion minimum capacitance" )
`MPRoo( ACESB             ,2.0                                      ,""            ,0.0         ,inf         ,"First fitting parameter for drain to bottom capacitance" )
`MPRnb( BCESB             ,0.0                                      ,"V"                                     ,"Second fitting parameter for drain to bottom capacitance" )
`MPRoo( ACEDB             ,ACESB                                    ,""            ,0.0         ,inf         ,"First fitting parameter for drain to bottom capacitance" )
`MPRnb( BCEDB             ,BCESB                                    ,"V"                                     ,"Second fitting parameter for drain to bottom capacitance" )

//Switch to eliminate hump in gm
`MPIcc( GMCMOD            ,0                                        ,""            ,0           ,1           ,"Switch for changing the core model to avoid gm-hump. 0: turns off the modification, 1: turns on the modification for avoiding gm hump issue" )

// Convenience instance parameters
`IPRcz( MULT_I            ,1.0                                      ,""                                      ,"Variability in current" )
`IPRcz( MULT_Q            ,1.0                                      ,""                                      ,"Variability in charge" )
`IPRcz( MULT_FN           ,MULT_I                                   ,""                                      ,"Variability in flicker noise" )
`MPRnb( GMVD              ,1.0                                      ,""                                      ,"Additional fitting parameter for GMCMOD=1" )
`MPRoo( LNDEPCV1          ,1.0                                      ,""            ,0.0          ,inf        ,"Additional fitting parameter for GMCMOD=1" )

// Common Variables for DD-MODEL
real nu, mutau, RT, RC, phic_star, CB, phic_s, CBOX, u_crit;
real sp_dd, SP_S_yg, SP_S_ysub, SP_S_eta, SP_S_temp, SP_S_a, SP_S_b, SP_S_c, SP_S_tau, SP_S_y0, fx, f_x, f_xx, x7_s, x7_d, PHIC;
real QI, Fj, Fj2;
real SP_S_delta0, SP_S_delta1, SP_S_xi0, SP_S_xi1, SP_S_xi2, SP_S_temp1, SP_S_temp2, SP_S_tempc;
real SP_S_pC, SP_S_qC;
real SP_xg1, SP_S_A_fac, SP_S_xbar, SP_S_w, SP_S_x1, SP_S_bx, SP_S_x0, sp_vfb;
real phisb0, zeta, zeta2, tau_fd;
//
real Vdsat_lim, xgm, Voxm, delta_1s, tempc, xi0s, Es1, Ds, Ps, sqms, sqd, xgs, x_ds, Udse, k_ds, pC, qC, xi0d;
real Ed, Dd, Pd, sqm, xgd, qid, alpha_DD, x_m, Em, D_bar, Dm, Pm, qim, qim1, qbm, alpha1, H_fact;
// PDE effect, DD model
real pdef, d0, eta_p, x_pm, p_pd, q_pd, xi_pd, u_pd, km, km0;
//
real x1, inv_x1, phisf, phisf_smooth, phidf, exp_ns, exp_ns_smooth, exp_nd, limit, limit1, K11, vg_FD, usf_FD, SP_S_Z0, a_fd , c_fd, c_fd2, d_fd ;
real v_fd, v_fd2, mu_fd, temp1_fd, temp2_fd, u_first_r, u0_first_FD, delta0_fd;
real p_fd, q_fd, temp3_fd, w_fd;
real xs;
// Variables for DD back bias solved independently for PD case
real gam_sb, x1_sb, limit_sb, x1_csb, inv_xi_sb, gam_sb2, inv_xg1_sb;
real pd_sb, PD_yg, PD_z,PD_eta,PD_a, PD_q, PD_c, PD_tau, PD_u;
real PD_y0, PD_D0, PD_temp, PD_p, PD_xi, PD_w;
real PD_Afac, PD_xbar, PD_x0, PD_w1, PD_temp1, PD_D01, PD_p1, PD_q1, PD_xi1;

// Common variables PDMODEL
real PSiso, PDiso, PSsha, PDsha, PSmer, PDmer, ASiso, ADiso, ASsha, ADsha, ASmer, ADmer;
real T0, T1, T2, T3, T4, T5, T6, T7, T8, T9, T10, T11, T12;
real epssi, epsox, ni, Weff, Leff, Weff1, Leff1, Wact, Lact, Weffcj, Eg, Weff_SH;
real dLIV, dWIV, dLB, dWB, dLCV, dWCV, dWJ, Cox, epsratio;
real Vdb_noswap, Vsb_noswap, Vgs_noswap, Vgd_noswap, Vds_noswap;
real Vgs_noswap_1, Vgd_noswap_1;
real Vgb, Vgp_eff, Ig_agbcp2;
real sigvds, vfb, vgfb, vgfb1, vfbb, vgfbb, vgfbCV, Vbsx, Vfbsdr, Vesx;
real Vg, vg, Vd, Vs, vs, Vds, Vdsx, Vgs_eff, Vgd_eff, Vg1, vg1, Vs1, vs1;
real Ve, Ves, ves, ved, ve, Ve1, ve1, Vbsx1;
real Vth_shift;
real qia, qba, qiaCV, qbaCV, qbs, qbd, qb, dps, phib, phib_n;
real nq, psip, psiavg, psipclamp, sqrtpsisa, sqrtpsisainv, sqrtpsip;
real Cdep, Lnew, L_mult, Wnew, W_mult;
real wf, wr;

// Short channel effects
real n, Fp, nVt, inv_nVt, Vt, inv_Vt;
real PhistVbs, sqrtPhistVbs, Xdep, cdsc;
real T1DEP;
real dVth_ldop, DVTP0_i, DVTP0EDGE_i, DVTP1_i, DVTP1EDGE_i, DVTP2_i, DVTP2EDGE_i, DVTP3_i, DVTP3EDGE_i, DVTP4_i, DVTP4EDGE_i, DVTP5_i, DVTP5EDGE_i;
real dVth_VNUD, dVth_dibl, dvth_temp;
real gam, inv_gam, gam2, inv_gam2, Phist, sqrtPhist, litl;
real sclf, scl, sclm, teff, tmp;

// Drain saturation voltage
real qis, qdsat, Eeffs, Dmobs, Esat, EsatL, Vdsat, LambdaC_by2, LambdaC;
real Vdseff, Vdssat, VdssatCV, vdeff, vdsat, qdeff, vdsatcv, VdsatCV;
real ln_T1_T2, WVCox, Ta, Tb, Tc;
real A1_i, A11_i, A1_t, A2_i, A21_i, A2_t, Nsat;

// Mobility degradation
real EeffFactor, Eeffm, ueff, eta_mu, Dmob, Dtot, Dmob_dL;

// Velocity saturation
real zsat, Dvsat, Dvsatinv, Dptwg, PSAT_i, PSATCV_i, PSATR_i, PSAT_a, zetasb, wsat, thesat1, inv_VP, dL, DdL;

// Output conductance
real diffVds, VaDITS, VaSCBE, Vasat;
real DIBLfactor, PVAGfactor, VaDIBL, Vgst2Vtm, Moc, MdL, Mscbe, QCLM;

// Impact ionization and GIDL
real vgsfb, VgsStep, Vdsatii, Vdsatii0, Vdiff, Ratio;
real Iii, igidl, igisl;
real Idsmosfet, Iiibjt, Vbc;

// I-V variables
integer devsign;
real ids;

// C-V variables
real Qb, Qs, Qd1, Qd2, Qd, Qi, QBi, QSi, QDi, QGi, WLCOXVtinv, QGim, QBim, QDim, QSim, QGiagbcp2, QBiagbcp2, QDiagbcp2, QSiagbcp2;
real qs, qbeff, dqgeff;
real DPD, vgfbPD, gammaPD, gamg2;
real MdL_2, inv_MdL, inv_MdL_2, MdL_less_1;
real sis, sid, vgpqm, Temps, Tempd, DQSD, DQSD2, invgamg2;
real Vgsov, Vgdov, Qovb, Qovg, Qovs, Qovd, Cgsof, Cgdof;
real XDCinv, Coxeffinv, BSIMBULKTOXP;
real Vgd_ov_noswap, Vgs_ov_noswap;
real phibCV, gamCV;
real QG_1, QS_1, QD_1, QB_1, QSI_1, QDI_1;

real vgfbAGBCP2, phibAGBCP2, gamAGBCP2;
real WLCOX, Qi_AGBCP2, QDi_AGBCP2, QBi_AGBCP2, QSi_AGBCP2, QGi_AGBCP2, Qi_AGBCP3, QDi_AGBCP3, QBi_AGBCP3, QSi_AGBCP3, QGi_AGBCP3;
// S/D series resistances
real WeffWRFactor, DMCGeff, DMDGeff, DMCIeff;
real RSourceGeo, RDrainGeo, Rsource, Rdrain, Rdss, Rdsi, Dr;

// S/D junction area and perimeters
real temp_ASeff, temp_ADeff, temp_PSeff, temp_PDeff;
real ASeff, ADeff;

// Gate resistances
real Grgeltd, Rgeltd, Gcrg, idsovvds;

// Gate currents
real Voxm1, Voxminv, Voxmacc, Vdseffx;
real Vaux_Igbinv, Vaux_Igbacc, igbinv, igbacc, igb;
real Vfb2;
real igcs, igcd, igc0, T1_exp;
real igs, igd, igs_mult, igd_mult;
real Aechvb, Bechvb, AechvbEdges, AechvbEdged, BechvbEdge, ToxRatio, ToxRatioEdge;

// Junction currents and capacitances
real PSeff, PDeff;
real Ibs, Ibd, Vbs_jct, Vbd_jct, arg, sarg;
real Czbs, czbs_p1, czbs_p2, Czbssw, czbssw_p1, czbssw_p2, Czbsswg, czbsswg_p1, czbsswg_p2;
real Czbd, czbd_p1, czbd_p2, Czbdsw, czbdsw_p1, czbdsw_p2, Czbdswg, czbdswg_p1, czbdswg_p2;
real Qbsj, Qbsj1, Qbsj2, Qbsj3, Qbsj4;
real Qbdj, Qbdj1, Qbdj2, Qbdj3, Qbdj4;

real NDIF_i, lratiodif, Iendif, Ibsdif, Ibddif;

//Diode and BJT Current --- As per SOI
real Ibs1, Ibd1, Ibs2, Ibd2, Ibs3, Ibd3, Ibs4, Ibd4;
real wdios, wdiod, WsTsi, WdTsi;
real XDIF_i,JDIFS, JDIFD, ISDIF_i, IDDIF_i;
real ISREC_i, IDREC_i;
real JRECS, JRECD, XREC_i, NRECF0_i;
real VREC0_i, VREC0D_i;
real wdiodCV, wdiosCV;
real NVtmf, NVtmr;
real NRECR0_i,NTRECF_i, NTRECR_i;
real ISTUN_i, IDTUN_i;
real XTUN_i, XTUND_i, JTUNS, JTUND, NTUN_i, NTUND_i;
real VTUN0_i, VTUN0D_i;
real JBJTD, JBJTS;

real Ic;
real Vearly;
real VABJT_i, AELY_i;
real Ehlis, Ehlid;
real Ahlis, Ahlid, AHLI_i, AHLID_i;
real XBJT_i;
real NDIODE_i;
real EhlisFactor, EhlidFactor;
real NVtm1, NVtm2, ExpVbsNVtm, ExpVbdNVtm;
real IDBJT_i, ISBJT_i, lratio;
real NBJT_i, LBJT0_i, WTsi, ALPHABJT, Ien, E2ndFactor;

// Flicker noise
real LINTNOI_i;
real Esatnoi, Leffnoi, Leffnoisq, DelClm;
real N0, Nl, Nstar, Ssi, Swi, FNPowerAt1Hz;

// Thermal noise
real gspr, gdpr;
real Gtnoi, sidn, Nt;
real mig, migid, mid, Lvsat, Vtn;
real cm_igid, sqid, sqig, ctnoi, betanoisq, thetanoisq, betaLowId;

// Temperature effects
real delTemp1;
real DevTemp, Tnom, Vtm, Vtm0;
real TRatio, delTemp;
real U0_t, U0R_t, UA_t, UAR_t, UC_t, UCR_t, UD_t, UDB_t, UDB_a, UDBR_t, UDR_t, UCS_t, UCSR_t, EU_t, rdstemp, VSAT_t, VSATR_t, VSATCV_t;
real DELTA_t, PTWG_t, PTWGR_t, BETA0_t, BGIDL_t, BGISL_t;
real igtemp;
real ETA0_t, ETA0R_t, NFACTOR_t;

//Diode temperature effects
real CJS_t, CJSWS_t, CJSWGD_t, CJD_t, CJSWD_t, CJSWGS_t;
real PBS_t, PBSWS_t, PBSWGS_t, PBD_t, PBSWD_t, PBSWGD_t;

// Binning
real PSATB_i, PSATE_i, PSATBCV_i, PSATECV_i;
real KT1_i, KT2_i;
real W_by_NF;
real L_LLN, W_LWN, LW_LLN_LWN, L_LLN1, W_LWN1, LW_LLN_LWN1;
real L_WLN, W_WWN, LW_WLN_WWN, L_WLN1, W_WWN1, LW_WLN_WWN1;
real Inv_L, Inv_W, Inv_WL, Inv_Lact, Inv_Wact, Inv_Llong, Inv_Wwide;
real BIN_L, BIN_W, BIN_WL;
real NGATE_i, NSD_i, NDEP_i, VFB_i, VFBB_i;
real CIT_i, CDSCD_i, CSECSE_i, CSECSEEDGE_i, CBCB_i, CDSC_i, CDSCEDGE_i, CBCBEDGE_i, CDSCDR_i, CDSCD_a, CDSCB_i, NFACTOR_i, ASCL_i, BSCL_i, DVT1_i, VSCE_i, DVBD0_i, DVBD1_i, CDSBS1_i, CDSBS_i;
real PHIN_i, ETA0_i, ETA0R_i, ETA0_a, ETAB_i, K2_i, K1_i, K1EDGE_i;
real DELTA_i;
real U0_i, U0R_i, U0_a, VSAT_i, KSATIV_i, KSATCV_i, LPE1_i, THESAT_i, THESATCV_i, VSATR_i, VSAT_a, VSATCV_i, UA_i, UAR_i, UA_a, EU_i, UD_i, UDB_i, UDB1_i, UDR_i, UDBR_i, UD_a, UCS_i, UCSR_i, UCS_a, UC_i, UCR_i, UC_a;
real PDIBLC_i, PDIBLCR_i, PDIBLC_a, PDIBLCB_i, PSCBE1_i, PSCBE2_i, PDITS_i, PDITSD_i, FPROUT_i;
real PRWG_i, WR_i, RDWMIN_i, RSWMIN_i, RDW_i, RSW_i, RDSW_i, RDSWMIN_i;
real PTWG_i, PTWGR_i, PTWG_a, PVAG_i, XJ_i;
real PCLM_i, PCLMR_i, PCLM_a, PCLMCV_i, PRWB_i;
real CF_i, CGSL_i, CGDL_i, CKAPPAS_i, CKAPPAD_i;
real VFBCV_i, NDEPCV_i, VFBBCV_i;
real VFBAGBCP2_i;

real UTE_i, UA1_i, UC1_i, UD1_i, UCSTE_i, PRT_i, AT_i, PTWGT_i, IIT_i, EU1_i;
real KVTH0WE_i, K2WE_i, KU0WE_i;
real EIGBINV_i;
real AIGC_i, BIGC_i, CIGC_i;
real AIGC1_i, AIGS1_i, AIGD1_i;
real AIGS_i, BIGS_i, CIGS_i, AIGD_i, BIGD_i, CIGD_i, POXEDGE_i, PIGCD_i;
real DLCIG_i, DLCIGD_i, NTOX_i;
real IGT_i;
real K0_i, M0_i;
real K01_i, M01_i;
real K0_t, M0_t;
real Mnud;
real NFACTOREDGE_i, CITEDGE_i, CDSCDEDGE_i, CDSCDEDGE_a, CDSCDEDGER_i, CDSCBEDGE_i, ETA0EDGE_i, ETABEDGE_i, KT1EDGE_i, KT1LEDGE_i, KT2EDGE_i, KT1EXPEDGE_i, TNFACTOREDGE_i, TETA0EDGE_i, K2EDGE_i, KVTH0EDGE_i, STK2EDGE_i, STETA0EDGE_i;
real Mnud1;
real K2EDGEWE_i, KVTH0EDGEWE_i;
real C0_i, C01_i, C0_t;
real C0SI_i, C0SI1_i, C0SI_t;
real C0SISAT_i, C0SISAT1_i, C0SISAT_t;

//IMPACT IONIZATION MODEL Variables
real ALPHA0_i, BETA0_i, BETA1_i, BETA2_i;
real LII_i, SII0_i, SII1_i, SII2_i, SIID_i;
real VDSATII0_i;
real ESATII_i;
real FBJTII_i;
real EBJTII_i, CBJTII_i, ABJTII_i, VBCI_i, MBJTII_i;

real ALPHAGB2_i, BETAGB2_i;
real ALPHAGB1_i, BETAGB1_i;
real ALPHAGB1_T_i, ALPHAGB2_T_i;

real AIGBCP2_i, BIGBCP2_i, CIGBCP2_i;
real AIGBCP2_T_i;

real AGIDL_i, BGIDL_i, CGIDL_i, EGIDL_i;
real AGISL_i, BGISL_i, CGISL_i, EGISL_i;
real BGIDL1_i, BGISL1_i;

real RGIDL_i, KGIDL_i, FGIDL_i;
real RGISL_i, KGISL_i, FGISL_i;

//Substrate (back gate)
real NSUB_i, KB1_i;

// Stress effects
real W_tmp_stress, tmp1_stress, kstress_u0, tmp1_stress_vth, kstress_vth0, ku0_temp;
real Inv_sa, Inv_sb, Inv_saref, Inv_sbref, Inv_odref, rho_ref, Inv_od,rho;
real mu0_mult, vsat_mult, vth0_stress, k2_stress, eta_stress;
integer i;

// Well proximity effects
real vth0_well, k2_well, vth0_well_edge, k2_well_edge, mu_well, Wdrn, local_sca, local_scb, local_scc;

// Edge FET Model Variables
real ids_edge, ETA0EDGE_t, NFACTOREDGE_t, Vbi_edge, theta_sce_edge, dvth_dibl, dvth_sce, litl_edge, DGAMMAEDGE_i, vdsatedge, Vdsatedge, Vdssate, phib_edge, phib_n_edge, NDEPEDGE_i, gam_edge, Theta_SCE;
real vth0_stress_EDGE, k2_stress_EDGE, eta_stress_EDGE;

// 1/f noise model for Edge FET
real nq_edge, qdeff_edge, qs_edge, Leffnoi_edge, Leffnoisq_edge, noia_edge, noib_edge, noic_edge, FNPowerAtedge;

// Below are used by macros by GEOMOD and RGEOMOD
real nuIntD, nuEndD, nuIntS, nuEndS;
real Rint, Rend;

// Sub-surface punchthrough
real Issl, SSL0_NT, SSL1_NT, PHIB_SSL;

// VTH variables
real q_vth, psip_th;

// 1/f noise model for halo
real vgfbh, gam_h, phib_h, psiph, psiphclamp, qsh, nq_h, U0_i_h, i1, qdh, i2, qsch;
real Np2, beta_ch, beta_h, gds_h, gds_ch, gm_ch, R_ch, R_h, Ssi_ch;
real Swi_ch, FNPowerAt1Hz_ch, FNPowerAt1Hz_h;
real T0a, T0b, T0c, T0d, T0e, Swi_h, t_tot, CF_ch, CF_h, LeffnoiH, LH1;

// Self heating
real gth, cth, Pdiss;

// gmin is placed in parallel with drain-bulk and source-bulk diode to increase the numerical convergence
real gmin;

// Abulk variables
real AbulkIV, AbulkCV;

//Body contact resistance
real gbody, gbodyagbcp2, gbodyINT;
real RBODYEXT, RBODYINT;
real QB1;
real UB_t, UB_i, UBTE_i;
real NEFF_i, Qbody;

//Backgate
real Vesfb, Vbs;
real Cbox;
real LeffCVb, LeffCVbg, CboxWL;
real Qe1, Qsub;

//Sidewall Fringing Capacitance
real csesw, cdesw;

//Bottom S/D Capacitance
real csbox, csmin, cdbox, cdmin;
real qse, qde;

//   Kb/q (Joule/degree)
real KboQ;

// GMCMOD=1 variable
real gmesp, sp_dd1;

// New variables in 100.2.0beta01
real x7_sb, x7_db, ebs, ebd, ebm, XGL_d, LH_d, DLBIN_d, DWBIN_d, NDEPAGBCP2_d;

// Operating-point variables
`OPM( QBI,          "C",     "Intrinsic body charge" )
`OPM( QSI,          "C",     "Intrinsic source charge" )
`OPM( QSIM,         "C",     "Intrinsic source charge" )
`OPM( QSIAGBCP2,    "C",     "AGBCP2 source charge" )
`OPM( QDI,          "C",     "Intrinsic drain charge" )
`OPM( QDIM,         "C",     "Intrinsic drain charge" )
`OPM( QDIAGBCP2,    "C",     "AGBCP2 drain charge" )
`OPM( QGI,          "C",     "Intrinsic gate charge" )
`OPM( QGIM,         "C",     "Intrinsic gate charge" )
`OPM( QGIAGBCP2,    "C",     "AGBCP2 gate charge" )
`OPM( CGGI,         "F",     "Intrinsic gate capacitance" )
`OPM( CGBI,         "F",     "Intrinsic gate-to-body capacitance" )
`OPM( CGSI,         "F",     "Intrinsic gate-to-source capacitance" )
`OPM( CGDI,         "F",     "Intrinsic gate-to-drain capacitance" )
`OPM( CSGI,         "F",     "Intrinsic source-to-gate capacitance" )
`OPM( CSBI,         "F",     "Intrinsic source-to-body capacitance" )
`OPM( CSSI,         "F",     "Intrinsic source capacitance" )
`OPM( CSDI,         "F",     "Intrinsic source-to-drain capacitance" )
`OPM( CDGI,         "F",     "Intrinsic drain-to-gate capacitance" )
`OPM( CDBI,         "F",     "Intrinsic drain-to-body capacitance" )
`OPM( CDSI,         "F",     "Intrinsic drain-to-source capacitance" )
`OPM( CDDI,         "F",     "Intrinsic drain capacitance" )
`OPM( CBGI,         "F",     "Intrinsic body-to-gate capacitance" )
`OPM( CBBI,         "F",     "Intrinsic body capacitance" )
`OPM( CBSI,         "F",     "Intrinsic body-to-source capacitance" )
`OPM( CBDI,         "F",     "Intrinsic body-to-drain capacitance" )
`OPM( QB,           "C",     "Body charge" )
`OPM( QS,           "C",     "Source charge" )
`OPM( QD,           "C",     "Drain charge" )
`OPM( QG,           "C",     "Gate charge" )
`OPM( CGG,          "F",     "Total gate capacitance" )
`OPM( CGB,          "F",     "Total gate-to-body capacitance" )
`OPM( CGS,          "F",     "Total gate-to-source capacitance" )
`OPM( CGD,          "F",     "Total gate-to-drain capacitance" )
`OPM( CSG,          "F",     "Total source-to-gate capacitance" )
`OPM( CSB,          "F",     "Total source-to-body capacitance" )
`OPM( CSS,          "F",     "Total source capacitance" )
`OPM( CSD,          "F",     "Total source-to-drain capacitance" )
`OPM( CDG,          "F",     "Total drain-to-gate capacitance" )
`OPM( CDB,          "F",     "Total drain-to-body capacitance" )
`OPM( CDS,          "F",     "Total drain-to-source capacitance" )
`OPM( CDD,          "F",     "Total drain capacitance" )
`OPM( CBG,          "F",     "Total body-to-gate capacitance" )
`OPM( CBB,          "F",     "Total body capacitance" )
`OPM( CBS,          "F",     "Total body-to-source capacitance" )
`OPM( CBD,          "F",     "Total body-to-drain capacitance" )
`OPM( ISUB,         "A",     "Substrate current" )
`OPM( IGIDL,        "A",     "" )
`OPM( IGISL,        "A",     "" )
`OPM( IGS,          "A",     "" )
`OPM( IGD,          "A",     "" )
`OPM( IGCS,         "A",     "" )
`OPM( IGCD,         "A",     "" )
`OPM( IGB,          "A",     "" )
`OPM( CGSEXT,       "F",     "" )
`OPM( CGDEXT,       "F",     "" )
`OPM( CGBOV,        "F",     "Front gate charge" )
`OPM( CAPBS,        "F",     "" )
`OPM( CAPBD,        "F",     "" )
`OPP( WEFF,         "m",     "" )
`OPP( LEFF,         "m",     "" )
`OPP( WEFFCV,       "m",     "" )
`OPP( LEFFCV,       "m",     "" )
`OPM( IDS,          "A",     "Drain-source current" )
`OPM( IDEFF,        "A",     "Effective drain current" )
`OPM( ISEFF,        "A",     "Effective source current" )
`OPM( IGEFF,        "A",     "Effective gate current" )
`OPM( IBS,          "A",     "" )
`OPM( IBD,          "A",     "" )
`OPP( VDS,          "V",     "Drain-to-source voltage" )
`OPP( VGS,          "V",     "Gate-to-source voltage" )
`OPP( VBS,          "V",     "Body-to-source voltage" )
`OPP( VDSAT,        "V",     "" )
`OPM( GM,           "mho",   "" )
`OPM( GMBS,         "mho",   "" )
`OPM( GDS,          "mho",   "" )
`OPP( T_TOTAL_K,    "K",     "" )
`OPP( T_TOTAL_C,    "deg-C", "" )
`OPP( T_DELTA_SH,   "K",     "" )
`OPP( VTH,          "V",     "Threshold voltage" )

analog begin
    // Variable initialization to prevent hidden states
    sp_vfb           = 0.0;
    SP_S_xbar        = 0.0;
    Ig_agbcp2        = 0.0;
    psip             = 0.0;
    inv_gam          = 0.0;
    Vdssat           = 0.0;
    Iii              = 0.0;
    Vfb2             = 0.0;
    gbody            = 0.0;
    CDSCDEDGER_i     = 0.0;
    CDSCDR_i         = 0.0;
    L_WLN1           = 0.0;
    PTWGR_i          = 0.0;
    UAR_i            = 0.0;
    UCSR_i           = 0.0;
    UD_a             = 0.0;
    W_WWN1           = 0.0;
    Inv_sa           = 0.0;
    eta_stress       = 0.0;

    M0_i             = 0.0;
    M0_t             = 0.0;
    ETA0EDGE_i       = 0.0;
    KT2EDGE_i        = 0.0;
    K2EDGE_i         = 0.0;
    Mnud1            = 0.0;
    C0SI_i           = 0.0;
    C0SISAT1_i       = 0.0;
    gmin             = $simparam("gmin",0);
    ETA0R_i          = 0.0;
    PCLMR_i          = 0.0;
    PTWGR_t          = 0.0;
    UAR_t            = 0.0;
    UCSR_t           = 0.0;
    VSATR_i          = 0.0;
    local_sca        = 0.0;
    Inv_sb           = 0.0;
    FNPowerAtedge    = 0.0;

    K01_i            = 0.0;
    CITEDGE_i        = 0.0;
    ETABEDGE_i       = 0.0;
    KT1EXPEDGE_i     = 0.0;
    KVTH0EDGE_i      = 0.0;
    C0_i             = 0.0;
    C0SI1_i          = 0.0;
    C0SISAT_t        = 0.0;
    ETA0R_t          = 0.0;
    PDIBLCR_i        = 0.0;
    U0R_i            = 0.0;
    UCR_i            = 0.0;
    UDR_i            = 0.0;
    UDBR_i           = 0.0;
    VSATR_t          = 0.0;
    local_scb        = 0.0;
    vth0_stress_EDGE = 0.0;
    eta_stress_EDGE  = 0.0;

    M01_i            = 0.0;
    CDSCDEDGE_i      = 0.0;
    KT1EDGE_i        = 0.0;
    TNFACTOREDGE_i   = 0.0;
    STK2EDGE_i       = 0.0;
    C01_i            = 0.0;
    C0SI_t           = 0.0;
    L_LLN1           = 0.0;
    PSATR_i          = 0.0;
    U0R_t            = 0.0;
    UCR_t            = 0.0;
    UDR_t            = 0.0;
    W_LWN1           = 0.0;
    local_scc        = 0.0;
    k2_stress_EDGE   = 0.0;
    K0_i             = 0.0;
    K0_t             = 0.0;
    CDSCBEDGE_i      = 0.0;
    KT1LEDGE_i       = 0.0;
    TETA0EDGE_i      = 0.0;
    STETA0EDGE_i     = 0.0;
    C0_t             = 0.0;
    C0SISAT_i        = 0.0;
    K2EDGEWE_i       = 0.0;
    KVTH0EDGEWE_i    = 0.0;
    temp_ADeff       = 0.0;
    temp_ASeff       = 0.0;
    temp_PDeff       = 0.0;
    temp_PSeff       = 0.0;
    AbulkIV          = 1.0;
    AbulkCV          = 1.0;
    gdpr             = 0.0;
    gspr             = 0.0;
    eta_p            = 1.0;
    DdL              = 0.0;
    Dmob             = 0.0;
    Dr               = 0.0;
    Dvsat            = 0.0;
    Dvsatinv         = 0.0;
    Ibddif           = 0.0;
    Ibsdif           = 0.0;
    Idsmosfet        = 0.0;
    Mnud             = 0.0;
    Moc              = 0.0;
    Mscbe            = 0.0;
    Nsat             = 0.0;
    Rdrain           = 0.0;
    Rsource          = 0.0;
    Vdseff           = 0.0;
    diffVds          = 0.0;
    dps              = 0.0;
    qia              = 0.0;
    qid              = 0.0;
    qim1             = 0.0;
    Rdsi             = 0.0;
    KboQ             =`P_K_NIST1998 / `P_Q_NIST1998;
    qdeff            = 0.0;
    qs               = 0.0;
    x7_d             = 0.0;
    x7_s             = 0.0;
    ln_T1_T2         = 0.0;
    alpha_DD         = 0.0;
    qim              = 0.0;
    H_fact           = 0.0;
    nq_edge          = 0.0;
    qdeff_edge       = 0.0;
    qs_edge          = 0.0;
    UDBR_t           = 0.0;

    // Bias-independent calculations
    if (TYPE == `ntype) begin
        devsign = 1;
    end else begin
        devsign = -1;
    end

    // Constants
    epssi    = EPSRSUB * `P_EPS0;
    epsox    = EPSROX * `P_EPS0;
    Cox      = EPSROX * `P_EPS0 / TOXE;
    epsratio = EPSRSUB / EPSROX;

    // Physical oxide thickness
    if (!$param_given(TOXP)) begin
        BSIMBULKTOXP = (TOXE * EPSROX / 3.9) - DTOX;
    end else begin
        BSIMBULKTOXP = TOXP;
    end
    L_mult = L * LMLT;
    W_mult = W * WMLT;
    Lnew = L_mult + XL;
    if (Lnew <= 0.0) begin
        $error("Fatal: Ldrawn * LMLT + XL = %e for %M is non-positive", Lnew);
    end
    W_by_NF = W_mult / NF;
    Wnew    = W_by_NF + XW;
    if (Wnew <= 0.0) begin
        $error("Fatal: W / NF * WMLT + XW = %e for %M is non-positive", Wnew);
    end

    XGL_d = XGL;
    if (XGL_d >= (L*LMLT + XL)) begin
        $error("Fatal: XGL_d = %e is too large ( >= L*LMLT + XL = %e).", XGL_d, L*LMLT + XL);
        XGL_d = 0.0;
    end

    LH_d = LH;
    if (LH_d >= L) begin
        $error("Fatal: LH_d = %e is too large ( >= L = %e).", LH_d, L);
        LH_d = 1.0e-8;
    end

    // Leff and Weff for I-V
    L_LLN      = pow(Lnew, -LLN);
    W_LWN      = pow(Wnew, -LWN);
    LW_LLN_LWN = L_LLN * W_LWN;
    dLIV       = LINT + LL * L_LLN + LW * W_LWN + LWL * LW_LLN_LWN;
    L_WLN      = pow(Lnew, -WLN);
    W_WWN      = pow(Wnew, -WWN);
    LW_WLN_WWN = L_WLN * W_WWN;
    dWIV       = WINT + WL * L_WLN + WW * W_WWN + WWL * LW_WLN_WWN;
    Leff       = Lnew - 2.0 * dLIV;
    if (Leff <= 0.0) begin
        $error("Fatal: Effective channel length = %e for  %M is non-positive", Leff);
        Leff = Lnew;
    end else if (Leff <= 1.0e-9) begin
        $strobe("Warning: Effective channel length = %e for %M is <= 1.0e-9. Recommended Leff >= 1e-8", Leff);
    end
    Weff = Wnew - NBC * DWBC - (2.0 - NBC) * dWIV;
    if (Weff <= 0.0) begin
        $error("Fatal: Effective channel Width = %e for %M is non-positive", Weff);
    end else if (Weff <= 1.0e-9) begin
        $strobe("Warning: Effective channel width = %e for %M is <= 1.0e-9. Recommended Weff >= 1e-8", Weff);
    end

    // Leff and Weff for C-V
    dLCV = DLC + LLC * L_LLN + LWC * W_LWN + LWLC * LW_LLN_LWN;
    dWCV = DWC + WLC * L_WLN + WWC * W_WWN + WWLC * LW_WLN_WWN;
    Lact = Lnew - 2.0 * dLCV;
    if (Lact <= 0.0) begin
        $error("Fatal: Effective channel length for C-V = %e for %M is non-positive", Lact);
        Lact = Lnew;
    end else if (Lact <= 1.0e-9) begin
        $strobe("Warning: Effective channel length for C-V = %e for %M is <= 1.0e-9. Recommended Lact >= 1e-8", Lact);
    end
    Wact = Wnew - NBC * DWBC - (2.0 - NBC) * dWCV;
    if (Wact <= 0.0) begin
        $error("Fatal: Effective channel width for C-V = %e for %M is non-positive", Wact);
        Wact = Wnew;
    end else if (Wact <= 1.0e-9) begin
        $strobe("Warning: Effective channel width for C-V = %e for %M is <= 1.0e-9. Recommended Wact >= 1e-8", Wact);
    end

    // Weffcj for diode, GIDL etc.
    dWJ    = DWJ + WLC / pow(Lnew, WLN) + WWC / pow(Wnew, WWN) + WWLC / pow(Lnew, WLN) / pow(Wnew, WWN);
    Weffcj = Wnew - 2.0 * dWJ;
    if (Weffcj <= 0.0) begin
        $error("Fatal: Effective channel width for S/D junctions = %e for %M is non-positive", Weffcj);
        Weffcj = Wnew;
    end
    Inv_L     = 1.0e-6 / Leff;
    Inv_W     = 1.0e-6 / Weff;
    Inv_Lact  = 1.0e-6 / Lact;
    Inv_Wact  = 1.0e-6 / Wact;
    Inv_Llong = 1.0e-6 / LLONG;
    Inv_Wwide = 1.0e-6 / WWIDE;
    Inv_WL    = Inv_L * Inv_W;

    // Effective length and width for binning
    L_LLN1 = L_LLN;
    L_WLN1 = L_WLN;
    DLBIN_d = DLBIN;
    if (DLBIN_d != 0.0) begin
        if (DLBIN_d <= -Lnew) begin
            $error("Fatal: DLBIN_d for %M = %e is <= -Ldrawn * LMLT", DLBIN_d);
            DLBIN_d = 0.0;
        end else begin
            L_LLN1 = pow(Lnew + DLBIN_d, -LLN);
            L_WLN1 = pow(Lnew + DLBIN_d, -WLN);
        end
    end
    W_LWN1 = W_LWN;
    W_WWN1 = W_WWN;
    DWBIN_d = DWBIN;
    if (DWBIN_d != 0.0) begin
        if (DWBIN_d <= -Wnew) begin
            $error("Fatal: DWBIN_d for %M = %e is <= -Wdrawn * WMLT", DWBIN_d);
            DWBIN_d = 0.0;
        end else begin
            W_LWN1 = pow(Wnew + DWBIN_d, -LWN);
            W_WWN1 = pow(Wnew + DWBIN_d, -WWN);
        end
    end
    LW_LLN_LWN1 = L_LLN1 * W_LWN1;
    dLB         = LINT + LL * L_LLN1 + LW * W_LWN1 + LWL * LW_LLN_LWN1;
    LW_WLN_WWN1 = L_WLN1 * W_WWN1;
    dWB         = WINT + WL * L_WLN1 + WW * W_WWN1 + WWL * LW_WLN_WWN1;
    Leff1 = Lnew - 2.0 * dLB + DLBIN_d;
    if (Leff1 <= 0.0) begin
        $error("Fatal: Effective channel length for binning = %e for %M is non-positive", Leff1);
        Leff1 = Lnew;
    end
    Weff1 = Wnew - 2.0 * dWB + DWBIN_d;
    if (Weff1 <= 0.0) begin
        $error("Fatal: Effective channel width for binning = %e for %M is non-positive", Weff1);
        Weff1 = Wnew;
    end
    if (BINUNIT == 1) begin
        BIN_L = 1.0e-6 / Leff1;
        BIN_W = 1.0e-6 / Weff1;
    end else begin
        BIN_L = 1.0 / Leff1;
        BIN_W = 1.0 / Weff1;
    end
    BIN_WL         = BIN_L * BIN_W;
    VFB_i          = VFB + BIN_L * LVFB + BIN_W * WVFB + BIN_WL * PVFB;
    VFBB_i         = VFBB + BIN_L * LVFBB + BIN_W * WVFBB + BIN_WL * PVFBB;
    VFBCV_i        = VFBCV + BIN_L * LVFBCV + BIN_W * WVFBCV + BIN_WL * PVFBCV;
    VFBBCV_i       = VFBBCV + BIN_L * LVFBBCV + BIN_W * WVFBBCV + BIN_WL * PVFBBCV;
    NSD_i          = NSD + BIN_L * LNSD + BIN_W * WNSD + BIN_WL * PNSD;
    NDEP_i         = NDEP + BIN_L * LNDEP + BIN_W * WNDEP + BIN_WL * PNDEP;
    NDEPCV_i       = NDEPCV + BIN_L * LNDEPCV + BIN_W * WNDEPCV + BIN_WL * PNDEPCV;
    NGATE_i        = NGATE + BIN_L * LNGATE + BIN_W * WNGATE + BIN_WL * PNGATE;
    CIT_i          = CIT + BIN_L * LCIT + BIN_W * WCIT + BIN_WL * PCIT;
    NFACTOR_i      = NFACTOR + BIN_L * LNFACTOR + BIN_W * WNFACTOR + BIN_WL * PNFACTOR;
    ASCL_i         = ASCL + LASCL * BIN_L + WASCL * BIN_W + PASCL * BIN_WL;
    BSCL_i         = BSCL + LBSCL * BIN_L + WBSCL * BIN_W + PBSCL * BIN_WL;
    DVBD0_i        = DVBD0 + LDVBD0 * BIN_L + WDVBD0 * BIN_W + PDVBD0 * BIN_WL;
    DVBD1_i        = DVBD1 + LDVBD1 * BIN_L + WDVBD1 * BIN_W + PDVBD1 * BIN_WL;
    VSCE_i         = VSCE + LVSCE * BIN_L + WVSCE * BIN_W + PVSCE * BIN_WL;
    CDSBS_i        = CDSBS + LCDSBS * BIN_L + WCDSBS * BIN_W + PCDSBS * BIN_WL;
    CDSBS1_i       = CDSBS1 + LCDSBS1 * BIN_L + WCDSBS1 * BIN_W + PCDSBS1 * BIN_WL;
    DVT1_i         = DVT1 + LDVT1 * BIN_L + WDVT1 * BIN_W + PDVT1 * BIN_WL;
    CDSCD_i        = CDSCD + BIN_L * LCDSCD + BIN_W * WCDSCD + BIN_WL * PCDSCD;
    CDSC_i         = CDSC + BIN_L * LCDSC + BIN_W * WCDSC + BIN_WL * PCDSC;
    CDSCEDGE_i     = CDSCEDGE + BIN_L * LCDSCEDGE + BIN_W * WCDSCEDGE + BIN_WL * PCDSCEDGE;
    CBCBEDGE_i     = CBCBEDGE + BIN_L * LCBCBEDGE + BIN_W * WCBCBEDGE + BIN_WL * PCBCBEDGE;
    CDSCB_i        = CDSCB + BIN_L * LCDSCB + BIN_W * WCDSCB + BIN_WL * PCDSCB;
    CSECSE_i       = CSECSE + BIN_L * LCSECSE + BIN_W * WCSECSE + BIN_WL * PCSECSE;
    CSECSEEDGE_i   = CSECSEEDGE + BIN_L * LCSECSEEDGE + BIN_W * WCSECSEEDGE + BIN_WL * PCSECSEEDGE;
    CBCB_i         = CBCB + BIN_L * LCBCB + BIN_W * WCBCB + BIN_WL * PCBCB;
    DVTP0_i        = DVTP0 + BIN_L * LDVTP0 + BIN_W * WDVTP0 + BIN_WL * PDVTP0;
    DVTP0EDGE_i    = DVTP0EDGE + BIN_L * LDVTP0EDGE + BIN_W * WDVTP0EDGE + BIN_WL * PDVTP0EDGE;
    DVTP1_i        = DVTP1 + BIN_L * LDVTP1 + BIN_W * WDVTP1 + BIN_WL * PDVTP1;
    DVTP1EDGE_i    = DVTP1EDGE + BIN_L * LDVTP1EDGE + BIN_W * WDVTP1EDGE + BIN_WL * PDVTP1EDGE;
    DVTP2_i        = DVTP2 + BIN_L * LDVTP2 + BIN_W * WDVTP2 + BIN_WL * PDVTP2;
    DVTP3_i        = DVTP3 + BIN_L * LDVTP3 + BIN_W * WDVTP3 + BIN_WL * PDVTP3;
    DVTP4_i        = DVTP4 + BIN_L * LDVTP4 + BIN_W * WDVTP4 + BIN_WL * PDVTP4;
    DVTP5_i        = DVTP5 + BIN_L * LDVTP5 + BIN_W * WDVTP5 + BIN_WL * PDVTP5;
    DVTP2EDGE_i    = DVTP2EDGE + BIN_L * LDVTP2EDGE + BIN_W * WDVTP2EDGE + BIN_WL * PDVTP2EDGE;
    DVTP3EDGE_i    = DVTP3EDGE + BIN_L * LDVTP3EDGE + BIN_W * WDVTP3EDGE + BIN_WL * PDVTP3EDGE;
    DVTP4EDGE_i    = DVTP4EDGE + BIN_L * LDVTP4EDGE + BIN_W * WDVTP4EDGE + BIN_WL * PDVTP4EDGE;
    DVTP5EDGE_i    = DVTP5EDGE + BIN_L * LDVTP5EDGE + BIN_W * WDVTP5EDGE + BIN_WL * PDVTP5EDGE;
    K2_i           = K2 + BIN_L * LK2 + BIN_W * WK2 + BIN_WL * PK2;
    K1_i           = K1 + BIN_L * LK1 + BIN_W * WK1 + BIN_WL * PK1;
    K1EDGE_i       = K1EDGE + BIN_L * LK1EDGE + BIN_W * WK1EDGE + BIN_WL * PK1EDGE;
    XJ_i           = XJ + BIN_L * LXJ + BIN_W * WXJ + BIN_WL * PXJ;
    PHIN_i         = PHIN + BIN_L * LPHIN + BIN_W * WPHIN + BIN_WL * PPHIN;
    ETA0_i         = ETA0 + BIN_L * LETA0 + BIN_W * WETA0 + BIN_WL * PETA0;
    ETAB_i         = ETAB + BIN_L * LETAB + BIN_W * WETAB + BIN_WL * PETAB;
    DELTA_i        = DELTA + BIN_L * LDELTA + BIN_W * WDELTA + BIN_WL * PDELTA;
    U0_i           = U0 + BIN_L * LU0 + BIN_W * WU0 + BIN_WL * PU0;
    UA_i           = UA + BIN_L * LUA + BIN_W * WUA + BIN_WL * PUA;
    UD_i           = UD + BIN_L * LUD + BIN_W * WUD + BIN_WL * PUD;
    UDB_i          = UDB + BIN_L * LUDB + BIN_W * WUDB + BIN_WL * PUDB;
    EU_i           = EU + BIN_L * LEU + BIN_W * WEU + BIN_WL * PEU;
    UCS_i          = UCS + BIN_L * LUCS + BIN_W * WUCS + BIN_WL * PUCS;
    UC_i           = UC + BIN_L * LUC + BIN_W * WUC + BIN_WL * PUC;
    PCLM_i         = PCLM + BIN_L * LPCLM + BIN_W * WPCLM + BIN_WL * PPCLM;
    PCLMCV_i       = PCLMCV + BIN_L * LPCLMCV + BIN_W * WPCLMCV + BIN_WL * PPCLMCV;
    RSW_i          = RSW + BIN_L * LRSW + BIN_W * WRSW + BIN_WL * PRSW;
    RDW_i          = RDW + BIN_L * LRDW + BIN_W * WRDW + BIN_WL * PRDW;
    PRWG_i         = PRWG + BIN_L * LPRWG + BIN_W * WPRWG + BIN_WL * PPRWG;
    PRWB_i         = PRWB + BIN_L * LPRWB + BIN_W * WPRWB + BIN_WL * PPRWB;
    WR_i           = WR + BIN_L * LWR + BIN_W * WWR + BIN_WL * PWR;
    RSWMIN_i       = RSWMIN + BIN_L * LRSWMIN + BIN_W * WRSWMIN + BIN_WL * PRSWMIN;
    RDWMIN_i       = RDWMIN + BIN_L * LRDWMIN + BIN_W * WRDWMIN + BIN_WL * PRDWMIN;
    RDSW_i         = RDSW + BIN_L * LRDSW + BIN_W * WRDSW + BIN_WL * PRDSW;
    RDSWMIN_i      = RDSWMIN + BIN_L * LRDSWMIN + BIN_W * WRDSWMIN + BIN_WL * PRDSWMIN;
    PTWG_i         = PTWG + BIN_L * LPTWG + BIN_W * WPTWG + BIN_WL * PPTWG;
    PDIBLC_i       = PDIBLC + BIN_L * LPDIBLC + BIN_W * WPDIBLC + BIN_WL * PPDIBLC;
    PDIBLCB_i      = PDIBLCB + BIN_L * LPDIBLCB + BIN_W * WPDIBLCB + BIN_WL * PPDIBLCB;
    PSCBE1_i       = PSCBE1 + BIN_L * LPSCBE1 + BIN_W * WPSCBE1 + BIN_WL * PPSCBE1;
    PSCBE2_i       = PSCBE2 + BIN_L * LPSCBE2 + BIN_W * WPSCBE2 + BIN_WL * PPSCBE2;
    PDITS_i        = PDITS + BIN_L * LPDITS + BIN_W * WPDITS + BIN_WL * PPDITS;
    PDITSD_i       = PDITSD + BIN_L * LPDITSD + BIN_W * WPDITSD + BIN_WL * PPDITSD;
    FPROUT_i       = FPROUT + BIN_L * LFPROUT + BIN_W * WFPROUT + BIN_WL * PFPROUT;
    PVAG_i         = PVAG + BIN_L * LPVAG + BIN_W * WPVAG + BIN_WL * PPVAG;
    VSAT_i         = VSAT + BIN_L * LVSAT + BIN_W * WVSAT + BIN_WL * PVSAT;
    KSATIV_i       = KSATIV +  BIN_L * LKSATIV + BIN_W * WKSATIV + BIN_WL * PKSATIV;
    KSATCV_i       = KSATCV +  BIN_L * LKSATCV + BIN_W * WKSATCV + BIN_WL * PKSATCV;
    THESAT_i       = THESAT + BIN_L * LTHESAT + BIN_W * WTHESAT + BIN_WL * PTHESAT;
    THESATCV_i     = THESATCV + BIN_L * LTHESATCV + BIN_W * WTHESATCV + BIN_WL * PTHESATCV;
    LPE1_i         = LPE1 + LLPE1 * BIN_L + WLPE1 * BIN_W + PLPE1 * BIN_WL;
    PSAT_i         = PSAT + BIN_L * LPSAT + BIN_W * WPSAT + BIN_WL * PPSAT;
    PSATCV_i       = PSATCV + BIN_L * LPSATCV + BIN_W * WPSATCV + BIN_WL * PPSATCV;
    VSATCV_i       = VSATCV + BIN_L * LVSATCV + BIN_W * WVSATCV + BIN_WL * PVSATCV;
    CF_i           = CF + BIN_L * LCF + BIN_W * WCF + BIN_WL * PCF;
    CGSL_i         = CGSL + BIN_L * LCGSL + BIN_W * WCGSL + BIN_WL * PCGSL;
    CGDL_i         = CGDL + BIN_L * LCGDL + BIN_W * WCGDL + BIN_WL * PCGDL;
    CKAPPAS_i      = CKAPPAS + BIN_L * LCKAPPAS + BIN_W * WCKAPPAS + BIN_WL * PCKAPPAS;
    CKAPPAD_i      = CKAPPAD + BIN_L * LCKAPPAD + BIN_W * WCKAPPAD + BIN_WL * PCKAPPAD;

    //For BSIM-SOI Impact Ionization Module
    ALPHA0_i       = ALPHA0 + BIN_L * LALPHA0 + BIN_W * WALPHA0 + BIN_WL * PALPHA0;
    BETA0_i        = BETA0 + BIN_L * LBETA0 + BIN_W * WBETA0 + BIN_WL * PBETA0;
    BETA1_i        = BETA1 + BIN_L * LBETA1 + BIN_W * WBETA1 + BIN_WL * PBETA1;
    BETA2_i        = BETA2 + BIN_L * LBETA2 + BIN_W * WBETA2 + BIN_WL * PBETA2;
    LII_i          = LII + BIN_L * LLII + BIN_W * WLII + BIN_WL * PLII;
    SII0_i         = SII0 + BIN_L * LSII0 + BIN_W * WSII0 + BIN_WL * PSII0;
    SII1_i         = SII1 + BIN_L * LSII1 + BIN_W * WSII1 + BIN_WL * PSII1;
    SII2_i         = SII2 + BIN_L * LSII2 + BIN_W * WSII2 + BIN_WL * PSII2;
    SIID_i         = SIID + BIN_L * LSIID + BIN_W * WSIID + BIN_WL * PSIID;
    VDSATII0_i     = VDSATII0 + LVDSATII0 * BIN_L + WVDSATII0 * BIN_W + PVDSATII0 * BIN_WL;
    ESATII_i       = ESATII + BIN_L * LESATII + BIN_W * WESATII + BIN_WL * PESATII;
    FBJTII_i       = FBJTII + BIN_L * LFBJTII + BIN_W * WFBJTII + BIN_WL * PFBJTII;

    EBJTII_i       = EBJTII + BIN_L * LEBJTII + BIN_W * WEBJTII + BIN_WL * PEBJTII;
    CBJTII_i       = CBJTII + BIN_L * LCBJTII + BIN_W * WCBJTII + BIN_WL * PCBJTII;
    ABJTII_i       = ABJTII + BIN_L * LABJTII + BIN_W * WABJTII + BIN_WL * PABJTII;
    VBCI_i         = VBCI + BIN_L * LVBCI + BIN_W * WVBCI + BIN_WL * PVBCI;
    MBJTII_i       = MBJTII + BIN_L * LMBJTII + BIN_W * WMBJTII + BIN_WL * PMBJTII;

    //Non-linear Body Resistance
    UB_i           = UB + BIN_L * LUB + BIN_W * WUB + BIN_WL * PUB;
    UBTE_i         = UBTE + BIN_L * LUBTE + BIN_W * WUBTE + BIN_WL * PUBTE;
    NEFF_i         = NEFF + BIN_L * LNEFF + BIN_W * WNEFF + BIN_WL * PNEFF;

    //Binning of Diode and BJT Parameters -- For SOI Junction Currents (Diode and BJT)
    XDIF_i = XDIF + LXDIF * BIN_L + WXDIF * BIN_W + PXDIF * BIN_WL;
    ISDIF_i = ISDIF + LISDIF * BIN_L + WISDIF * BIN_W + PISDIF * BIN_WL;
    IDDIF_i = IDDIF + LIDDIF * BIN_L + WIDDIF * BIN_W + PIDDIF * BIN_WL;
    NRECF0_i = NRECF0 + LNRECF0 * BIN_L + WNRECF0 * BIN_W + PNRECF0 * BIN_WL;
    NRECR0_i = NRECR0 + LNRECR0 * BIN_L + WNRECR0 * BIN_W + PNRECR0 * BIN_WL;
    XREC_i = XREC + LXREC * BIN_L + WXREC * BIN_W + PXREC * BIN_WL;
    ISREC_i = ISREC + LISREC * BIN_L + WISREC * BIN_W + PISREC * BIN_WL;
    IDREC_i = IDREC + LIDREC * BIN_L + WIDREC * BIN_W + PIDREC * BIN_WL;

    NTRECF_i = NTRECF + LNTRECF * BIN_L + WNTRECF * BIN_W + PNTRECF * BIN_WL;
    NTRECR_i = NTRECR + LNTRECR * BIN_L + WNTRECR * BIN_W + PNTRECR * BIN_WL;

    ISTUN_i = ISTUN + LISTUN * BIN_L + WISTUN * BIN_W + PISTUN * BIN_WL;
    IDTUN_i = IDTUN + LIDTUN * BIN_L + WIDTUN * BIN_W + PIDTUN * BIN_WL;

    XTUN_i = XTUN + LXTUN * BIN_L + WXTUN * BIN_W + PXTUN * BIN_WL;
    XTUND_i = XTUND + LXTUND * BIN_L + WXTUND * BIN_W + PXTUND * BIN_WL;

    NTUN_i = NTUN + LNTUN * BIN_L + WNTUN * BIN_W + PNTUN * BIN_WL;
    NTUND_i = NTUND + LNTUND * BIN_L + WNTUND * BIN_W + PNTUND * BIN_WL;

    VTUN0_i = VTUN0 + LVTUN0 * BIN_L + WVTUN0 * BIN_W + PVTUN0 * BIN_WL;
    VTUN0D_i = VTUN0D + LVTUN0D * BIN_L + WVTUN0D * BIN_W + PVTUN0D * BIN_WL;

    VREC0_i = VREC0 + LVREC0 * BIN_L + WVREC0 * BIN_W + PVREC0 * BIN_WL;
    VREC0D_i = VREC0D + LVREC0D * BIN_L + WVREC0D * BIN_W + PVREC0D * BIN_WL;

    VABJT_i     = VABJT + LVABJT  * BIN_L + WVABJT  * BIN_W + PVABJT  * BIN_WL;
    AELY_i      = AELY + LAELY   * BIN_L + WAELY   * BIN_W + PAELY   * BIN_WL;
    AHLI_i      = AHLI + BIN_L * LAHLI + BIN_W * WAHLI + PAHLI * BIN_WL;
    AHLID_i     = AHLID + BIN_L * LAHLID + BIN_W * WAHLID + PAHLID * BIN_WL;
    XBJT_i      = XBJT + LXBJT   * BIN_L + WXBJT   * BIN_W + PXBJT   * BIN_WL;
    NDIODE_i    = NDIODE + LNDIODE * BIN_L + WNDIODE * BIN_W + PNDIODE * BIN_WL;
    ISBJT_i     = ISBJT + LISBJT * BIN_L + WISBJT * BIN_W + PISBJT * BIN_WL;
    IDBJT_i     = IDBJT + LIDBJT * BIN_L + WIDBJT * BIN_W + PIDBJT * BIN_WL;
    NBJT_i      = NBJT + LNBJT * BIN_L + WNBJT * BIN_W + PNBJT * BIN_WL;
    LBJT0_i     = LBJT0 + LLBJT0 * BIN_L +WLBJT0 * BIN_W + PLBJT0 * BIN_WL;
    NDIF_i      = NDIF + LNDIF * BIN_L + WNDIF * BIN_W + PNDIF * BIN_WL;

    KVTH0WE_i      = KVTH0WE + BIN_L * LKVTH0WE  + BIN_W * WKVTH0WE + BIN_WL * PKVTH0WE;
    K2WE_i         = K2WE + BIN_L * LK2WE + BIN_W * WK2WE + BIN_WL * PK2WE;
    KU0WE_i        = KU0WE + BIN_L * LKU0WE + BIN_W * WKU0WE + BIN_WL * PKU0WE;

    AGIDL_i        = AGIDL + BIN_L * LAGIDL + BIN_W * WAGIDL + BIN_WL * PAGIDL;
    BGIDL_i        = BGIDL + BIN_L * LBGIDL + BIN_W * WBGIDL + BIN_WL * PBGIDL;
    BGIDL1_i       = BGIDL1 + LBGIDL1 * BIN_L + WBGIDL1 * BIN_W + PBGIDL1 * BIN_WL;
    CGIDL_i        = CGIDL + BIN_L * LCGIDL + BIN_W * WCGIDL + BIN_WL * PCGIDL;
    EGIDL_i        = EGIDL + BIN_L * LEGIDL + BIN_W * WEGIDL + BIN_WL * PEGIDL;
    AGISL_i        = AGISL + BIN_L * LAGISL + BIN_W * WAGISL + BIN_WL * PAGISL;
    BGISL_i        = BGISL + BIN_L * LBGISL + BIN_W * WBGISL + BIN_WL * PBGISL;
    BGISL1_i       = BGISL1 + LBGISL1 * BIN_L + WBGISL1 * BIN_W + PBGISL1 * BIN_WL;
    CGISL_i        = CGISL + BIN_L * LCGISL + BIN_W * WCGISL + BIN_WL * PCGISL;
    EGISL_i        = EGISL + BIN_L * LEGISL + BIN_W * WEGISL + BIN_WL * PEGISL;
    //GIDL_MOD = 1
    RGISL_i       = RGISL + BIN_L * LRGISL + BIN_W * WRGISL + BIN_WL * PRGISL;
    RGIDL_i       = RGIDL + BIN_L * LRGIDL + BIN_W * WRGIDL + BIN_WL * PRGIDL;
    KGISL_i       = KGISL + BIN_L * LKGISL + BIN_W * WKGISL + BIN_WL * PKGISL;
    KGIDL_i       = KGIDL + BIN_L * LKGIDL + BIN_W * WKGIDL + BIN_WL * PKGIDL;
    FGISL_i       = FGISL + BIN_L * LFGISL + BIN_W * WFGISL + BIN_WL * PFGISL;
    FGIDL_i       = FGIDL + BIN_L * LFGIDL + BIN_W * WFGIDL + BIN_WL * PFGIDL;

    UTE_i          = UTE + BIN_L * LUTE + BIN_W * WUTE + BIN_WL * PUTE;
    UA1_i          = UA1 + BIN_L * LUA1 + BIN_W * WUA1 + BIN_WL * PUA1;
    UC1_i          = UC1 + BIN_L * LUC1 + BIN_W * WUC1 + BIN_WL * PUC1;
    UD1_i          = UD1 + BIN_L * LUD1 + BIN_W * WUD1 + BIN_WL * PUD1;
    UDB1_i         = UDB1 + BIN_L * LUDB1 + BIN_W * WUDB1 + BIN_WL * PUDB1;
    EU1_i          = EU1 + BIN_L * LEU1 + BIN_W * WEU1 + BIN_WL * PEU1;
    UCSTE_i        = UCSTE + BIN_L * LUCSTE + BIN_W * WUCSTE + BIN_WL * PUCSTE;
    PRT_i          = PRT + BIN_L * LPRT + BIN_W * WPRT + BIN_WL * PPRT;
    AT_i           = AT + BIN_L * LAT + BIN_W * WAT + BIN_WL * PAT;
    PTWGT_i        = PTWGT + BIN_L * LPTWGT + BIN_W * WPTWGT + BIN_WL * PPTWGT;
    IIT_i          = IIT + BIN_L * LIIT + BIN_W * WIIT + BIN_WL * PIIT;
    IGT_i          = IGT + BIN_L * LIGT + BIN_W * WIGT + BIN_WL * PIGT;
    EIGBINV_i      = EIGBINV + BIN_L * LEIGBINV + BIN_W * WEIGBINV + BIN_WL * PEIGBINV;

    //Binning of IGB's Parameters
    ALPHAGB2_i     = ALPHAGB2 + BIN_L * LALPHAGB2 + BIN_W * WALPHAGB2 + BIN_WL * PALPHAGB2;
    ALPHAGB2_T_i   = ALPHAGB2_T + LALPHAGB2_T * BIN_L + WALPHAGB2_T * BIN_W + PALPHAGB2_T * BIN_WL;
    BETAGB2_i      = BETAGB2  + BIN_L * LBETAGB2 + BIN_W * WBETAGB2 + BIN_WL * PBETAGB2;

    ALPHAGB1_i     = ALPHAGB1 + BIN_L * LALPHAGB1 + BIN_W * WALPHAGB1 + BIN_WL * PALPHAGB1;
    ALPHAGB1_T_i   = ALPHAGB1_T + LALPHAGB1_T * BIN_L + WALPHAGB1_T * BIN_W + PALPHAGB1_T * BIN_WL;
    BETAGB1_i      = BETAGB1  + BIN_L * LBETAGB1 + BIN_W * WBETAGB1 + BIN_WL * PBETAGB1;

    AIGC_i         = AIGC + BIN_L * LAIGC + BIN_W * WAIGC + BIN_WL * PAIGC;
    AIGC1_i        = AIGC1 + LAIGC1 * BIN_L + WAIGC1 * BIN_W + PAIGC1 * BIN_WL;
    BIGC_i         = BIGC + BIN_L * LBIGC + BIN_W * WBIGC + BIN_WL * PBIGC;
    CIGC_i         = CIGC + BIN_L * LCIGC + BIN_W * WCIGC + BIN_WL * PCIGC;
    AIGS_i         = AIGS + BIN_L * LAIGS + BIN_W * WAIGS + BIN_WL * PAIGS;
    AIGS1_i        = AIGS1 + LAIGS1 * BIN_L + WAIGS1 * BIN_W + PAIGS1 * BIN_WL;
    BIGS_i         = BIGS + BIN_L * LBIGS + BIN_W * WBIGS + BIN_WL * PBIGS;
    CIGS_i         = CIGS + BIN_L * LCIGS + BIN_W * WCIGS + BIN_WL * PCIGS;
    AIGD_i         = AIGD + BIN_L * LAIGD + BIN_W * WAIGD + BIN_WL * PAIGD;
    AIGD1_i        = AIGD1 + LAIGD1 * BIN_L + WAIGD1 * BIN_W + PAIGD1 * BIN_WL;
    BIGD_i         = BIGD + BIN_L * LBIGD + BIN_W * WBIGD + BIN_WL * PBIGD;
    CIGD_i         = CIGD + BIN_L * LCIGD + BIN_W * WCIGD + BIN_WL * PCIGD;
    POXEDGE_i      = POXEDGE + BIN_L * LPOXEDGE + BIN_W * WPOXEDGE + BIN_WL * PPOXEDGE;
    DLCIG_i        = DLCIG + BIN_L * LDLCIG + BIN_W * WDLCIG + BIN_WL * PDLCIG;
    DLCIGD_i       = DLCIGD + BIN_L * LDLCIGD + BIN_W * WDLCIGD + BIN_WL * PDLCIGD;
    NTOX_i         = NTOX + BIN_L * LNTOX + BIN_W * WNTOX + BIN_WL * PNTOX;
    KT1_i          = KT1 + BIN_L * LKT1 + BIN_W * WKT1 + BIN_WL * PKT1;
    KT2_i          = KT2 + BIN_L * LKT2 + BIN_W * WKT2 + BIN_WL * PKT2;
    PSATB_i        = PSATB + BIN_L * LPSATB + BIN_W * WPSATB + BIN_WL * PPSATB;
    PSATE_i        = PSATE + BIN_L * LPSATE + BIN_W * WPSATE + BIN_WL * PPSATE;
    PSATBCV_i      = PSATBCV + BIN_L * LPSATBCV + BIN_W * WPSATBCV + BIN_WL * PPSATBCV;
    PSATECV_i      = PSATECV + BIN_L * LPSATECV + BIN_W * WPSATECV + BIN_WL * PPSATECV;
    A1_i           = A1 + BIN_L * LA1 + BIN_W * WA1 + BIN_WL * PA1;
    A11_i          = A11 + BIN_L * LA11 + BIN_W * WA11 + BIN_WL * PA11;
    A2_i           = A2 + BIN_L * LA2 + BIN_W * WA2 + BIN_WL * PA2;
    A21_i          = A21 + BIN_L * LA21 + BIN_W * WA21 + BIN_WL * PA21;
    K0_i           = K0 + BIN_L * LK0 + BIN_W * WK0 + BIN_WL * PK0;
    M0_i           = M0 + BIN_L * LM0 + BIN_W * WM0 + BIN_WL * PM0;
    K01_i          = K01 + BIN_L * LK01 + BIN_W * WK01 + BIN_WL * PK01;
    M01_i          = M01 + BIN_L * LM01 + BIN_W * WM01 + BIN_WL * PM01;
    NFACTOREDGE_i  = NFACTOREDGE + BIN_L * LNFACTOREDGE + BIN_W * WNFACTOREDGE + BIN_WL * PNFACTOREDGE;
    NDEPEDGE_i     = NDEPEDGE + BIN_L * LNDEPEDGE + BIN_W * WNDEPEDGE + BIN_WL * PNDEPEDGE;
    CITEDGE_i      = CITEDGE + BIN_L * LCITEDGE + BIN_W * WCITEDGE + BIN_WL * PCITEDGE;
    CDSCDEDGE_i    = CDSCDEDGE + BIN_L * LCDSCDEDGE + BIN_W * WCDSCDEDGE + BIN_WL * PCDSCDEDGE;
    CDSCBEDGE_i    = CDSCBEDGE + BIN_L * LCDSCBEDGE + BIN_W * WCDSCBEDGE + BIN_WL * PCDSCBEDGE;
    ETA0EDGE_i     = ETA0EDGE + BIN_L * LETA0EDGE + BIN_W * WETA0EDGE + BIN_WL * PETA0EDGE;
    ETABEDGE_i     = ETABEDGE + BIN_L * LETABEDGE + BIN_W * WETABEDGE + BIN_WL * PETABEDGE;
    KT1EDGE_i      = KT1EDGE + BIN_L * LKT1EDGE + BIN_W * WKT1EDGE + BIN_WL * PKT1EDGE;
    KT1LEDGE_i     = KT1LEDGE + BIN_L * LKT1LEDGE + BIN_W * WKT1LEDGE + BIN_WL * PKT1LEDGE;
    KT2EDGE_i      = KT2EDGE + BIN_L * LKT2EDGE + BIN_W * WKT2EDGE + BIN_WL * PKT2EDGE;
    KT1EXPEDGE_i   = KT1EXPEDGE + BIN_L * LKT1EXPEDGE + BIN_W * WKT1EXPEDGE + BIN_WL * PKT1EXPEDGE;
    TNFACTOREDGE_i = TNFACTOREDGE + BIN_L * LTNFACTOREDGE + BIN_W * WTNFACTOREDGE + BIN_WL * PTNFACTOREDGE;
    TETA0EDGE_i    = TETA0EDGE + BIN_L * LTETA0EDGE + BIN_W * WTETA0EDGE + BIN_WL * PTETA0EDGE;
    K2EDGE_i       = K2EDGE + BIN_L * LK2EDGE + BIN_W * WK2EDGE + BIN_WL * PK2EDGE;
    KVTH0EDGE_i    = KVTH0EDGE + BIN_L * LKVTH0EDGE + BIN_W * WKVTH0EDGE + BIN_WL * PKVTH0EDGE;
    K2EDGEWE_i     = K2EDGEWE + BIN_L * LK2EDGEWE + BIN_W * WK2EDGEWE + BIN_WL * PK2EDGEWE;
    KVTH0EDGEWE_i  = KVTH0EDGEWE + BIN_L * LKVTH0EDGEWE + BIN_W * WKVTH0EDGEWE + BIN_WL * PKVTH0EDGEWE;
    STK2EDGE_i     = STK2EDGE + BIN_L * LSTK2EDGE + BIN_W * WSTK2EDGE + BIN_WL * PSTK2EDGE;
    STETA0EDGE_i   = STETA0EDGE + BIN_L * LSTETA0EDGE + BIN_W * WSTETA0EDGE + BIN_WL * PSTETA0EDGE;
    C0_i           = C0 + BIN_L * LC0 + BIN_W * WC0 + BIN_WL * PC0;
    C01_i          = C01 + BIN_L * LC01 + BIN_W * WC01 + BIN_WL * PC01;
    C0SI_i         = C0SI + BIN_L * LC0SI + BIN_W * WC0SI + BIN_WL * PC0SI;
    C0SI1_i        = C0SI1 + BIN_L * LC0SI1 + BIN_W * WC0SI1 + BIN_WL * PC0SI1;
    C0SISAT_i      = C0SISAT + BIN_L * LC0SISAT + BIN_W * WC0SISAT + BIN_WL * PC0SISAT;
    C0SISAT1_i     = C0SISAT1 + BIN_L * LC0SISAT1 + BIN_W * WC0SISAT1 + BIN_WL * PC0SISAT1;

    //Gate current in accumulation in AGBCP2 region
    AIGBCP2_i    = AIGBCP2 + BIN_L * LAIGBCP2 + BIN_W * WAIGBCP2 + BIN_WL * PAIGBCP2;
    AIGBCP2_T_i = AIGBCP2_T + LAIGBCP2_T * BIN_L + WAIGBCP2_T * BIN_W + PAIGBCP2_T * BIN_WL;
    BIGBCP2_i    = BIGBCP2 + BIN_L * LBIGBCP2 + BIN_W * WBIGBCP2 + BIN_WL * PBIGBCP2;
    CIGBCP2_i    = CIGBCP2 + BIN_L * LCIGBCP2 + BIN_W * WCIGBCP2 + BIN_WL * PCIGBCP2;

    //Substrate (back gate)
    NSUB_i    = NSUB + BIN_L * LNSUB + BIN_W * WNSUB + BIN_WL * PNSUB;
    KB1_i     = KB1 + BIN_L * LKB1 + BIN_W * WKB1 + BIN_WL * PKB1;

    if (ASYMMOD != 0) begin
        CDSCDEDGER_i = CDSCDEDGER + BIN_L * LCDSCDEDGER + BIN_W * WCDSCDEDGER + BIN_WL * PCDSCDEDGER;
        CDSCDR_i     = CDSCDR + BIN_L * LCDSCDR + BIN_W * WCDSCDR + BIN_WL * PCDSCDR;
        ETA0R_i      = ETA0R + BIN_L * LETA0R + BIN_W * WETA0R + BIN_WL * PETA0R;
        U0R_i        = U0R + BIN_L * LU0R + BIN_W * WU0R + BIN_WL * PU0R;
        UAR_i        = UAR + BIN_L * LUAR + BIN_W * WUAR + BIN_WL * PUAR;
        UDR_i        = UDR + BIN_L * LUDR + BIN_W * WUDR + BIN_WL * PUDR;
        UDBR_i        = UDBR + BIN_L * LUDBR + BIN_W * WUDBR + BIN_WL * PUDBR;
        UCSR_i       = UCSR + BIN_L * LUCSR + BIN_W * WUCSR + BIN_WL * PUCSR;
        UCR_i        = UCR + BIN_L * LUCR + BIN_W * WUCR + BIN_WL * PUCR;
        PCLMR_i      = PCLMR + BIN_L * LPCLMR + BIN_W * WPCLMR + BIN_WL * PPCLMR;
        PDIBLCR_i    = PDIBLCR + BIN_L * LPDIBLCR + BIN_W * WPDIBLCR + BIN_WL * PPDIBLCR;
        VSATR_i      = VSATR + BIN_L * LVSATR + BIN_W * WVSATR + BIN_WL * PVSATR;
        PSATR_i      = PSATR + BIN_L * LPSATR + BIN_W * WPSATR + BIN_WL * PPSATR;
        PTWGR_i      = PTWGR + BIN_L * LPTWGR + BIN_W * WPTWGR + BIN_WL * PPTWGR;
    end

    // Geometrical scaling
    T0        = NDEPL1 * max(pow(Inv_L, NDEPLEXP1) - pow(Inv_Llong, NDEPLEXP1), 0.0) + NDEPL2 * max(pow(Inv_L, NDEPLEXP2) - pow(Inv_Llong, NDEPLEXP2), 0.0);
    T1        = NDEPW * max(pow(Inv_W, NDEPWEXP) - pow(Inv_Wwide, NDEPWEXP), 0.0) + NDEPWL * pow(Inv_W * Inv_L, NDEPWLEXP);
    NDEP_i    = NDEP_i * (1.0 + T0 + T1);
    T0        = NFACTORL * max( pow(Inv_L, NFACTORLEXP) - pow(Inv_Llong, NFACTORLEXP), 0.0);
    T1        = NFACTORW * max( pow(Inv_W, NFACTORWEXP) - pow(Inv_Wwide, NFACTORWEXP), 0.0) + NFACTORWL * pow(Inv_WL, NFACTORWLEXP);
    NFACTOR_i = NFACTOR_i * (1.0 + T0 + T1);
    T0        = (1.0 + CDSCDL * max(pow(Inv_L, CDSCDLEXP) - pow(Inv_Llong, CDSCDLEXP), 0.0));
    CDSCD_i   = CDSCD_i * T0;
    if (ASYMMOD != 0) begin
        CDSCDEDGER_i = CDSCDEDGER_i * T0;
        CDSCDR_i     = CDSCDR_i * T0;
    end
    CDSCB_i = CDSCB_i * (1.0 + CDSCBL * max(pow(Inv_L, CDSCBLEXP) - pow(Inv_Llong, CDSCBLEXP), 0.0));
    U0_i    = MULU0 * U0_i;
    if (MOBSCALE != 1) begin
        if (U0LEXP > 0.0) begin
            U0_i = U0_i * (1.0 - U0L * max(pow(Inv_L, U0LEXP) - pow(Inv_Llong, U0LEXP), 0.0));
            if (ASYMMOD != 0) begin
                U0R_i = U0R_i * (1.0 - U0L * max(pow(Inv_L, U0LEXP) - pow(Inv_Llong, U0LEXP), 0.0));
            end
        end else begin
            U0_i = U0_i * (1.0 - U0L);
            if (ASYMMOD != 0) begin
                U0R_i = U0R_i * (1.0 - U0L);
            end
        end
    end else begin
        U0_i = U0_i * (1.0 - (UP1 * lexp(-Leff / LP1)) - (UP2 * lexp(-Leff / LP2)));
        if (ASYMMOD != 0) begin
            U0R_i = U0R_i * (1.0 - (UP1 * lexp(-Leff / LP1)) - (UP2 * lexp(-Leff / LP2)));
        end
    end
    T0   = UAL * max(pow(Inv_L, UALEXP) - pow(Inv_Llong, UALEXP), 0.0);
    T1   = UAW * max(pow(Inv_W, UAWEXP) - pow(Inv_Wwide, UAWEXP), 0.0) + UAWL * pow(Inv_WL, UAWLEXP);
    UA_i = UA_i * (1.0 + T0 + T1);
    if (ASYMMOD != 0) begin
        UAR_i = UAR_i * (1.0 + T0 + T1);
    end
    T0   = EUL * max(pow(Inv_L, EULEXP) - pow(Inv_Llong, EULEXP), 0.0);
    T1   = EUW * max(pow(Inv_W, EUWEXP) - pow(Inv_Wwide, EUWEXP), 0.0) + EUWL * pow(Inv_WL, EUWLEXP);
    EU_i = EU_i * (1.0 + T0 + T1);
    T0   = 1.0 + UDL * max(pow(Inv_L, UDLEXP) - pow(Inv_Llong, UDLEXP), 0.0);
    UD_i = UD_i * T0;
    T1   = 1.0 + UDBL * max(pow(Inv_L, UDBLEXP) - pow(Inv_Llong, UDBLEXP), 0.0);
    UDB_i = UDB_i * T1;
    if (ASYMMOD != 0) begin
        UDR_i = UDR_i * T0;
        UDBR_i = UDBR_i * T1;
    end
    T0   = UCL * max(pow(Inv_L, UCLEXP) - pow(Inv_Llong, UCLEXP), 0.0);
    T1   = UCW * max(pow(Inv_W, UCWEXP) - pow(Inv_Wwide, UCWEXP), 0.0) + UCWL * pow(Inv_WL, UCWLEXP);
    UC_i = UC_i * (1.0 + T0 + T1);
    if (ASYMMOD != 0) begin
        UCR_i = UCR_i * (1.0 + T0 + T1);
    end
    T0     = max(pow(Inv_L, DSUB) - pow(Inv_Llong, DSUB), 0.0);
    ETA0_i = ETA0_i * T0;
    if (ASYMMOD != 0) begin
        ETA0R_i = ETA0R_i * T0;
    end
    ETAB_i     = ETAB_i * max(pow(Inv_L, ETABEXP) - pow(Inv_Llong, ETABEXP), 0.0);
    T0         = 1.0 + PDIBLCL * max(pow(Inv_L, PDIBLCLEXP) - pow(Inv_Llong, PDIBLCLEXP), 0.0);
    PDIBLC_i = PDIBLC_i * T0;
    if (ASYMMOD != 0) begin
        PDIBLCR_i = PDIBLCR_i * T0;
    end
    T0       = DELTA_i * (1.0 + DELTAL * max(pow(Inv_L, DELTALEXP) - pow(Inv_Llong, DELTALEXP), 0.0));
    DELTA_i  = min(T0, 0.5);
    FPROUT_i = FPROUT_i * (1.0 + FPROUTL * max(pow(Inv_L, FPROUTLEXP) - pow(Inv_Llong, FPROUTLEXP), 0.0));
    T0       = (1.0 + PCLML * max(pow(Inv_L, PCLMLEXP) - pow(Inv_Llong, PCLMLEXP), 0.0));
    PCLM_i   = PCLM_i * T0;
    PCLM_i   = max(PCLM_i, 0.0);
    if (ASYMMOD != 0) begin
        PCLMR_i = PCLMR_i * T0;
        PCLMR_i = max(PCLMR_i, 0.0);
    end
    T0     = VSATL * max(pow(Inv_L, VSATLEXP) - pow(Inv_Llong, VSATLEXP), 0.0);
    T1     = VSATW * max(pow(Inv_W, VSATWEXP) - pow(Inv_Wwide, VSATWEXP), 0.0) + VSATWL * pow(Inv_WL, VSATWLEXP);
    VSAT_i = VSAT_i * (1.0 + T0 + T1);
    if (ASYMMOD != 0) begin
        VSATR_i = VSATR_i * (1.0 + T0 + T1);
    end
    PSAT_i = max(PSAT_i * (1.0 + PSATL * max(pow(Inv_L, PSATLEXP) - pow(Inv_Llong, PSATLEXP), 0.0)), 0.25);
    PSATCV_i = max(PSATCV_i * (1.0 + PSATLCV * max(pow(Inv_Lact, PSATLEXPCV) - pow(Inv_Llong, PSATLEXPCV), 0.0)), 0.25);
    if (ASYMMOD != 0) begin
        PSATR_i = max(PSATR_i * (1.0 + PSATL * max(pow(Inv_L, PSATLEXP) - pow(Inv_Llong, PSATLEXP), 0.0)), 0.25);
    end
    T0     = (1.0 + PTWGL * max(pow(Inv_L, PTWGLEXP) - pow(Inv_Llong, PTWGLEXP), 0.0));
    PTWG_i = PTWG_i * T0;
    if (ASYMMOD != 0) begin
        PTWGR_i = PTWGR_i * T0;
    end
    ALPHA0_i = ALPHA0_i * (1.0 + ALPHA0L * max(pow(Inv_L, ALPHA0LEXP) - pow(Inv_Llong, ALPHA0LEXP), 0.0));
    AGIDL_i  = AGIDL_i * (1.0 + AGIDLL * Inv_L + AGIDLW * Inv_W);
    AGISL_i  = AGISL_i * (1.0 + AGISLL * Inv_L + AGISLW * Inv_W);
    AIGC_i   = AIGC_i * (1.0 + AIGCL * Inv_L + AIGCW * Inv_W);
    AIGS_i   = AIGS_i * (1.0 + AIGSL * Inv_L + AIGSW * Inv_W);
    AIGD_i   = AIGD_i * (1.0 + AIGDL * Inv_L + AIGDW * Inv_W);
    PIGCD_i  = PIGCD * (1.0 + PIGCDL * Inv_L);
    T0       = NDEPCVL1 * max(pow(Inv_Lact, NDEPCVLEXP1) - pow(Inv_Llong, NDEPCVLEXP1), 0.0) + NDEPCVL2 * max( pow(Inv_Lact, NDEPCVLEXP2) - pow(Inv_Llong, NDEPCVLEXP2), 0.0);
    T1       = NDEPCVW * max(pow(Inv_Wact, NDEPCVWEXP) - pow(Inv_Wwide, NDEPCVWEXP), 0.0) + NDEPCVWL * pow(Inv_Wact * Inv_Lact, NDEPCVWLEXP);
    NDEPCV_i = NDEPCV_i * (1.0 + T0 + T1);

    T0       = VFBL * max(pow(Inv_L, VFBLEXP) - pow(Inv_Llong, VFBLEXP), 0.0);
    T1       = VFBW * max(pow(Inv_W, VFBWEXP) - pow(Inv_Wwide, VFBWEXP), 0.0) + VFBWL * pow(Inv_WL, VFBWLEXP);
    VFB_i    = VFB_i * (1.0 + T0 + T1);
    T0       = VFBCVL * max(pow(Inv_Lact, VFBCVLEXP) - pow(Inv_Llong, VFBCVLEXP), 0.0);
    T1       = VFBCVW * max(pow(Inv_Wact, VFBCVWEXP) - pow(Inv_Wwide, VFBCVWEXP), 0.0) + VFBCVWL * pow(Inv_Wact * Inv_Lact, VFBCVWLEXP);
    VFBCV_i  = VFBCV_i * (1.0 + T0 + T1);
    T0       = VSATCVL * max(pow(Inv_Lact, VSATCVLEXP) - pow(Inv_Llong, VSATCVLEXP), 0.0);
    T1       = VSATCVW * max(pow(Inv_Wact, VSATCVWEXP) - pow(Inv_Wwide, VSATCVWEXP), 0.0) + VSATCVWL * pow(Inv_Wact * Inv_Lact, VSATCVWLEXP);
    VSATCV_i = VSATCV_i * (1.0 + T0 + T1);
    PCLMCV_i = PCLMCV_i * (1.0 + PCLMCVL * max(pow(Inv_Lact, PCLMCVLEXP) - pow(Inv_Llong, PCLMCVLEXP), 0.0));
    PCLMCV_i = max(PCLMCV_i, 0.0);
    T0       = K1L * max(pow(Inv_L, K1LEXP) - pow(Inv_Llong, K1LEXP), 0.0);
    T1       = K1W * max(pow(Inv_W, K1WEXP) - pow(Inv_Wwide, K1WEXP), 0.0) + K1WL * pow(Inv_WL, K1WLEXP);
    K1_i     = K1_i * (1.0 + T0 + T1);
    T0       = K1LEDGE * max(pow(Inv_L, K1LEXPEDGE) - pow(Inv_Llong, K1LEXPEDGE), 0.0);
    T1       = K1WEDGE * max(pow(Inv_W, K1WEXPEDGE) - pow(Inv_Wwide, K1WEXPEDGE), 0.0) + K1WLEDGE * pow(Inv_WL, K1WLEXPEDGE);
    K1EDGE_i = K1EDGE_i * (1.0 + T0 + T1);
    T0       = K2L * max(pow(Inv_L, K2LEXP) - pow(Inv_Llong, K2LEXP), 0.0);
    T1       = K2W * max(pow(Inv_W, K2WEXP) - pow(Inv_Wwide, K2WEXP), 0.0) + K2WL * pow(Inv_WL, K2WLEXP);
    K2_i     = K2_i * (1.0 + T0 + T1);
    T0       = K2LEDGE * max(pow(Inv_L, K2LEXPEDGE) - pow(Inv_Llong, K2LEXPEDGE), 0.0);
    T1       = K2WEDGE * max(pow(Inv_W, K2WEXPEDGE) - pow(Inv_Wwide, K2WEXPEDGE), 0.0) + K2WLEDGE * pow(Inv_WL, K2WLEXPEDGE);
    K2EDGE_i = K2EDGE_i * (1.0 + T0 + T1);
    PRWB_i   = PRWB_i * (1.0 + PRWBL * max( pow(Inv_L, PRWBLEXP) - pow(Inv_Llong, PRWBLEXP), 0));

    // Global scaling parameters for temperature
    UTE_i   = UTE_i * (1.0 + Inv_L * UTEL);
    UA1_i   = UA1_i * (1.0 + Inv_L * UA1L);
    UD1_i   = UD1_i * (1.0 + Inv_L * UD1L);
    UDB1_i   = UDB1_i * (1.0 + Inv_L * UDB1L);
    AT_i    = AT_i * (1.0 + Inv_L * ATL);
    PTWGT_i = PTWGT_i * (1.0 + Inv_L * PTWGTL);

    if (RDSMOD == 1) begin
        RSW_i = RSW_i * (1.0 + RSWL * max(pow(Inv_L, RSWLEXP) - pow(Inv_Llong, RSWLEXP), 0.0));
        RDW_i = RDW_i * (1.0 + RDWL * max(pow(Inv_L, RDWLEXP) - pow(Inv_Llong, RDWLEXP), 0.0));
    end else begin
        RDSW_i = RDSW_i * (1.0 + RDSWL * max(pow(Inv_L, RDSWLEXP) - pow(Inv_Llong, RDSWLEXP), 0.0));
    end

    // Parameter checking
    if (UCS_i < 1.0) begin
        UCS_i = 1.0;
    end else if (UCS_i > 2.0) begin
        UCS_i = 2.0;
    end
    if (ASYMMOD != 0) begin
        if (UCSR_i < 1.0) begin
            UCSR_i = 1.0;
        end else if (UCSR_i > 2.0) begin
            UCSR_i = 2.0;
        end
    end
    if (CGIDL_i < 0.0) begin
        $error("Fatal: CGIDL_i = %e is negative.", CGIDL_i);
        CGIDL_i = 0.5;
    end
    if (CGISL_i < 0.0) begin
        $error("Fatal: CGISL_i = %e is negative.", CGISL_i);
        CGISL_i = 0.5;
    end
    if (CKAPPAD_i <= 0.0) begin
        $error("Fatal: CKAPPAD_i = %e is non-positive.", CKAPPAD_i);
        CKAPPAD_i = 0.6;
    end
    if (CKAPPAS_i <= 0.0) begin
        $error("Fatal: CKAPPAS_i = %e is non-positive.", CKAPPAS_i);
        CKAPPAS_i = 0.6;
    end
    if (PDITS_i < 0.0) begin
        $error("Fatal: PDITS_i = %e is negative.", PDITS_i);
        PDITS_i = 0.0;
    end
    if (CIT_i < 0.0) begin
        $error("Fatal: CIT_i = %e is negative.", CIT_i);
        CIT_i = 0.0;
    end
    if (NFACTOR_i < 0.0) begin
        $error("Fatal: NFACTOR_i = %e is negative.", NFACTOR_i);
        NFACTOR_i = 0.0;
    end
    if (K1_i < 0.0) begin
        $error("Fatal: K1_i = %e is negative.", K1_i);
        K1_i = 0.0;
    end
    if (NSD_i <= 0.0) begin
        $error("Fatal: NSD_i = %e is non-positive.", NSD_i);
        NSD_i = 1e26;
    end
    if (NDEP_i <= 0.0) begin
        $error("Fatal: NDEP_i = %e is non-positive.", NDEP_i);
        NDEP_i = 1e24;
    end
    if (NGATE_i <= 0.0) begin
        $error("Fatal: NGATE_i = %e is non-positive.", NGATE_i);
        NGATE_i = 5e25;
    end
    if (XJ_i <= 0.0) begin
        $error("Fatal: XJ_i = %e is non-positive.", XJ_i);
        XJ_i = 1.5e-7;
    end
    if (ISDIF_i < 0.0) begin
        $strobe("Warning: ISDIF_i = %e is negative, setting it to 0.", ISDIF_i);
        ISDIF_i = 0.0;
    end
    if (IDDIF_i < 0.0) begin
        $strobe("Warning: IDDIF_i = %e is negative, setting it to 0.", IDDIF_i);
        IDDIF_i = 0.0;
    end
    if (ISTUN_i < 0.0) begin
        $strobe("Warning: ISTUN_i = %e is negative, setting it to 0.", ISTUN_i);
        ISTUN_i = 0.0;
    end
    if (IDTUN_i < 0.0) begin
        $strobe("Warning: IDTUN_i = %e is negative, setting it to 0.", IDTUN_i);
        IDTUN_i = 0.0;
    end
    if (ISREC_i < 0.0) begin
        $strobe("Warning: ISREC_i = %e is negative, setting it to 0.", ISREC_i);
        ISREC_i = 0.0;
    end
    if (IDREC_i < 0.0) begin
        $strobe("Warning: IDREC_i = %e is negative, setting it to 0.", IDREC_i);
        IDREC_i = 0.0;
    end
    if (ISBJT_i < 0.0) begin
        $strobe("Warning: ISBJT_i = %e is negative, setting it to 0.", ISBJT_i);
        ISBJT_i = 0.0;
    end
    if (IDBJT_i < 0.0) begin
        $strobe("Warning: IDBJT_i = %e is negative, setting it to 0.", IDBJT_i);
        IDBJT_i = 0.0;
    end
    if (CDSCD_i < 0.0) begin
        $error("Fatal: CDSCD_i = %e is negative.", CDSCD_i);
        CDSCD_i = 0.0;
    end
    if (CDSC_i < 0.0) begin
        $strobe("Warning: CDSC_i = %e is negative.", CDSC_i);
    end
    if (DLCIG_i < 0.0) begin
        $strobe("Warning: DLCIG = %e is negative, setting it to 0.", DLCIG_i);
        DLCIG_i = 0.0;
    end
    if (DLCIGD_i < 0.0) begin
        $strobe("Warning: DLCIGD = %e is negative, setting it to 0.", DLCIGD_i);
        DLCIGD_i = 0.0;
    end
    if (M0_i < 0.0) begin
        $strobe("Warning: M0_i = %e is negative, setting it to 0.", M0_i);
        M0_i = 0.0;
    end
    if (U0_i <= 0.0) begin
        $strobe("Warning: U0_i = %e is non-positive, setting it to the default value.", U0_i);
        U0_i = 0.067;
    end
    if (UB_i <= 0.0) begin
        $strobe("Warning: UB_i = %e is non-positive, setting it to the default value.", UB_i);
        UB_i = 0.067;
    end
    if (UA_i < 0.0) begin
        $strobe("Warning: UA_i = %e is negative, setting it to 0.", UA_i);
        UA_i = 0.0;
    end
    if (EU_i < 0.0) begin
        $strobe("Warning: EU_i = %e is negative, setting it to 0.", EU_i);
        EU_i = 0.0;
    end
    if (UD_i < 0.0) begin
        $strobe("Warning: UD_i = %e is negative, setting it to 0.", UD_i);
        UD_i = 0.0;
    end
    if (UDB_i < 0.0) begin
        $strobe("Warning: UDB_i = %e is negative, setting it to 0.", UDB_i);
        UDB_i = 0.0;
    end
    if (UCS_i < 0.0) begin
        $strobe("Warning: UCS_i = %e is negative, setting it to 0.", UCS_i);
        UCS_i = 0.0;
    end
    if (NDIODE_i <= 0.0) begin
        $strobe("Warning: NDIODE_i = %e is non-positive, setting it to the default value.", NDIODE_i);
        NDIODE_i = 1.0;
    end
    if (NRECR0_i <= 0.0) begin
        $strobe("Warning: NRECR0_i = %e is non-positive, setting it to the default value.", NRECR0_i);
        NRECR0_i = 10.0;
    end
    if (NRECF0_i <= 0.0) begin
        $strobe("Warning: NRECF0_i = %e is non-positive, setting it to the default value.", NRECF0_i);
        NRECF0_i = 2.0;
    end
    if (CSDMIN < 0.0) begin
        $strobe("Warning: Csdmin = %g is negative.", CSDMIN);
    end
    if (VSAT_i <= 0.0) begin
        $error("Fatal: Effective VSAT = %g is not positive.", VSAT_i);
        VSAT_i = 1.0e5;
    end
    if (ETA0_i < 0.0) begin
        $strobe("Warning: Effective ETA0 = %g is negative, setting it to 0.", ETA0_i);
        ETA0_i = 0.0;
    end
    if (PDIBLC_i < 0.0) begin
        $strobe("Warning: Effective PDIBLC = %g is negative, setting it to 0.", PDIBLC_i);
        PDIBLC_i = 0.0;
    end
    if (PRWG_i < 0.0) begin
        $strobe("Warning: Effective PRWG = %g is negative, setting it to 0.", PRWG_i);
        PRWG_i = 0.0;
    end
    if (PTWG_i < 0.0) begin
        $strobe("Warning: Effective PTWG = %g is negative, setting it to 0.", PTWG_i);
        PTWG_i = 0.0;
    end
    if (CF_i < 0.0) begin
        $strobe("Warning: Effective CF = %g is negative. Setting it to 0.", CF_i);
        CF_i = 0.0;
    end
    if (K0_i < 0.0) begin
        $strobe("Warning: K0_i = %e is negative, setting it to 0.", K0_i);
        K0_i = 0.0;
    end

    if (COVMOD != 0) begin
        if (CGSL_i < 0.0) begin
            $strobe("Warning: Effective CGSL = %g is negative. Setting it to 0.", CGSL_i);
            CGSL_i = 0.0;
        end
        if (CGDL_i < 0.0) begin
            $strobe("Warning: Effective CGDL = %g is negative. Setting it to 0.", CGDL_i);
            CGDL_i = 0.0;
        end
    end

    if (CVMOD != 0) begin
        if (NDEPCV_i <= 0.0) begin
            $error("Fatal: NDEPCV_i = %e is non-positive.", NDEPCV_i);
            NDEPCV_i = 1e24;
        end
        if (VSATCV_i <= 0.0) begin
            $error("Fatal: Effective VSATCV = %g is not positive.", VSATCV_i);
            VSATCV_i = 1.0e5;
        end
    end

    NDEPAGBCP2_d = NDEPAGBCP2;
    if (MODAGBCP2 == 1) begin
        if (NDEPAGBCP2_d <= 0.0) begin
            $error("Fatal: NDEPAGBCP2_d = %e is non-positive.", NDEPAGBCP2_d);
            NDEPAGBCP2_d = 1e24;
        end
    end

    if (EDGEFET == 1) begin
        if (NDEPEDGE_i <= 0.0) begin
            $error("Fatal: NDEPEDGE_i = %e is non-positive.", NDEPEDGE_i);
            NDEPEDGE_i = 1e24;
        end
        if (K1EDGE_i < 0.0) begin
            $error("Fatal: K1EDGE_i = %e is negative.", K1EDGE_i);
            K1EDGE_i = 0.0;
        end
    end

    if (IGCMOD != 0) begin
        if (POXEDGE_i <= 0.0) begin
            $error("Fatal: POXEDGE_i = %e is non-positive.", POXEDGE_i);
            POXEDGE_i = 1.0;
        end
    end

    if (ASYMMOD != 0) begin
        if (CDSCDR_i < 0.0) begin
            $error("Fatal: CDSCDR_i = %e is negative.", CDSCDR_i);
            CDSCDR_i = 0.0;
        end
        if (CDSCDEDGER_i < 0.0) begin
            $error("Fatal: CDSCDEDGER_i = %e is negative.", CDSCDEDGER_i);
            CDSCDEDGER_i = 1e-9;
        end
        if (ETA0R_i < 0.0) begin
            $strobe("Warning: Effective ETA0R = %g is negative, setting it to 0.", ETA0R_i);
            ETA0R_i = 0.0;
        end
        if (U0R_i <= 0.0) begin
            $strobe("Warning: U0R_i = %e is non-positive, setting it to the default value.", U0R_i);
            U0R_i = 0.067;
        end
        if (UAR_i < 0.0) begin
            $strobe("Warning: Effective UAR = %g is negative, setting it to 0.", UAR_i);
            UAR_i = 0.0;
        end
        if (UDR_i < 0.0) begin
            $strobe("Warning: Effective UDR = %g is negative, setting it to 0.", UDR_i);
            UDR_i = 0.0;
        end
        if (UDBR_i < 0.0) begin
            $strobe("Warning: UDBR_i = %e is negative, setting it to 0.", UDBR_i);
            UDBR_i = 0.0;
        end
        if (UCSR_i < 0.0) begin
            $strobe("Warning: UCSR_i = %e is negative, setting it to 0.", UCSR_i);
            UCSR_i = 0.0;
        end
        if (PDIBLCR_i < 0.0) begin
            $strobe("Warning: Effective PDIBLCR = %g is negative, setting it to 0.", PDIBLCR_i);
            PDIBLCR_i = 0.0;
        end
        if (VSATR_i <= 0.0) begin
            $error("Fatal: Effective VSAT = %g is not positive.", VSATR_i);
            VSATR_i = 1.0e5;
        end
        if (PTWGR_i < 0.0) begin
            $strobe("Warning: Effective PTWGR = %g is negative, setting it to 0.", PTWGR_i);
            PTWGR_i = 0.0;
        end
    end

    // Initialize variables used in geometry macros
    nuEndD = 0.0; nuEndS = 0.0; nuIntD = 0.0; nuIntS = 0.0; Rend = 0.0; Rint = 0.0;

    // Process drain series resistance
    DMCGeff = DMCG - DMCGT;
    DMCIeff = DMCI;
    DMDGeff = DMDG - DMCGT;

    // Processing S/D resistances and conductances
    if ($param_given(NRS)) begin
        RSourceGeo = RSH * NRS;
    end else if (RGEOMOD > 0 && RSH > 0.0) begin
        `BSIMBULKRdseffGeo(NF, GEOMOD, RGEOMOD, MINZ, Weff, RSH, DMCGeff, DMCIeff, DMDGeff, 1, RSourceGeo)
    end else begin
        RSourceGeo = 0.0;
    end

    if ($param_given(NRD)) begin
        RDrainGeo = RSH * NRD;
    end else if (RGEOMOD > 0 && RSH > 0.0) begin
        `BSIMBULKRdseffGeo(NF, GEOMOD, RGEOMOD, MINZ, Weff, RSH, DMCGeff, DMCIeff, DMDGeff, 0, RDrainGeo)
    end else begin
        RDrainGeo = 0.0;
    end
    // Clamping of S/D resistances

    if (RDSMOD == 0) begin
        if (RSourceGeo < minr) begin
            RSourceGeo = 0;
        end
        if (RDrainGeo < minr) begin
            RDrainGeo = 0;
        end
    end else begin
        if (RSourceGeo <= minr) begin
            RSourceGeo = minr;
        end
        if (RDrainGeo <= minr) begin
            RDrainGeo = minr;
        end
    end

    if (RDSMOD == 1) begin
        if (RSWMIN_i <= 0.0) begin
            RSWMIN_i = 0.0;
        end
        if (RDWMIN_i <= 0.0) begin
            RDWMIN_i = 0.0;
        end
        if (RSW_i <= 0.0) begin
            RSW_i = 0.0;
        end
        if (RDW_i <= 0.0) begin
            RDW_i = 0.0;
        end
    end else begin
        if (RDSWMIN_i <= 0.0) begin
            RDSWMIN_i = 0.0;
        end
        if (RDSW_i <= 0.0) begin
            RDSW_i = 0.0;
        end
    end

    // Gate process resistance
    Grgeltd = RSHG * (XGW + Weffcj / 3.0 / NGCON) / (NGCON * NF * (Lnew - XGL_d));
    if (Grgeltd > 0.0) begin
        Grgeltd = 1.0 / Grgeltd;
    end else begin
        Grgeltd = 1.0e3;
        if (RGATEMOD != 0) begin
            `STROBE("Warning: (instance %M) The gate conductance reset to 1.0e3 mho.");
        end
    end
    T0           = TOXE * TOXE;
    T1           = TOXE * POXEDGE_i;
    T2           = T1 * T1;
    ToxRatio     = lexp(NTOX_i * lln(TOXREF / TOXE)) / T0;
    ToxRatioEdge = lexp(NTOX_i * lln(TOXREF / T1)) / T2;
    Aechvb       = (TYPE == `ntype) ? AGBC2P : AGBC2N;
    Bechvb       = (TYPE == `ntype) ? BGBC2P : BGBC2N;
    AechvbEdges   = Aechvb * (Weff / NSEG + PSBCP) * ToxRatioEdge;
    AechvbEdged   = Aechvb * (Weff / NSEG + PDBCP) * ToxRatioEdge;
    BechvbEdge   = -Bechvb * TOXE * POXEDGE_i;
    Aechvb       = Aechvb * (Weff / NSEG * Leff + AGBCPD / NF) * ToxRatio;
    Bechvb       = -Bechvb * TOXE;
    Weff_SH      = WTH0 + Weff;

    if ((SHMOD != 0) && (RTH0 > 0.0) && (Weff_SH > 0.0)) begin
        if (TNODEOUT && !$port_connected(t)) begin
            if ($port_connected(b)) begin             //last terminal is 'b'
                $strobe("\nWarning: A fifth node has been specified with TNODEOUT = 1. The fifth node will be treated as the temperature node 'T'.");
            end else begin
                $strobe("\nWarning: TNODEOUT = 1 requesting an external temperature node, but a fifth node for temperature is not supplied.");
            end
        end
    end else begin
        Temp(t) <+ 0.0;
    end
    // Parameters for self-heating effects
    if ((SHMOD != 0) && (RTH0 > 0.0) && (Weff_SH > 0.0)) begin
        gth = Weff_SH * NF / RTH0;
        cth = CTH0 * Weff_SH * NF;
    end else begin
        // Set gth to some value to prevent a singular G matrix
        gth = 1.0;
        cth = 0.0;
    end

    // Temperature-dependent calculations
    if (TNOM <= -`P_CELSIUS0) begin
        T0 = `REFTEMP - `P_CELSIUS0;
        $strobe("Warning: TNOM = %e C <= %e C. Setting TNOM to %e C.", TNOM, -`P_CELSIUS0, T0);
        Tnom = `REFTEMP;
    end else begin
        Tnom = TNOM + `P_CELSIUS0;
    end
    DevTemp = $temperature + DTEMP;

    // Calculate temperature dependent values for self-heating effects
    if ((SHMOD != 0) && (RTH0 > 0.0)) begin
        if (TNODEOUT != 0 && !$port_connected(t)) begin
            if ($port_connected(b)) begin
                delTemp1 = V(b);
            end else begin //'t' is an internal node
                delTemp1 = Temp(t);
            end
        end else begin
            delTemp1 = Temp(t);
        end
    end else begin
        delTemp1 = 0.0;
    end
    DevTemp    = delTemp1 + DevTemp;
    if (($param_given(TEMPH)) && (DevTemp > TEMPH)) begin
        $strobe("Warning: Device temperature %e K exceeds maximum specified value of %e K!", DevTemp, TEMPH);
    end
    T_DELTA_SH = Temp(t);
    T_TOTAL_K  = DevTemp;
    T_TOTAL_C  = DevTemp - `P_CELSIUS0;
    Vt         = KboQ * DevTemp;
    inv_Vt     = 1.0 / Vt;
    TRatio     = DevTemp / Tnom;
    delTemp    = DevTemp - Tnom;
    Vtm        = KboQ * DevTemp;
    Vtm0       = KboQ * Tnom;
    Eg         = BG0SUB - TBGASUB * DevTemp * DevTemp / (DevTemp + TBGBSUB);
    T1         = (DevTemp / Tnom) * sqrt(DevTemp / Tnom);
    ni         = NI0SUB * T1 * lexp(Eg / (2.0 * Vtm0) - Eg / (2.0 * Vtm));
    if ((SHMOD != 0) && (RTH0 > 0.0) && (Weff_SH > 0.0)) begin
        T0   = lln(NDEP_i / ni);
        phib = sqrt(T0 * T0 + 1.0e-6);
    end else begin
        phib = lln(NDEP_i / ni);
    end
    if ((SHMOD != 0) && (RTH0 > 0.0) && (Weff_SH > 0.0)) begin
        T0  = lln(NDEPEDGE_i * NSD_i / (ni * ni));
        Vbi_edge = sqrt(T0 * T0 + 1.0e-6);

    end else begin
        Vbi_edge = lln(NDEPEDGE_i * NSD_i / (ni * ni));

    end
    if (NGATE_i > 0.0) begin
        Vfbsdr = -devsign * Vt * lln(NGATE_i / NSD_i) + VFBSDOFF;
    end else begin
        Vfbsdr = 0.0;
    end

    if ($port_connected(b) == 0) begin
        if (BODYMOD != 0) begin
            $strobe("\nWarning: b-node is not connected, however BODYMOD != 0. Assuming Floating-body device!");
        end
        if (MODAGBCP2 != 0) begin
            $strobe("\nWarning: MODAGBCP2 should be set to 0 as it is a floating-body device!");
        end
    end else begin
        if (TNODEOUT && !$port_connected(t)) begin
            $strobe("\nWarning: last node is b which is a thermal node. Assuming Floating body device!");
            if (MODAGBCP2 != 0) begin
                $strobe("\nWarning: MODAGBCP2 should be set to 0 as it is a floating-body device!");
            end
        end else begin
            if (BODYMOD == 0) begin
                $strobe("\nWarning: b-node is connected, however BODYMOD = 0. Assuming Floating-body device!");
                if (MODAGBCP2 != 0) begin
                    $strobe("\nWarning: MODAGBCP2 should be set to 0 as it is a floating-body device!");
                end
            end
        end
    end
    if ( (BODYMOD !=0) && ($port_connected (b) == 1) && !((TNODEOUT == 1) && ($port_connected(t) == 0))) begin
        if (MODAGBCP2 == 0) begin
            $strobe("\nWarning: MODAGBCP2 should be set to 1 as it is a body-contacted device!");
        end
    end

    // Short channel effects
    Phist     = max(0.4 + Vt * phib + PHIN_i, 0.4);
    sqrtPhist = sqrt(Phist);
    T1DEP     = sqrt(2.0 * epssi / (`P_Q_NIST1998 * NDEP_i));
    litl      = sqrt((epssi / epsox) * TOXE * XJ_i);
    NFACTOR_t = NFACTOR_i * hypsmooth((1.0 + TNFACTOR * (TRatio - 1.0)), 1e-3);
    ETA0_t    = ETA0_i * (1.0 + TETA0 * (TRatio - 1.0));
    if (ASYMMOD != 0) begin
        ETA0R_t = ETA0R_i * (1.0 + TETA0 * (TRatio - 1.0));
    end

    // Mobility degradation
    eta_mu = (TYPE != `ntype) ? (`Oneby3 * ETAMOB) : (0.5 * ETAMOB);
    U0_t   = U0_i * pow(TRatio, UTE_i);
    UA_t   = UA_i * hypsmooth(1.0 + UA1_i * delTemp - 1.0e-6, 1.0e-3);
    UC_t   = UC_i * hypsmooth(1.0 + UC1_i * delTemp - 1.0e-6, 1.0e-3);
    UD_t   = UD_i * pow(TRatio, UD1_i);
    UDB_t   = UDB_i * pow(TRatio, UDB1_i);
    UCS_t  = UCS_i * pow(TRatio, UCSTE_i);
    EU_t   = EU_i * hypsmooth((1.0 + EU1_i * (TRatio - 1.0)), 1e-3);
    if (ASYMMOD != 0) begin
        U0R_t  = U0R_i * pow(TRatio, UTE_i);
        UAR_t  = UAR_i * hypsmooth(1.0 + UA1_i * delTemp - 1.0e-6, 1.0e-3);
        UCR_t  = UCR_i * hypsmooth(1.0 + UC1_i * delTemp - 1.0e-6, 1.0e-3);
        UDR_t  = UDR_i * pow(TRatio, UD1_i);
        UDBR_t  = UDBR_i * pow(TRatio, UDB1_i);
        UCSR_t = UCSR_i * pow(TRatio, UCSTE_i);
    end
    rdstemp = pow(TRatio, PRT_i);
    VSAT_t  = VSAT_i * pow(TRatio, -AT_i);
    if (VSAT_t < 100.0) begin
        VSAT_t = 100.0;
    end

    if (ASYMMOD != 0) begin
        VSATR_t = VSATR_i * pow(TRatio, -AT_i);
        if (VSATR_t < 100.0) begin
            VSATR_t = 100.0;
        end
    end
    VSATCV_t = VSATCV_i * pow(TRatio, -AT_i);
    if (VSATCV_t < 100.0) begin
        VSATCV_t = 100.0;
    end
    DELTA_t = 1.0 / ( hypsmooth((1.0 / DELTA_i) * (1.0 + TDELTA * delTemp) - 2.0 , 1.0e-3) + 2.0);
    PTWG_t  = PTWG_i * hypsmooth(1.0 - PTWGT_i * delTemp - 1.0e-6, 1.0e-3);
    if (ASYMMOD != 0) begin
        PTWGR_t = PTWGR_i * hypsmooth(1.0 - PTWGT_i * delTemp - 1.0e-6, 1.0e-3);
    end
    A1_t    = A1_i * hypsmooth(1.0 + A11_i * delTemp - 1.0e-6, 1.0e-3);
    A2_t    = A2_i * hypsmooth(1.0 + A21_i * delTemp - 1.0e-6, 1.0e-3);
    BETA0_t = BETA0_i * pow(TRatio, IIT_i);
    BGIDL_t = BGIDL_i + BGIDL1_i * (TRatio - 1.0);
    BGISL_t = BGISL_i + BGISL1_i * (TRatio - 1.0);
    igtemp  = lexp(IGT_i * lln(TRatio));
    K0_t    = K0_i * hypsmooth(1.0 + K01_i * delTemp - 1.0e-6, 1.0e-3);
    M0_t    = M0_i * hypsmooth(1.0 + M01_i * delTemp - 1.0e-6, 1.0e-3);
    C0_t    = C0_i * hypsmooth(1.0 + C01_i * delTemp - 1.0e-6, 1.0e-3);
    C0SI_t  = C0SI_i * hypsmooth(1.0 + C0SI1_i * delTemp - 1.0e-6, 1.0e-3);
    C0SISAT_t = C0SISAT_i * hypsmooth(1.0 + C0SISAT1_i * delTemp - 1.0e-6, 1.0e-3);

    // Diode model temperature effects
    CJS_t     = CJS * hypsmooth(1.0 + TCJ * delTemp - 1.0e-6, 1.0e-3);
    CJD_t     = CJD * hypsmooth(1.0 + TCJ * delTemp - 1.0e-6, 1.0e-3);
    CJSWS_t   = CJSWS * hypsmooth(1.0 + TCJSW * delTemp - 1.0e-6, 1.0e-3);
    CJSWD_t   = CJSWD * hypsmooth(1.0 + TCJSW * delTemp - 1.0e-6, 1.0e-3);
    CJSWGS_t  = CJSWGS * hypsmooth(1.0 + TCJSWG * delTemp - 1.0e-6, 1.0e-3);
    CJSWGD_t  = CJSWGD * hypsmooth(1.0 + TCJSWG * delTemp - 1.0e-6, 1.0e-3);
    PBS_t     = hypsmooth(PBS - TPB * delTemp - 0.01, 1.0e-3) + 0.01;
    PBD_t     = hypsmooth(PBD - TPB * delTemp - 0.01, 1.0e-3) + 0.01;
    PBSWS_t   = hypsmooth(PBSWS - TPBSW * delTemp - 0.01, 1.0e-3) + 0.01;
    PBSWD_t   = hypsmooth(PBSWD - TPBSW * delTemp - 0.01, 1.0e-3) + 0.01;
    PBSWGS_t  = hypsmooth(PBSWGS - TPBSWG * delTemp - 0.01, 1.0e-3) + 0.01;
    PBSWGD_t  = hypsmooth(PBSWGD - TPBSWG * delTemp - 0.01, 1.0e-3) + 0.01;

    // Effective S/D junction area and perimeters
    `BSIMBULKPAeffGeo(NF, GEOMOD, MINZ, Weffcj, DMCGeff, DMCIeff, DMDGeff, temp_PSeff, temp_PDeff, temp_ASeff, temp_ADeff)
    if ($param_given(AS)) begin
        ASeff = AS * WMLT * LMLT;
    end else begin
        ASeff = temp_ASeff;
    end
    if (ASeff < 0.0) begin
        $strobe("Warning: (instance %M) ASeff = %e is negative. Set to 0.0.", ASeff);
        ASeff = 0.0;
    end
    if ($param_given(AD)) begin
        ADeff = AD * WMLT * LMLT;
    end else begin
        ADeff = temp_ADeff;
    end
    if (ADeff < 0.0) begin
        $strobe("Warning: (instance %M) ADeff = %e is negative. Set to 0.0.", ADeff);
        ADeff = 0.0;
    end
    if ($param_given(PS)) begin
        if (PERMOD == 0) begin
            // PS does not include gate-edge perimeters
            PSeff = PS * WMLT;
        end else begin
            // PS includes gate-edge perimeters
            PSeff = max(PS * WMLT - Weffcj * NF, 0.0);
        end
    end else begin
        PSeff = temp_PSeff;
        if (PSeff < 0.0) begin
            $strobe("Warning: (instance %M) PSeff = %e is negative. Set to 0.0.", PSeff);
            PSeff = 0.0;
        end
    end
    if ($param_given(PD)) begin
        if (PERMOD == 0) begin
            // PD does not include gate-edge perimeters
            PDeff = PD * WMLT;
        end else begin
            // PD includes gate-edge perimeters
            PDeff = max(PD * WMLT - Weffcj * NF, 0.0);
        end
    end else begin
        PDeff = temp_PDeff;
        if (PDeff < 0.0) begin
            $strobe("Warning: (instance %M) PDeff = %e is negative. Set to 0.0.", PDeff);
            PDeff = 0.0;
        end
    end

    // STI stress equations
    if ((SA > 0.0) && (SB > 0.0) && ((NF == 1.0) || ((NF > 1.0) && (SD > 0.0)))) begin
        T0              = pow(Lnew, LLODKU0);
        W_tmp_stress    = Wnew + WLOD;
        T1              = pow(W_tmp_stress, WLODKU0);
        tmp1_stress     = LKU0 / T0 + WKU0 / T1 + PKU0 / (T0 * T1);
        kstress_u0      = 1.0 + tmp1_stress;
        T0              = pow(Lnew, LLODVTH);
        T1              = pow(W_tmp_stress, WLODVTH);
        tmp1_stress_vth = LKVTH0 / T0 + WKVTH0 / T1 + PKVTH0 / (T0 * T1);
        kstress_vth0    = 1.0 + tmp1_stress_vth;
        T0              = TRatio - 1.0;
        ku0_temp        = kstress_u0 * (1.0 + TKU0 * T0) + 1.0e-9;
        for (i = 0; i < NF; i = i + 1) begin: forloop
            T0     = 1.0 / NF / (SA + 0.5 * L_mult + i * (SD + L_mult));
            T1     = 1.0 / NF / (SB + 0.5 * L_mult + i * (SD + L_mult));
            Inv_sa = Inv_sa + T0;
            Inv_sb = Inv_sb + T1;
        end
        Inv_saref   = 1.0 / (SAREF + 0.5 * L_mult);
        Inv_sbref   = 1.0 / (SBREF + 0.5 * L_mult);
        Inv_odref   = Inv_saref + Inv_sbref;
        rho_ref     = (KU0 / ku0_temp) * Inv_odref;
        Inv_od      = Inv_sa + Inv_sb;
        rho         = (KU0 / ku0_temp) * Inv_od;
        mu0_mult    = (1.0 + rho) / (1.0 + rho_ref);
        vsat_mult   = (1.0 + rho * KVSAT) / (1.0 + rho_ref * KVSAT);
        vth0_stress = (KVTH0 / kstress_vth0) * (Inv_od - Inv_odref);
        k2_stress   = (STK2 / pow(kstress_vth0, LODK2)) * (Inv_od - Inv_odref);
        eta_stress  = (STETA0 / pow(kstress_vth0, LODETA0)) * (Inv_od - Inv_odref);
        U0_t        = U0_t * mu0_mult;
        VSAT_t      = VSAT_t * vsat_mult;
        K2_i        = K2_i + k2_stress;
        ETA0_t      = ETA0_t + eta_stress;
        if (EDGEFET == 1) begin
            vth0_stress_EDGE = (KVTH0EDGE_i / kstress_vth0) * (Inv_od - Inv_odref);
            k2_stress_EDGE   = (STK2EDGE_i / pow(kstress_vth0, LODK2)) * (Inv_od - Inv_odref);
            eta_stress_EDGE  = (STETA0EDGE_i / pow(kstress_vth0, LODETA0)) * (Inv_od - Inv_odref);
        end
        K2EDGE_i   = K2EDGE_i + k2_stress_EDGE;
        ETA0EDGE_i = ETA0EDGE_i + eta_stress_EDGE;
    end else begin
        vth0_stress = 0.0;
        vth0_stress_EDGE = 0.0;
    end

    // Well proximity effect
    if (WPEMOD == 1) begin
        Wdrn      = W / NF;
        local_sca = SCA;
        local_scb = SCB;
        local_scc = SCC;
        if (!$param_given(SCA) && !$param_given(SCB) && !$param_given(SCC)) begin
            if ($param_given(SC) && SC > 0.0) begin
                T1        = SC + Wdrn;
                T2        = 1.0 / SCREF;
                local_sca = SCREF * SCREF / (SC * T1);
                local_scb = ((0.1 * SC + 0.01 * SCREF) * lexp(-10.0 * SC * T2)  - (0.1 * T1 + 0.01 * SCREF) *
                            lexp(-10.0 * T1 * T2)) / Wdrn;
                local_scc = ((0.05 * SC + 0.0025 * SCREF) * lexp(-20.0 * SC * T2)  - (0.05 * T1 + 0.0025 * SCREF) *
                            lexp(-20.0 * T1 * T2)) / Wdrn;
            end else begin
                `STROBE("Warning: (Instance %M) No WPE as none of SCA, SCB, SCC, SC is given and/or SC not positive.");
            end
        end
    end
    vth0_well      = KVTH0WE_i * (local_sca + WEB * local_scb + WEC * local_scc);
    k2_well        = K2WE_i * (local_sca + WEB * local_scb + WEC * local_scc);
    vth0_well_edge = KVTH0EDGEWE_i * (local_sca + WEB * local_scb + WEC * local_scc);
    k2_well_edge   = K2EDGEWE_i * (local_sca + WEB * local_scb + WEC * local_scc);
    mu_well        = 1.0 + KU0WE_i * (local_sca + WEB * local_scb + WEC * local_scc);
    U0_t           = U0_t * mu_well;
    K2_i           = K2_i + k2_well;
    K2EDGE_i       = K2EDGE_i + k2_well_edge;

    // Load terminal voltages
    Vg            = devsign * V(gi, bi);
    Vg1           = devsign * V(gi, bi2);
    Vd            = devsign * V(di, bi);
    Vs            = devsign * V(si, bi);
    Vs1           = devsign * V(si, bi2);
    Vds           = Vd - Vs;
    Vds_noswap    = Vds;
    Vsb_noswap    = Vs;
    Vdb_noswap    = Vd;
    Vbs_jct       = devsign * V(bi, si);
    Vbd_jct       = devsign * V(bi, di);
    Vgd_noswap    = Vg - Vd;
    Vgs_noswap    = Vg - Vs;
    Vgd_ov_noswap = devsign * V(gm, di);
    Vgs_ov_noswap = devsign * V(gm, si);

    //Introduced e terminal : substrate terminal
    Ve            = devsign * V(e, bi);
    Ve1           = devsign * V(e, bi2);
    Ves           = Ve - Vs;
    ves           = Ve - Vs;
    ved           = Ve - Vd;
    Vbs           = -devsign * V(si, bi);

    // Terminal voltage conditioning
    // Source-drain interchange
    sigvds = 1.0;
    if (Vds < 0.0) begin
        sigvds = -1.0;
        Vd = devsign * V(si, bi);
        Vs = devsign * V(di, bi);
        Vs1 = devsign * V(di, bi2);
        Ves = Ve - Vs;
        Vbs = -devsign * V(di, bi);

    end
    Vds  = Vd - Vs;
    T0   = AVDSX * Vds;
    if (T0 > `EXPL_THRESHOLD) begin
        T1 = T0;
    end else begin
        T1 = ln(1.0 + lexp(T0));
    end
    Vdsx = ((2.0 / AVDSX) * T1) - Vds - ((2.0 / AVDSX) * ln(2.0));
    Vbsx = -(Vs + 0.5 * (Vds - Vdsx));
    Vbsx1 = -(Vs1 + 0.5 * (Vds - Vdsx));
    Vesx  = Ve + 0.5 * (Vdsx - Vds);

    // Asymmetry model
    T0 = tanh(0.6 * Vds_noswap / Vtm);
    wf = 0.5 + 0.5 * T0;
    wr = 1.0 - wf;
    if (ASYMMOD != 0) begin
        CDSCDEDGE_a = CDSCDEDGER_i * wr + CDSCDEDGE_i * wf;
        CDSCD_a     = CDSCDR_i * wr + CDSCD_i * wf;
        ETA0_a      = ETA0R_t * wr + ETA0_t * wf;
        PDIBLC_a    = PDIBLCR_i * wr + PDIBLC_i * wf;
        PCLM_a      = PCLMR_i * wr + PCLM_i * wf;
        PSAT_a      = PSATR_i * wr + PSAT_i * wf;
        VSAT_a      = VSATR_t * wr + VSAT_t * wf;
        PTWG_a      = PTWGR_t * wr + PTWG_t * wf;
        U0_a        = U0R_t * wr + U0_t * wf;
        UA_a        = UAR_t * wr + UA_t * wf;
        UC_a        = UCR_t * wr + UC_t * wf;
        UD_a        = UDR_t * wr + UD_t * wf;
        UDB_a       = UDBR_t * wr + UDB_t * wf;
        UCS_a       = UCSR_t * wr + UCS_t * wf;
    end else begin
        CDSCDEDGE_a = CDSCDEDGE_i;
        CDSCD_a     = CDSCD_i;
        ETA0_a      = ETA0_t;
        PDIBLC_a    = PDIBLC_i;
        PCLM_a      = PCLM_i;
        PSAT_a      = PSAT_i;
        VSAT_a      = VSAT_t;
        PTWG_a      = PTWG_t;
        U0_a        = U0_t;
        UA_a        = UA_t;
        UC_a        = UC_t;
        UD_a        = UD_t;
        UDB_a        = UDB_t;
        UCS_a       = UCS_t;
    end

    //SOIMOD=1 additional effects Back-gate bias dependence
    sclf = sqrt(epsratio * TSI * TOXE);
    sclm = sqrt(TSI * (epsratio * TOXE + 0.375 * TSI));
    teff       = TSI + epsratio * (TOXE + TBOX);
    T0   = ((Vg - VFB_i) * (TBOX * epsratio) + (Ve - VFBB_i) * (TOXE * epsratio + TSI)) / teff ;
    T1   = atan(ASCL_i + BSCL_i * T0) / `M_PI + 0.5;
    scl  = sclm + T1 * (sclf - sclm);

    tmp = DVT1_i * Leff / scl + 1.0e-6;

    if (tmp < 40.0) begin
        Theta_SCE = 0.5 / (cosh(tmp) - 1.0);
    end else begin
        Theta_SCE = lexp(-tmp);
    end

    // SCE, DIBL, SS degradation effects, Ref: BSIM4
    CB = epssi / TSI;
    CBOX = epsox / TBOX;
    `Smooth(Phist - Vbsx, 0.05, 0.1, PhistVbs)
    sqrtPhistVbs = sqrt(PhistVbs);
    Xdep         = T1DEP * sqrtPhistVbs;
    Cdep         = epssi / Xdep;
    cdsc         = CIT_i + NFACTOR_t + CDSCD_a * Vdsx - CDSCB_i * Vbsx;
    T1           = 1.0 + cdsc/Cox;
    if (SOIMOD == 1) begin
        T2        = CB * CBOX / (CB + CBOX);
        T3        = (CDSCD_a + CSECSED * Vesx - CBCBD * Vbsx) * Vdsx;
        T4        = CSECSE0 * Vesx + CSECSE0P * Vesx * Vesx - CBCB0 *Vbsx - CBCB0P *Vbsx*Vbsx  + Theta_SCE * (CDSC_i + CSECSE_i * Vesx + CSECSEP * Vesx * Vesx + CBCB_i *Vbsx + CBCBP *Vbsx * Vbsx+ T3);
        T1        =  (Cox + T2 + CIT_i + NFACTOR_t + T4) / (Cox + T2);
    end
    `Smooth(T1, 1.0, 0.05, n)
    nVt     = n * Vt;
    inv_nVt = 1.0 / nVt;

    // Vth shift for DIBL
    dVth_dibl = -(ETA0_a + ETAB_i * Vbsx) * Vdsx;
    `Smooth2(dVth_dibl, 0.0, 5.0e-5, dVth_dibl)

    // Vth shift with temperature
    dvth_temp = (KT1_i + KT1L / Leff + KT2_i * Vbsx) * (pow(TRatio, KT1EXP) - 1.0);

    // Vth correction for pocket implants
    if (DVTP0_i > 0.0) begin
        T0 = -DVTP1_i * Vdsx;
        if (T0 < -`EXPL_THRESHOLD) begin
            T2 = `MIN_EXPL;
        end else begin
            T2 = lexp(T0);
        end
        T3        = Leff + DVTP0_i * (1.0 + T2);
        dVth_ldop = -nVt * lln(Leff / T3);
    end else begin
        dVth_ldop = 0.0;
    end
    T4        = DVTP5_i + DVTP2_i / pow(Leff, DVTP3_i);
    dVth_ldop = dVth_ldop - T4 * tanh(DVTP4_i * Vdsx);

    // Normalization of terminal and flatband voltage by nVt
    VFB_i = VFB_i + DELVTO;
    vg    = Vg * inv_nVt;
    vs    = Vs * inv_nVt;
    vfb   = VFB_i * inv_nVt;
    vfbb  = VFBB_i * inv_nVt;
    ve = Ve * inv_nVt;

    // Compute dVth_VNUD with "first-order" and "second-order" body-bias effect
    dVth_VNUD = K1_i * (sqrtPhistVbs - sqrtPhist) - K2_i * Vbsx;
    Vth_shift = dVth_dibl + dVth_ldop + dVth_VNUD - dvth_temp + vth0_stress + vth0_well;
    vgfb      = vg - vfb - Vth_shift * inv_nVt;

    vgsfb = vg - Vbsx * inv_nVt - vfb - Vth_shift * inv_nVt;

    //Normalized terminal voltages for DDMOD
    vgfb1 = vg - vfb  - Vth_shift * inv_nVt;
    vgfbb = ve - vfbb;

    // Threshold voltage for operating point information
    gam     = sqrt(2.0 * `P_Q_NIST1998 * epssi * NDEP_i * inv_Vt) / Cox;
    q_vth   = 0.5;
    T0      = hypsmooth((2.0 * phib + Vs * inv_Vt), 1.0e-3);
    nq      = 1.0 + gam / (2.0 * sqrt(T0));
    psip_th = hypsmooth((Vs * inv_Vt + 2.0 * phib + lln(q_vth) + 2.0 * q_vth + lln(2.0 * nq / gam * (2.0 * q_vth * nq / gam + 2.0 * sqrt(T0)))), 1.0e-3);
    VTH     = devsign * (VFB_i + (psip_th - Vs * inv_Vt) * Vt + Vt * gam * sqrt(psip_th) + Vth_shift);
    inv_gam = 1.0 / gam;
    if (SOIMOD == 1) begin
        // Normalized body factor
        gam     = sqrt(2.0 * `P_Q_NIST1998 * epssi * NDEP_i * inv_nVt) / Cox;
        inv_gam = 1.0 / gam;
        gam2 = gam * gam;
        inv_gam2 = 1.0 / gam2;
        // DD Model Back potential solved independently for PD decoupled case.
        CB = epssi / TSI;
        CBOX = epsox / TBOX;
        RC= (CBOX +CDSBS_i) / CB ;
        RT = TOXE / TBOX ;
        gam_sb = gam / RT;
        x1_sb = 1.0 + gam_sb * `invSqrt2;
        limit_sb = 1.0e-7 * x1_sb;
        x1_csb         =  5.0/4.0;
        inv_xi_sb = (1.0/gam_sb);
        gam_sb2 = gam_sb*gam_sb;
        inv_xg1_sb  =  1.0 / (x1_csb + gam_sb * 7.324648775608221e-1);
        if (abs(vgfbb) <= limit_sb) begin
            pd_sb        =  ((-vgfbb ) * inv_xi_sb)*(1.0+gam_sb*((-vgfbb /(6.0*sqrt(2.0)*x1_sb*x1_sb))));
        end else begin
            if (vgfbb  < (-limit_sb)) begin
                PD_yg    =  -vgfbb ;
                PD_z     =  x1_csb * PD_yg  * inv_xi_sb;
                PD_eta   =  0.5 * (PD_z  + 10.0 - sqrt((PD_z  - 6.0) * (PD_z  - 6.0) + 64.0));
                PD_a     =  (PD_yg   - PD_eta) * (PD_yg   - PD_eta) + gam_sb2 * (PD_eta  + 1.0);
                PD_c     =  2.0 * (PD_yg   - PD_eta) - gam_sb2;
                PD_tau   =  lln(PD_a  / gam_sb2) - PD_eta ;
                `sigma0(PD_a, PD_c, PD_tau, PD_eta, PD_y0)
                PD_D0    =  lexp(PD_y0);
                PD_temp  =  PD_yg  - PD_y0 ;
                PD_p     =  2.0 * PD_temp  + gam_sb2 * (PD_D0  - 1.0);
                PD_q     =  PD_temp  * PD_temp  + gam_sb2 * (PD_y0  + 1.0 - PD_D0 );
                PD_xi    =  1.0 - gam_sb2 * 0.5 * PD_D0 ;
                PD_temp  =  PD_p  * PD_p  - 4.0 * (PD_xi  * PD_q );
                PD_w     =  2.0 * (PD_q  / (PD_p  + sqrt(PD_temp )));
                pd_sb    = -(PD_y0  + PD_w );
            end else begin
                PD_Afac  =  (x1_sb * x1_csb * inv_xg1_sb - 1.0) * inv_xg1_sb;
                PD_xbar  =  vgfbb  * inv_xi_sb * (1.0 + PD_Afac * vgfbb );
                PD_temp1 = lexp(-PD_xbar);
                PD_w1    =  1.0 - PD_temp1;
                PD_x0    =  vgfbb  + gam_sb2 * 0.5 - gam_sb * sqrt(vgfbb  + gam_sb2 * 0.25 - PD_w1 );
                PD_D01   =  lexp(-PD_x0);
                PD_p1    =  2.0 * (vgfbb - PD_x0 ) + gam_sb2 * (1.0 - PD_D01 );
                PD_q1    =  (vgfbb  - PD_x0 ) * (vgfbb  - PD_x0 ) - gam_sb2 * (PD_x0  - 1.0 + PD_D01 );
                PD_xi1   =  1.0 - gam_sb2 * 0.5 * PD_D01 ;
                PD_temp1 =  PD_p1  * PD_p1  - 4.0 * (PD_xi1  * PD_q1 );
                PD_u     =  2.0 * (PD_q1  / (PD_p1  + sqrt(PD_temp1 )));
                pd_sb    =  PD_x0  + PD_u ;
            end
        end
        // One iteration given to correct value even at 10th decimal point
        if (abs(vgfbb)  < (limit_sb)) begin
            phisb0=((-vgfbb ) * inv_xi_sb)*(1.0+gam_sb*((-vgfbb /(6.0*sqrt(2.0)*x1_sb*x1_sb))));
            pd_sb=((-vgfbb ) * inv_xi_sb)*(1.0+gam_sb*((-vgfbb /(6.0*sqrt(2.0)*x1_sb*x1_sb))));
        end else begin
            fx = RT*RT*(vgfbb - pd_sb)*(vgfbb - pd_sb)*(1.0/gam)*(1.0/gam) -(lexp(-pd_sb) + pd_sb -1.0);
            f_x = lexp(-pd_sb) + (RT*RT*(2.0*pd_sb - 2.0*vgfbb))/(gam*gam) - 1.0;
            phisb0 =(pd_sb)-(fx /f_x );
        end
        phisb0=phisb0* nVt;

        // DD-MODEL core source side surface potential
        /* Surface potential at source side  DD-MODEL*/
        x1           =  1.0 + gam * `invSqrt2;
        inv_x1       =  1.0 /  x1;
        phisf         =  2.0 * phib/n + vs ;
        exp_ns     =  lexp(-phisf);
        limit       =  1.0e-3 * x1;
        T0 = -DVBD1_i * Leff / litl;
        T1 = DVBD0_i * (lexp(0.5*T0) + 2.0*lexp(T0)) * (0.0 + VSCE_i);
        phic_star  = (1.0 + LPE1_i / Leff)*(`P_Q_NIST1998 * NDEP_i * TSI * TSI) / (2.0 * epssi * nVt) + VBSA/nVt - RC * (vgfbb);
        vg_FD = phic_star + gam * sqrt(lexp(-phic_star) + phic_star -1.0) ;

        if (vgfb1 < (vg_FD)) begin
            //PD initial Guess
            if (abs(vgfb1) <= limit) begin
                T0 =  inv_x1 * inv_x1 * `oneSixth * `invSqrt2;
                sp_dd         =  vgfb1 * inv_x1 * (1.0 + vgfb1 * (1.0 - (exp_ns)) * gam * T0);
            end else begin
                if (vgfb1 < (-limit)) begin
                    SP_S_yg   = -vgfb1;
                    SP_S_ysub   = 1.25 * (SP_S_yg * inv_x1);
                    SP_S_eta  =  0.5 * (SP_S_ysub + 10.0 - sqrt((SP_S_ysub - 6.0) * (SP_S_ysub - 6.0) + 64.0));
                    SP_S_temp   = SP_S_yg - SP_S_eta;
                    SP_S_a      = SP_S_temp * SP_S_temp + gam2 * (SP_S_eta + 1.0);
                    SP_S_c      = 2.0 * SP_S_temp - gam2;
                    SP_S_tau    = -SP_S_eta + lln(SP_S_a * inv_gam2);
                    `sigma0(SP_S_a, SP_S_c, SP_S_tau, SP_S_eta, SP_S_y0)
                    SP_S_delta0 = lexp(SP_S_y0);
                    SP_S_delta1 = 1.0 / SP_S_delta0;
                    SP_S_temp   = 1.0 / (2.0 + SP_S_y0 * SP_S_y0);
                    SP_S_xi0    = SP_S_y0 * SP_S_y0 * SP_S_temp;
                    SP_S_xi1    = 4.0 * (SP_S_y0 * SP_S_temp * SP_S_temp);
                    SP_S_xi2    = (8.0 * SP_S_temp - 12.0 * SP_S_xi0) * SP_S_temp * SP_S_temp;
                    SP_S_temp   = SP_S_yg - SP_S_y0;
                    SP_S_temp1  = (exp_ns) * SP_S_delta1;
                    SP_S_pC     = 2.0 * SP_S_temp + gam2 * (SP_S_delta0 - 1.0 - SP_S_temp1 + (exp_ns) * (1.0 - SP_S_xi1));
                    SP_S_qC     = SP_S_temp * SP_S_temp - gam2 * (SP_S_delta0 - SP_S_y0 - 1.0 + SP_S_temp1 + (exp_ns) * (SP_S_y0 - 1.0 - SP_S_xi0));
                    SP_S_temp   = 2.0 - gam2 * (SP_S_delta0 + SP_S_temp1 - (exp_ns) * SP_S_xi2);
                    SP_S_temp   = SP_S_pC * SP_S_pC - 2.0 * (SP_S_qC * SP_S_temp);
                    SP_S_temp   = sqrt(SP_S_temp * SP_S_temp + 64e-8) - 8e-4;
                    sp_dd       = -SP_S_y0 - 2.0 * (SP_S_qC / (SP_S_pC + sqrt(SP_S_temp)));
                end else begin
                    SP_xg1    = 1.0 / (1.25 + gam * 7.324648775608221e-001);
                    SP_S_A_fac= (x1 * 1.25 * SP_xg1 - 1.0) * SP_xg1;
                    SP_S_xbar = vgfb1 * inv_x1 * (1.0 + SP_S_A_fac * vgfb1);
                    SP_S_temp = lexp(-SP_S_xbar);
                    SP_S_w    = 1.0 - SP_S_temp;
                    SP_S_x1   = vgfb1 + gam2 * 0.5 - gam * sqrt(vgfb1 + gam2 * 0.25 - SP_S_w);
                    SP_S_bx   = (phisf) + 3.0;
                    SP_S_eta  = `MINF(SP_S_x1, SP_S_bx, 5.0) - 0.5 * (SP_S_bx - sqrt(SP_S_bx * SP_S_bx + 5.0));
                    SP_S_temp = vgfb1 - SP_S_eta;
                    SP_S_temp1= lexp(-SP_S_eta);
                    SP_S_temp2= 1.0 / (2.0 + SP_S_eta * SP_S_eta);
                    SP_S_xi0  = SP_S_eta * SP_S_eta * SP_S_temp2;
                    SP_S_xi1  = 4.0 * (SP_S_eta * SP_S_temp2 * SP_S_temp2);
                    SP_S_xi2  = (8.0 * SP_S_temp2 - 12.0 * SP_S_xi0) * SP_S_temp2 * SP_S_temp2;
                    SP_S_a    = max(1.0e-40, SP_S_temp * SP_S_temp - gam2 * (SP_S_temp1 + SP_S_eta - 1.0 - (exp_ns) * (SP_S_eta + 1.0 + SP_S_xi0)));
                    SP_S_b    = 1.0 - 0.5 * (gam2 * (SP_S_temp1 - (exp_ns) * SP_S_xi2));
                    SP_S_c    = 2.0 * SP_S_temp + gam2 * (1.0 - SP_S_temp1 - (exp_ns) * (1.0 + SP_S_xi1));
                    SP_S_tau  = (phisf) - SP_S_eta + lln(SP_S_a / gam2);
                    `sigma1(SP_S_a, SP_S_b, SP_S_c, SP_S_tau, SP_S_eta, SP_S_x0)
                    SP_S_delta0 = lexp(SP_S_x0);
                    SP_S_delta1 = 1.0 / SP_S_delta0;
                    SP_S_delta0 = lexp(SP_S_x0 - phisf);
                    SP_S_temp   = 1.0 / (2.0 + SP_S_x0 * SP_S_x0);
                    SP_S_xi0    = SP_S_x0 * SP_S_x0 * SP_S_temp;
                    SP_S_xi1    = 4.0 * (SP_S_x0 * SP_S_temp * SP_S_temp);
                    SP_S_xi2    = (8.0 * SP_S_temp - 12.0 * SP_S_xi0) * SP_S_temp * SP_S_temp;
                    SP_S_temp   = vgfb1 - SP_S_x0;
                    SP_S_pC     = 2.0 * SP_S_temp + gam2 * (1.0 - SP_S_delta1 + SP_S_delta0 - (exp_ns) * (1.0 + SP_S_xi1));
                    SP_S_qC     = SP_S_temp * SP_S_temp - gam2 * (SP_S_delta1 + SP_S_x0 - 1.0 + SP_S_delta0 - (exp_ns) * (SP_S_x0 + 1.0 + SP_S_xi0));
                    SP_S_temp   = 2.0 - gam2 * (SP_S_delta1 + SP_S_delta0 - (exp_ns) * SP_S_xi2);
                    SP_S_temp   = SP_S_pC * SP_S_pC - 2.0 * (SP_S_qC * SP_S_temp);
                    SP_S_temp   = sqrt(SP_S_temp * SP_S_temp + 64e-8) - 8e-4;
                    sp_dd       = SP_S_x0 + 2.0 * (SP_S_qC / (SP_S_pC + sqrt(SP_S_temp)));
                end
            end
        end else begin
            //FD initial Guess
            zeta    = RT;
            zeta2   = zeta * zeta;
            u_crit  = phic_star - phisb0 * inv_nVt;
            usf_FD  = vgfb1 - gam * sqrt(lexp(-u_crit) + u_crit -1.0) ;
            SP_S_bx = (phisf) + 3.0;
            SP_S_Z0 =  `MINF(usf_FD, SP_S_bx, 40.0);
            a_fd = ((vgfb1-SP_S_Z0) * (vgfb1-SP_S_Z0) - zeta2 * (vgfbb-SP_S_Z0 + phic_star) * (vgfbb-SP_S_Z0+phic_star) - gam2 * (phic_star));
            c_fd = 2.0 * (vgfb1 - SP_S_Z0 ) - 2.0 * zeta2 * (vgfbb - SP_S_Z0 + phic_star) ;
            c_fd2 = c_fd * c_fd;
            d_fd = 1.0 - zeta2;
            if (a_fd < 0) begin
                a_fd = 0.0;
            end
            tau_fd = phisf - SP_S_Z0  + lln(a_fd * inv_gam2);
            v_fd = a_fd + c_fd;
            v_fd2 = v_fd * v_fd;
            mu_fd = v_fd2 / tau_fd  + 0.5 * c_fd2 - a_fd * d_fd;
            temp1_fd = (c_fd * v_fd) / mu_fd;
            temp2_fd = ( `oneThird * c_fd2 - a_fd * d_fd);
            u_first_r = (v_fd * a_fd) / (mu_fd + temp1_fd * temp2_fd);
            u0_first_FD = SP_S_Z0  + u_first_r;
            delta0_fd = lexp(u0_first_FD - phisf);
            p_fd = 2 *(vgfb1-u0_first_FD)- 2.0 * zeta2 * (vgfbb-u0_first_FD + phic_star)+ gam2 * delta0_fd;
            q_fd = (vgfb1-u0_first_FD) * (vgfb1-u0_first_FD) - zeta2 * (vgfbb-u0_first_FD + phic_star) * (vgfbb-u0_first_FD+phic_star)- gam2 * (phic_star+delta0_fd);
            temp3_fd = 2.0 * q_fd * (2.0- 2.0 * zeta2 - gam2 * delta0_fd);
            w_fd= (2.0 * q_fd) / (p_fd + sqrt(p_fd * p_fd - temp3_fd));
            sp_dd  = u0_first_FD + w_fd;
        end
        phisf_smooth      =  2.0 * phib / n - sqrt(vs * vs + 0.000064) + 0.008;
        exp_ns_smooth     =  lexp(-phisf_smooth);

        if (abs(vgfb1) <= limit) begin
            T0 =  inv_x1 * inv_x1 * `oneSixth * `invSqrt2;
            sp_dd1         =  vgfb1 * inv_x1 * (1.0 + vgfb1 * (1.0 - (lexp(-phisf_smooth))) * gam * T0); // sp-> sp_dd
        end else begin
            if (vgfb1 < (-limit)) begin
                SP_S_yg   = -vgfb1;
                SP_S_ysub   = 1.25 * (SP_S_yg * inv_x1);
                SP_S_eta  =  0.5 * (SP_S_ysub + 10.0 - sqrt((SP_S_ysub - 6.0) * (SP_S_ysub - 6.0) + 64.0));
                SP_S_temp   = SP_S_yg - SP_S_eta;
                SP_S_a      = SP_S_temp * SP_S_temp + gam2 * (SP_S_eta + 1.0);
                SP_S_c      = 2.0 * SP_S_temp - gam2;
                SP_S_tau    = -SP_S_eta + lln(SP_S_a * inv_gam2);
                `sigma0(SP_S_a, SP_S_c, SP_S_tau, SP_S_eta, SP_S_y0)
                SP_S_delta0 = lexp(SP_S_y0);
                SP_S_delta1 = 1.0 / SP_S_delta0;
                SP_S_temp   = 1.0 / (2.0 + SP_S_y0 * SP_S_y0);
                SP_S_xi0    = SP_S_y0 * SP_S_y0 * SP_S_temp;
                SP_S_xi1    = 4.0 * (SP_S_y0 * SP_S_temp * SP_S_temp);
                SP_S_xi2    = (8.0 * SP_S_temp - 12.0 * SP_S_xi0) * SP_S_temp * SP_S_temp;
                SP_S_temp   = SP_S_yg - SP_S_y0;
                SP_S_temp1  = (exp_ns_smooth) * SP_S_delta1;
                SP_S_pC     = 2.0 * SP_S_temp + gam2 * (SP_S_delta0 - 1.0 - SP_S_temp1 + (exp_ns_smooth) * (1.0 - SP_S_xi1));
                SP_S_qC     = SP_S_temp * SP_S_temp - gam2 * (SP_S_delta0 - SP_S_y0 - 1.0 + SP_S_temp1 + (exp_ns_smooth) * (SP_S_y0 - 1.0 - SP_S_xi0));
                SP_S_temp   = 2.0 - gam2 * (SP_S_delta0 + SP_S_temp1 - (exp_ns_smooth) * SP_S_xi2);
                SP_S_temp   = SP_S_pC * SP_S_pC - 2.0 * (SP_S_qC * SP_S_temp);
                SP_S_temp   = sqrt(SP_S_temp * SP_S_temp + 64e-8) - 8e-4;
                sp_dd1          = -SP_S_y0 - 2.0 * (SP_S_qC / (SP_S_pC + sqrt(SP_S_temp)));
            end else begin
                SP_xg1    = 1.0 / (1.25 + gam * 7.324648775608221e-001);
                SP_S_A_fac= (x1 * 1.25 * SP_xg1 - 1.0) * SP_xg1;
                SP_S_xbar = vgfb1 * inv_x1 * (1.0 + SP_S_A_fac * vgfb1);
                SP_S_temp = lexp(-SP_S_xbar);
                SP_S_w    = 1.0 - SP_S_temp;
                SP_S_x1   = vgfb1 + gam2 * 0.5 - gam * sqrt(vgfb1 + gam2 * 0.25 - SP_S_w);
                SP_S_bx   = (phisf_smooth) + 3.0;
                SP_S_eta  = `MINF(SP_S_x1, SP_S_bx, 5.0) - 0.5 * (SP_S_bx - sqrt(SP_S_bx * SP_S_bx + 5.0));
                SP_S_temp = vgfb1 - SP_S_eta;
                SP_S_temp1= lexp(-SP_S_eta);
                SP_S_temp2= 1.0 / (2.0 + SP_S_eta * SP_S_eta);
                SP_S_xi0  = SP_S_eta * SP_S_eta * SP_S_temp2;
                SP_S_xi1  = 4.0 * (SP_S_eta * SP_S_temp2 * SP_S_temp2);
                SP_S_xi2  = (8.0 * SP_S_temp2 - 12.0 * SP_S_xi0) * SP_S_temp2 * SP_S_temp2;
                SP_S_a    = max(1.0e-40, SP_S_temp * SP_S_temp - gam2 * (SP_S_temp1 + SP_S_eta - 1.0 - (exp_ns_smooth) * (SP_S_eta + 1.0 + SP_S_xi0)));
                SP_S_b    = 1.0 - 0.5 * (gam2 * (SP_S_temp1 - (exp_ns_smooth) * SP_S_xi2));
                SP_S_c    = 2.0 * SP_S_temp + gam2 * (1.0 - SP_S_temp1 - (exp_ns_smooth) * (1.0 + SP_S_xi1));
                SP_S_tau  = (phisf_smooth) - SP_S_eta + lln(SP_S_a / gam2);
                `sigma1(SP_S_a, SP_S_b, SP_S_c, SP_S_tau, SP_S_eta, SP_S_x0)
                SP_S_delta0 = lexp(SP_S_x0);
                SP_S_delta1 = 1.0 / SP_S_delta0;
                SP_S_delta0 = (lexp(SP_S_x0-phisf_smooth));
                SP_S_temp   = 1.0 / (2.0 + SP_S_x0 * SP_S_x0);
                SP_S_xi0    = SP_S_x0 * SP_S_x0 * SP_S_temp;
                SP_S_xi1    = 4.0 * (SP_S_x0 * SP_S_temp * SP_S_temp);
                SP_S_xi2    = (8.0 * SP_S_temp - 12.0 * SP_S_xi0) * SP_S_temp * SP_S_temp;
                SP_S_temp   = vgfb1 - SP_S_x0;
                SP_S_pC     = 2.0 * SP_S_temp + gam2 * (1.0 - SP_S_delta1 + SP_S_delta0 - (exp_ns_smooth) * (1.0 + SP_S_xi1));
                SP_S_qC     = SP_S_temp * SP_S_temp - gam2 * (SP_S_delta1 + SP_S_x0 - 1.0 + SP_S_delta0 - (exp_ns_smooth) * (SP_S_x0 + 1.0 + SP_S_xi0));
                SP_S_temp   = 2.0 - gam2 * (SP_S_delta1 + SP_S_delta0 - (exp_ns_smooth) * SP_S_xi2);
                SP_S_temp   = SP_S_pC * SP_S_pC - 2.0 * (SP_S_qC * SP_S_temp);
                SP_S_temp   = sqrt(SP_S_temp * SP_S_temp + 64e-8) - 8e-4;
                sp_dd1      = SP_S_x0 + 2.0 * (SP_S_qC / (SP_S_pC + sqrt(SP_S_temp)));
            end
        end

        xs = sp_dd;
        limit1 = 1.0e-7;
        K11 = 2.0;
        SP_S_tempc =  inv_x1 * inv_x1 * `oneSixth * `invSqrt2 ;

        T0 = -DVBD1_i * Leff / litl;
        T1 = DVBD0_i * (lexp(0.5*T0) + 2.0*lexp(T0)) * (0.0 + VSCE_i);
        PHIC =  (1.0 + LPE1_i / Leff)*(`P_Q_NIST1998 * NDEP_i * (TSI * TSI)) / (2.0 * epssi)+ VBSA;
        phic_s = PHIC-RC*(vgfbb*nVt)*CDSBS1_i+ (1.0+RC)*(phisb0);
        gmesp = (8.0 + (7.0) * tanh(10.0 * ((phic_s/nVt) - phisf) + 50.0))*(1.0-lexp( -GMVD*(sqrt((Vdsx*Vdsx) +1.0e-10))));

        //First Iteration of final Poisson's expression
        if (abs(vgfb1)<= (limit1)) begin
            T0 =  inv_x1 * inv_x1 * `oneSixth * `invSqrt2;
            x7_s         =  vgfb1 * inv_x1 * (1.0 + vgfb1 * (1.0 - (exp_ns)) * gam * T0); // sp-> sp_dd
        end else begin
            T0= (0.5 * (tanh(-5.0 * (vgfb1 - K11)) +  tanh(5.0 * (vgfb1 + K11)) ));
            sp_vfb       =vgfb1 * inv_x1 * (1.0 + vgfb1 * (1.0 - (exp_ns)) * gam * SP_S_tempc) * T0;

            T0  = lexp((xs * nVt - phic_s)/nVt);
            T1  = lexp((sp_vfb * nVt - phic_s)/nVt);
            T2  = ln_one_plus_exp((xs * nVt - phic_s) / nVt) - ln_one_plus_exp((sp_vfb * nVt - phic_s)/nVt);
            T6  = lexp(-xs);
            T7  = xs * xs;
            T8  = 1.0 / (T7 + 2.0);
            T9  = lexp(-phisf);
            T10 = lexp(xs - phisf);
            if (GMCMOD == 0) begin
                T11 = (1.0 + RC);
            end else begin
                T11 = (1.0 + 1.0 / (LNDEPCV1*lexp((((sp_dd1 * nVt) / phic_s) - 1.0) * gmesp))) * (1.0 + RC);
            end
            T12 = (1.0 + T0) * T11;
            T3  = -(phisb0 / nVt + T2 / T11);
            T4  = lexp(T3);

            fx   = (vgfb1 - xs) * (vgfb1 - xs) - RT * RT * (vgfbb + T3) * (vgfbb + T3) - gam2 * (T6 - T4 + xs + T3 + T10 - T9 * (xs + 1.0 + T8 * T7));
            f_x  = (2.0 * T0 * (vgfbb + T3) * RT * RT) / T12 - 2.0 * vgfb1 + 2.0 * xs - gam2 * (T10 + T9 * (-2.0 * xs * T8 + 2.0 * xs * xs * xs * T8 * T8 - 1.0) - T6 - T0 / T12 + (T0 * T4) / T12 + 1.0);
            f_xx = 2.0 * RT * RT * T0 * (vgfbb + T3) / T12 - 2.0 * RT * RT * T0 * T0 / (T12 * T12) - gam2 * (T6 + T10 - 2.0 * T9 * T8 * (1.0 - T7 * T8 * (5.0 - 4.0 * T7 * T8)) - T0 / T12 * (1.0 - T0 / (1.0 + T0) - T4 + T0 * T4 / (1.0 + T0) * (1.0 + 1.0 / T11))) - 2.0 * RT * RT * T0 * T0 * (vgfbb + T3) / (T12 * (1.0 + T0)) + 2.0;

            x7_s=xs-(fx/f_x)*(1.0 + ((fx*f_xx)/(2.0*f_x*f_x)));

        end

        //Second Iteration of final Poisson's expression
        xs=x7_s;
        if (abs(vgfb1)<= (limit1)) begin
            T0 =  inv_x1 * inv_x1 * `oneSixth * `invSqrt2;
            x7_s         =  vgfb1 * inv_x1 * (1.0 + vgfb1 * (1.0 - (exp_ns)) * gam * T0); // sp-> sp_dd
        end else begin
            T0= (0.5 * (tanh(-5.0 * (vgfb1 - K11)) +  tanh(5.0 * (vgfb1 + K11)) ));
            sp_vfb       =vgfb1 * inv_x1 * (1.0 + vgfb1 * (1.0 - (exp_ns)) * gam * SP_S_tempc) * T0;

            T0  = lexp((xs * nVt - phic_s)/nVt);
            T1  = lexp((sp_vfb * nVt - phic_s)/nVt);
            T2  = ln_one_plus_exp((xs * nVt - phic_s) / nVt) - ln_one_plus_exp((sp_vfb * nVt - phic_s)/nVt);
            T6  = lexp(-xs);
            T7  = xs * xs;
            T8  = 1.0 / (T7 + 2.0);
            T9  = lexp(-phisf);
            T10 = lexp(xs - phisf);
            if (GMCMOD == 0) begin
                T11 = (1.0 + RC);
            end else begin
                T11 = (1.0 + 1.0 / (LNDEPCV1*lexp((((sp_dd1 * nVt) / phic_s) - 1.0) * gmesp))) * (1.0 + RC);
            end
            T12 = (1.0 + T0) * T11;
            T3  = -(phisb0 / nVt + T2 / T11);
            T4  = lexp(T3);

            fx   = (vgfb1 - xs) * (vgfb1 - xs) - RT * RT * (vgfbb + T3) * (vgfbb + T3) - gam2 * (T6 - T4 + xs + T3 + T10 - T9 * (xs + 1.0 + T8 * T7));
            f_x  = (2.0 * T0 * (vgfbb + T3) * RT * RT) / T12 - 2.0 * vgfb1 + 2.0 * xs - gam2 * (T10 + T9 * (-2.0 * xs * T8 + 2.0 * xs * xs * xs * T8 * T8 - 1.0) - T6 - T0 / T12 + (T0 * T4) / T12 + 1.0);
            f_xx = 2.0 * RT * RT * T0 * (vgfbb + T3) / T12 - 2.0 * RT * RT * T0 * T0 / (T12 * T12) - gam2 * (T6 + T10 - 2.0 * T9 * T8 * (1.0 - T7 * T8 * (5.0 - 4.0 * T7 * T8)) - T0 / T12 * (1.0 - T0 / (1.0 + T0) - T4 + T0 * T4 / (1.0 + T0) * (1.0 + 1.0 / T11))) - 2.0 * RT * RT * T0 * T0 * (vgfbb + T3) / (T12 * (1.0 + T0)) + 2.0;

            x7_s=xs-(fx/f_x)*(1.0 + ((fx*f_xx)/(2.0*f_x*f_x)));

        end

        //Third Iteration of final Poisson's expression
        xs=x7_s;
        if (abs(vgfb1)<= (limit1)) begin
            T0 =  inv_x1 * inv_x1 * `oneSixth * `invSqrt2;
            x7_s         =  vgfb1 * inv_x1 * (1.0 + vgfb1 * (1.0 - (exp_ns)) * gam * T0); // sp-> sp_dd
        end else begin
            T0= (0.5 * (tanh(-5.0 * (vgfb1 - K11)) +  tanh(5.0 * (vgfb1 + K11)) ));
            sp_vfb       =vgfb1 * inv_x1 * (1.0 + vgfb1 * (1.0 - (exp_ns)) * gam * SP_S_tempc) * T0;

            T0  = lexp((xs * nVt - phic_s)/nVt);
            T1  = lexp((sp_vfb * nVt - phic_s)/nVt);
            T2  = ln_one_plus_exp((xs * nVt - phic_s) / nVt) - ln_one_plus_exp((sp_vfb * nVt - phic_s)/nVt);
            T6  = lexp(-xs);
            T7  = xs * xs;
            T8  = 1.0 / (T7 + 2.0);
            T9  = lexp(-phisf);
            T10 = lexp(xs - phisf);
            if (GMCMOD == 0) begin
                T11 = (1.0 + RC);
            end else begin
                T11 = (1.0 + 1.0 / (LNDEPCV1*lexp((((sp_dd1 * nVt) / phic_s) - 1.0) * gmesp))) * (1.0 + RC);
            end
            T12 = (1.0 + T0) * T11;
            T3  = -(phisb0 / nVt + T2 / T11);
            T4  = lexp(T3);

            fx   = (vgfb1 - xs) * (vgfb1 - xs) - RT * RT * (vgfbb + T3) * (vgfbb + T3) - gam2 * (T6 - T4 + xs + T3 + T10 - T9 * (xs + 1.0 + T8 * T7));
            f_x  = (2.0 * T0 * (vgfbb + T3) * RT * RT) / T12 - 2.0 * vgfb1 + 2.0 * xs - gam2 * (T10 + T9 * (-2.0 * xs * T8 + 2.0 * xs * xs * xs * T8 * T8 - 1.0) - T6 - T0 / T12 + (T0 * T4) / T12 + 1.0);
            f_xx = 2.0 * RT * RT * T0 * (vgfbb + T3) / T12 - 2.0 * RT * RT * T0 * T0 / (T12 * T12) - gam2 * (T6 + T10 - 2.0 * T9 * T8 * (1.0 - T7 * T8 * (5.0 - 4.0 * T7 * T8)) - T0 / T12 * (1.0 - T0 / (1.0 + T0) - T4 + T0 * T4 / (1.0 + T0) * (1.0 + 1.0 / T11))) - 2.0 * RT * RT * T0 * T0 * (vgfbb + T3) / (T12 * (1.0 + T0)) + 2.0;

            x7_s=xs-(fx/f_x)*(1.0 + ((fx*f_xx)/(2.0*f_x*f_x)));

        end
        T2  = ln_one_plus_exp((x7_s * nVt - phic_s) / nVt) - ln_one_plus_exp((sp_vfb * nVt - phic_s)/nVt);
        if (GMCMOD == 0) begin
            T11 = (1.0 + RC);
        end else begin
            T11 = (1.0 + 1.0 / lexp((((sp_dd1 * nVt) / phic_s) - 1.0) * gmesp)) * (1.0 + RC);
        end
        x7_sb = (phisb0 / nVt + T2/T11);
        ebs   = (x7_s - x7_sb)/TSI;

        // Drain current and Charge calculation part starts
        Vdsat_lim    =  3.912023005 * nVt;
        if (x7_s <= 0.0) begin
            qis          =  0.0;
            xgm          =  vgfb1 - x7_s;
            Voxm         =  xgm * nVt;
            Vdsat        =  Vdsat_lim;
            ebs = 0.0;
            Dr = 1.0;
            Nsat = 1.0;
            Mnud = 1.0;
            Mnud1 = 1.0;
            Dvsat = 1.0;
            Dmob  = 1.0;
            Moc = 1.0;
            Mscbe = 1.0;
            Rdrain = RDrainGeo;
            Rsource = RSourceGeo;
        end else begin //vgfb1 >0

            tempc        =  1.0 / (2.0 + x7_s * x7_s);
            xi0s         =  x7_s * x7_s * tempc;
            delta_1s     =  lexp(x7_s);
            Es1          =  1.0 / delta_1s;
            delta_1s     =  lexp(x7_s - phisf);
            Ds           =  delta_1s - lexp(-phisf) * (x7_s + 1.0 + xi0s);
            Ps           =  (vgfb1-x7_s)*(vgfb1-x7_s)*(1.0/gam2) - Ds;
            Ps           =  hypsmooth(Ps - 1.0e-3, 1.0e-5) + 1.0e-3;
            sqms         =  sqrt(Ps);
            xgs          =  gam * sqrt(Ps + Ds);
            qis          =  gam2 * Ds * nVt / (xgs + gam * sqms);
            qbs          =  sqms * gam * nVt;
            Em           =  Es1;

            Dm           =  Ds;

            //Drain saturation voltage part implementation (Ref. BSIM4,BSIM-CMG)
            EeffFactor = 1.0e-8 / (epsratio * TOXE);
            T2 = (qbs  + eta_mu * qis + EBA*ebs * (epsratio * TOXE));
            T3 = 0.5*(T2+sqrt(T2*T2 + 0.001));
            Eeffs = EeffFactor * T3;

            // Ref: BSIM4 mobility model

            T2 = lexp(UCS_a * lln(0.5 * (1.0 + (qis / qbs))));

            T3 = (UA_a + UC_a * Vbsx) * pow(Eeffs, EU_t) + (UD_a + UDB_a* Vbsx)/ T2;
            T4 = 1.0 + T3;
            `Smooth(T4, 1.0, 0.0015, Dmobs)

            WeffWRFactor = 1.0 / (pow(Weff * 1.0e6, WR_i) * NF);

            if (RDSMOD == 1) begin
                Rdss = 0.0;
            end else begin
                T0   = 1.0 + PRWG_i * qis;
                T1   = PRWB_i * (sqrtPhistVbs - sqrtPhist);
                T2   = 1.0 / T0 + T1;
                T3   = T2 + sqrt(T2 * T2 + 0.01);
                Rdss = (RDSWMIN_i + RDSW_i * T3) * WeffWRFactor * NF * rdstemp;
                if (RDSMOD == 2) begin
                    Rdss = (RSourceGeo + (RDSWMIN_i + RDSW_i * T3) * WeffWRFactor * NF + RDrainGeo) * rdstemp;
                end
            end

            Esat = 2.0 * VSAT_a / U0_a * Dmobs;
            EsatL = Esat * Leff;
            T6 = KSATIV_i * (qis + 2.0 * nVt);

            if (Rdss > 0.0) begin
                WVCox = Weff * VSAT_a * Cox;
                T0 = WVCox * Rdss;
                Ta = 2.0 * T0;
                Tb = T6 + EsatL + 3.0 * T6 * T0;
                Tc = T6 * (EsatL + 2.0 * T6 * T0);
                Vdsat = (Tb - sqrt(Tb * Tb - 2.0 * Ta * Tc)) / Ta;
            end else begin
                Vdsat = EsatL * T6 / (EsatL + T6);
            end

            if (A0 == 0.0 && AGS == 0.0) begin
                AbulkIV = 1.0;
            end else begin
                T1  = Leff / (Leff + sqrt(XJ_i * Xdep));
                AbulkIV = 1.0 + (A0 * T1 - AGS * T1 * pow(qis,AGS1) * nVt) / (1.0 + KETA * Vbsx);
                `Smooth(AbulkIV, 0.1, 0.0005, AbulkIV)
            end

            Vdsat   = hypsmooth(Vdsat - 1.0e-3, 1.0e-5) + 1.0e-3;
            Vdsat    = Vdsat / AbulkIV;
            T7      = pow((Vds / Vdsat) + 1.0e-6, 1.0 / DELTA_t);
            T8      = pow(1.0 + T7, -DELTA_t);
            Vdseff  = Vds * T8;
            vdeff   = (Vdseff +Vs) * inv_nVt;

            /* Surface potential at Drain side  DD-MODEL*/
            phidf         =  2 * phib/n + vdeff;
            exp_nd     =  lexp(-phidf);
            limit       =  1.0e-3 * x1;
            T0 = -DVBD1_i * Leff / litl;
            T1 = DVBD0_i * (lexp(0.5*T0) + 2.0*lexp(T0)) * (Vds* inv_nVt + VSCE_i* inv_nVt);
            phic_star  = (1.0 + LPE1_i / Leff)*(`P_Q_NIST1998 * NDEP_i * TSI * TSI) / (2.0 * epssi * nVt) + VBSA/nVt - RC * (vgfbb)*CDSBS1_i + (1.0+RC)*T1;

            vg_FD = phic_star + gam * sqrt(lexp(-phic_star) + phic_star -1.0 );

            if (vgfb1 < (vg_FD)) begin
                //PD initial Guess
                if (abs(vgfb1) <= limit) begin
                    T0 =  inv_x1 * inv_x1 * `oneSixth * `invSqrt2;
                    sp_dd         =  vgfb1 * inv_x1 * (1.0 + vgfb1 * (1.0 - (exp_nd)) * gam * T0);// sp-> sp_dd
                end else begin
                    if (vgfb1 < (-limit)) begin
                        SP_S_yg   = -vgfb1;
                        SP_S_ysub   = 1.25 * (SP_S_yg * inv_x1);
                        SP_S_eta  =  0.5 * (SP_S_ysub + 10.0 - sqrt((SP_S_ysub - 6.0) * (SP_S_ysub - 6.0) + 64.0));
                        SP_S_temp   = SP_S_yg - SP_S_eta;
                        SP_S_a      = SP_S_temp * SP_S_temp + gam2 * (SP_S_eta + 1.0);
                        SP_S_c      = 2.0 * SP_S_temp - gam2;
                        SP_S_tau    = -SP_S_eta + lln(SP_S_a * inv_gam2);
                        `sigma0(SP_S_a, SP_S_c, SP_S_tau, SP_S_eta, SP_S_y0)
                        SP_S_delta0 = lexp(SP_S_y0);
                        SP_S_delta1 = 1.0 / SP_S_delta0;
                        SP_S_temp   = 1.0 / (2.0 + SP_S_y0 * SP_S_y0);
                        SP_S_xi0    = SP_S_y0 * SP_S_y0 * SP_S_temp;
                        SP_S_xi1    = 4.0 * (SP_S_y0 * SP_S_temp * SP_S_temp);
                        SP_S_xi2    = (8.0 * SP_S_temp - 12.0 * SP_S_xi0) * SP_S_temp * SP_S_temp;
                        SP_S_temp   = SP_S_yg - SP_S_y0;
                        SP_S_temp1  = (exp_nd) * SP_S_delta1;
                        SP_S_pC     = 2.0 * SP_S_temp + gam2 * (SP_S_delta0 - 1.0 - SP_S_temp1 + (exp_nd) * (1.0 - SP_S_xi1));
                        SP_S_qC     = SP_S_temp * SP_S_temp - gam2 * (SP_S_delta0 - SP_S_y0 - 1.0 + SP_S_temp1 + (exp_nd) * (SP_S_y0 - 1.0 - SP_S_xi0));
                        SP_S_temp   = 2.0 - gam2 * (SP_S_delta0 + SP_S_temp1 - (exp_nd) * SP_S_xi2);
                        SP_S_temp   = SP_S_pC * SP_S_pC - 2.0 * (SP_S_qC * SP_S_temp);
                        sp_dd          = -SP_S_y0 - 2.0 * (SP_S_qC / (SP_S_pC + sqrt(SP_S_temp)));
                    end else begin
                        SP_xg1    = 1.0 / (1.25 + gam * 7.324648775608221e-001);
                        SP_S_A_fac= (x1 * 1.25 * SP_xg1 - 1.0) * SP_xg1;
                        SP_S_xbar = vgfb1 * inv_x1 * (1.0 + SP_S_A_fac * vgfb1);
                        SP_S_temp = lexp(-SP_S_xbar);
                        SP_S_w    = 1.0 - SP_S_temp;
                        SP_S_x1   = vgfb1 + gam2 * 0.5 - gam * sqrt(vgfb1 + gam2 * 0.25 - SP_S_w);
                        SP_S_bx   = (phidf) + 3.0;
                        SP_S_eta  = `MINF(SP_S_x1, SP_S_bx, 5.0) - 0.5 * (SP_S_bx - sqrt(SP_S_bx * SP_S_bx + 5.0));
                        SP_S_temp = vgfb1 - SP_S_eta;
                        SP_S_temp1= lexp(-SP_S_eta);
                        SP_S_temp2= 1.0 / (2.0 + SP_S_eta * SP_S_eta);
                        SP_S_xi0  = SP_S_eta * SP_S_eta * SP_S_temp2;
                        SP_S_xi1  = 4.0 * (SP_S_eta * SP_S_temp2 * SP_S_temp2);
                        SP_S_xi2  = (8.0 * SP_S_temp2 - 12.0 * SP_S_xi0) * SP_S_temp2 * SP_S_temp2;
                        SP_S_a    = max(1.0e-40, SP_S_temp * SP_S_temp - gam2 * (SP_S_temp1 + SP_S_eta - 1.0 - (exp_nd) * (SP_S_eta + 1.0 + SP_S_xi0)));
                        SP_S_b    = 1.0 - 0.5 * (gam2 * (SP_S_temp1 - (exp_nd) * SP_S_xi2));
                        SP_S_c    = 2.0 * SP_S_temp + gam2 * (1.0 - SP_S_temp1 - (exp_nd) * (1.0 + SP_S_xi1));
                        SP_S_tau  = (phidf) - SP_S_eta + lln(SP_S_a / gam2);
                        `sigma1(SP_S_a, SP_S_b, SP_S_c, SP_S_tau, SP_S_eta, SP_S_x0)
                        SP_S_delta0 = lexp(SP_S_x0);
                        SP_S_delta1 = 1.0 / SP_S_delta0;
                        SP_S_delta0 = lexp(SP_S_x0 - phidf);
                        SP_S_temp   = 1.0 / (2.0 + SP_S_x0 * SP_S_x0);
                        SP_S_xi0    = SP_S_x0 * SP_S_x0 * SP_S_temp;
                        SP_S_xi1    = 4.0 * (SP_S_x0 * SP_S_temp * SP_S_temp);
                        SP_S_xi2    = (8.0 * SP_S_temp - 12.0 * SP_S_xi0) * SP_S_temp * SP_S_temp;
                        SP_S_temp   = vgfb1 - SP_S_x0;
                        SP_S_pC     = 2.0 * SP_S_temp + gam2 * (1.0 - SP_S_delta1 + SP_S_delta0 - (exp_nd) * (1.0 + SP_S_xi1));
                        SP_S_qC     = SP_S_temp * SP_S_temp - gam2 * (SP_S_delta1 + SP_S_x0 - 1.0 + SP_S_delta0 - (exp_nd) * (SP_S_x0 + 1.0 + SP_S_xi0));
                        SP_S_temp   = 2.0 - gam2 * (SP_S_delta1 + SP_S_delta0 - (exp_nd) * SP_S_xi2);
                        SP_S_temp   = SP_S_pC * SP_S_pC - 2.0 * (SP_S_qC * SP_S_temp);
                        sp_dd          = SP_S_x0 + 2.0 * (SP_S_qC / (SP_S_pC + sqrt(SP_S_temp)));
                    end
                end
            end else begin
                //FD initial Guess
                zeta    = RT;
                zeta2   = zeta * zeta;
                u_crit  = phic_star - phisb0 * inv_nVt;
                usf_FD  = vgfb1 - gam * sqrt(lexp(-u_crit) + u_crit -1.0);
                SP_S_bx = (phidf) + 3.0;
                SP_S_Z0 =  `MINF(usf_FD, SP_S_bx, 40.0);
                a_fd = ((vgfb1-SP_S_Z0) * (vgfb1-SP_S_Z0) - zeta2 * (vgfbb-SP_S_Z0 + phic_star) * (vgfbb-SP_S_Z0+phic_star) - gam2 * (phic_star));
                c_fd = 2.0 * (vgfb1 - SP_S_Z0 ) - 2.0 * zeta2 * (vgfbb - SP_S_Z0 + phic_star) ;
                c_fd2 = c_fd * c_fd;
                d_fd = 1.0 - zeta2;
                if (a_fd < 0) begin
                    a_fd = 0.0;
                end
                tau_fd = phidf - SP_S_Z0  + lln(a_fd * inv_gam2);
                v_fd = a_fd + c_fd;
                v_fd2 = v_fd * v_fd;
                mu_fd = v_fd2 / tau_fd  + 0.5 * c_fd2 - a_fd * d_fd;
                temp1_fd = (c_fd * v_fd) / mu_fd;
                temp2_fd = ( `oneThird * c_fd2 - a_fd * d_fd);
                u_first_r = (v_fd * a_fd) / (mu_fd + temp1_fd * temp2_fd);
                u0_first_FD = SP_S_Z0  + u_first_r;
                delta0_fd = lexp(u0_first_FD - phidf);
                p_fd = 2.0 *(vgfb1-u0_first_FD)- 2.0 * zeta2 * (vgfbb-u0_first_FD + phic_star)+ gam2 * delta0_fd;
                q_fd = (vgfb1-u0_first_FD) * (vgfb1-u0_first_FD) - zeta2 * (vgfbb-u0_first_FD + phic_star) * (vgfbb-u0_first_FD+phic_star)- gam2 * (phic_star+delta0_fd);
                temp3_fd = 2.0 * q_fd * (2.0- 2.0 * zeta2 - gam2 * delta0_fd);
                w_fd= (2.0 * q_fd) / (p_fd + sqrt(p_fd * p_fd - temp3_fd));
                sp_dd  = u0_first_FD + w_fd;
            end

            xs = sp_dd;
            limit1 = 1e-7;
            K11 = 2.0;
            SP_S_tempc =  inv_x1 * inv_x1 * `oneSixth * `invSqrt2 ;
            PHIC =  (1.0 + LPE1_i / Leff)*(`P_Q_NIST1998 * NDEP_i * (TSI * TSI)) / (2.0 * epssi) + VBSA;
            T0 = -DVBD1_i * Leff / litl;
            T1 = DVBD0_i * (lexp(0.5*T0) + 2.0*lexp(T0)) * (Vds* inv_nVt + VSCE_i* inv_nVt);
            phic_s =PHIC-RC*(vgfbb*nVt)*CDSBS1_i + (1.0+RC)*T1*nVt+ (1.0+RC)*(phisb0);
            gmesp = (8.0 + (7.0) * tanh(10.0 * ((phic_s/nVt) - phisf) + 50.0))*(1.0-lexp( -GMVD*(sqrt((Vdsx*Vdsx/(1.0)) +1.0e-10))));

            //First Iteration of final Poisson's expression
            if (abs(vgfb1)<= (limit1)) begin
                T0 =  inv_x1 * inv_x1 * `oneSixth * `invSqrt2;
                x7_d         =  vgfb1 * inv_x1 * (1.0 + vgfb1 * (1.0 - (exp_nd)) * gam * T0);
            end else begin
                T0= (0.5 * (tanh(-5.0 * (vgfb1 - K11)) +  tanh(5.0 * (vgfb1 + K11)) ));
                sp_vfb       =vgfb1 * inv_x1 * (1.0 + vgfb1 * (1.0 - (lexp(-phidf))) * gam * SP_S_tempc) * T0;

                T0  = lexp((xs * nVt - phic_s)/nVt);
                T1  = lexp((sp_vfb * nVt - phic_s)/nVt);
                T2  = ln_one_plus_exp((xs * nVt - phic_s) / nVt) - ln_one_plus_exp((sp_vfb * nVt - phic_s)/nVt);
                T6  = lexp(-xs);
                T7  = xs * xs;
                T8  = 1.0 / (T7 + 2.0);
                T9  = lexp(-phidf);
                T10 = lexp(xs - phidf);
                if (GMCMOD == 0) begin
                    T11 = (1.0 + RC);
                end else begin
                    T11 = (1.0 + 1.0 / (LNDEPCV1*lexp((((sp_dd1 * nVt) / phic_s) - 1.0) * gmesp))) * (1.0 + RC);
                end
                T12 = (1.0 + T0) * T11;
                T3  = -(phisb0 / nVt + T2 / T11);
                T4  = lexp(T3);

                fx   = (vgfb1 - xs) * (vgfb1 - xs) - RT * RT * (vgfbb + T3) * (vgfbb + T3) - gam2 * (T6 - T4 + xs + T3 + T10 - T9 * (xs + 1.0 + T8 * T7));
                f_x  = (2.0 * T0 * (vgfbb + T3) * RT * RT) / T12 - 2.0 * vgfb1 + 2.0 * xs - gam2 * (T10 + T9 * (-2.0 * xs * T8 + 2.0 * xs * xs * xs * T8 * T8 - 1.0) - T6 - T0 / T12 + (T0 * T4) / T12 + 1.0);
                f_xx = 2.0 * RT * RT * T0 * (vgfbb + T3) / T12 - 2.0 * RT * RT * T0 * T0 / (T12 * T12) - gam2 * (T6 + T10 - 2.0 * T9 * T8 * (1.0 - T7 * T8 * (5.0 - 4.0 * T7 * T8)) - T0 / T12 * (1.0 - T0 / (1.0 + T0) - T4 + T0 * T4 / (1.0 + T0) * (1.0 + 1.0 / T11))) - 2.0 * RT * RT * T0 * T0 * (vgfbb + T3) / (T12 * (1.0 + T0)) + 2.0;

                x7_d=xs-(fx/f_x)*(1.0 + ((fx*f_xx)/(2.0*f_x*f_x)));
            end

            //Second Iteration of final Poisson's expression
            xs=x7_d;
            if (abs(vgfb1)<= (limit1)) begin
                T0 =  inv_x1 * inv_x1 * `oneSixth * `invSqrt2;
                x7_d         =  vgfb1 * inv_x1 * (1.0 + vgfb1 * (1.0 - (exp_nd)) * gam * T0);
            end else begin
                T0= (0.5 * (tanh(-5.0 * (vgfb1 - K11)) +  tanh(5.0 * (vgfb1 + K11)) ));
                sp_vfb       =vgfb1 * inv_x1 * (1.0 + vgfb1 * (1.0 - (lexp(-phidf))) * gam * SP_S_tempc) * T0;

                T0  = lexp((xs * nVt - phic_s)/nVt);
                T1  = lexp((sp_vfb * nVt - phic_s)/nVt);
                T2  = ln_one_plus_exp((xs * nVt - phic_s) / nVt) - ln_one_plus_exp((sp_vfb * nVt - phic_s)/nVt);
                T6  = lexp(-xs);
                T7  = xs * xs;
                T8  = 1.0 / (T7 + 2.0);
                T9  = lexp(-phidf);
                T10 = lexp(xs - phidf);
                if (GMCMOD == 0) begin
                    T11 = (1.0 + RC);
                end else begin
                    T11 = (1.0 + 1.0 / (LNDEPCV1*lexp((((sp_dd1 * nVt) / phic_s) - 1.0) * gmesp))) * (1.0 + RC);
                end
                T12 = (1.0 + T0) * T11;
                T3  = -(phisb0 / nVt + T2 / T11);
                T4  = lexp(T3);

                fx   = (vgfb1 - xs) * (vgfb1 - xs) - RT * RT * (vgfbb + T3) * (vgfbb + T3) - gam2 * (T6 - T4 + xs + T3 + T10 - T9 * (xs + 1.0 + T8 * T7));
                f_x  = (2.0 * T0 * (vgfbb + T3) * RT * RT) / T12 - 2.0 * vgfb1 + 2.0 * xs - gam2 * (T10 + T9 * (-2.0 * xs * T8 + 2.0 * xs * xs * xs * T8 * T8 - 1.0) - T6 - T0 / T12 + (T0 * T4) / T12 + 1.0);
                f_xx = 2.0 * RT * RT * T0 * (vgfbb + T3) / T12 - 2.0 * RT * RT * T0 * T0 / (T12 * T12) - gam2 * (T6 + T10 - 2.0 * T9 * T8 * (1.0 - T7 * T8 * (5.0 - 4.0 * T7 * T8)) - T0 / T12 * (1.0 - T0 / (1.0 + T0) - T4 + T0 * T4 / (1.0 + T0) * (1.0 + 1.0 / T11))) - 2.0 * RT * RT * T0 * T0 * (vgfbb + T3) / (T12 * (1.0 + T0)) + 2.0;

                x7_d=xs-(fx/f_x)*(1.0 + ((fx*f_xx)/(2.0*f_x*f_x)));
            end

            //Third Iteration of final Poisson's expression
            xs=x7_d;
            if (abs(vgfb1)<= (limit1)) begin
                T0 =  inv_x1 * inv_x1 * `oneSixth * `invSqrt2;
                x7_d         =  vgfb1 * inv_x1 * (1.0 + vgfb1 * (1.0 - (exp_nd)) * gam * T0);
            end else begin
                T0= (0.5 * (tanh(-5.0 * (vgfb1 - K11)) +  tanh(5.0 * (vgfb1 + K11)) ));
                sp_vfb       =vgfb1 * inv_x1 * (1.0 + vgfb1 * (1.0 - (lexp(-phidf))) * gam * SP_S_tempc) * T0;

                T0  = lexp((xs * nVt - phic_s)/nVt);
                T1  = lexp((sp_vfb * nVt - phic_s)/nVt);
                T2  = ln_one_plus_exp((xs * nVt - phic_s) / nVt) - ln_one_plus_exp((sp_vfb * nVt - phic_s)/nVt);
                T6  = lexp(-xs);
                T7  = xs * xs;
                T8  = 1.0 / (T7 + 2.0);
                T9  = lexp(-phidf);
                T10 = lexp(xs - phidf);
                if (GMCMOD == 0) begin
                    T11 = (1.0 + RC);
                end else begin
                    T11 = (1.0 + 1.0 / (LNDEPCV1*lexp((((sp_dd1 * nVt) / phic_s) - 1.0) * gmesp))) * (1.0 + RC);
                end
                T12 = (1.0 + T0) * T11;
                T3  = -(phisb0 / nVt + T2 / T11);
                T4  = lexp(T3);

                fx   = (vgfb1 - xs) * (vgfb1 - xs) - RT * RT * (vgfbb + T3) * (vgfbb + T3) - gam2 * (T6 - T4 + xs + T3 + T10 - T9 * (xs + 1.0 + T8 * T7));
                f_x  = (2.0 * T0 * (vgfbb + T3) * RT * RT) / T12 - 2.0 * vgfb1 + 2.0 * xs - gam2 * (T10 + T9 * (-2.0 * xs * T8 + 2.0 * xs * xs * xs * T8 * T8 - 1.0) - T6 - T0 / T12 + (T0 * T4) / T12 + 1.0);
                f_xx = 2.0 * RT * RT * T0 * (vgfbb + T3) / T12 - 2.0 * RT * RT * T0 * T0 / (T12 * T12) - gam2 * (T6 + T10 - 2.0 * T9 * T8 * (1.0 - T7 * T8 * (5.0 - 4.0 * T7 * T8)) - T0 / T12 * (1.0 - T0 / (1.0 + T0) - T4 + T0 * T4 / (1.0 + T0) * (1.0 + 1.0 / T11))) - 2.0 * RT * RT * T0 * T0 * (vgfbb + T3) / (T12 * (1.0 + T0)) + 2.0;

                x7_d=xs-(fx/f_x)*(1.0 + ((fx*f_xx)/(2.0*f_x*f_x)));
            end
            T2  = ln_one_plus_exp((x7_d * nVt - phic_s) / nVt) - ln_one_plus_exp((sp_vfb * nVt - phic_s)/nVt);
            if (GMCMOD == 0) begin
                T11 = (1.0 + RC);
            end else begin
                T11 = (1.0 + 1.0 / lexp((((sp_dd1 * nVt) / phic_s) - 1.0) * gmesp)) * (1.0 + RC);
            end
            x7_db  = (phisb0 / nVt + T2/T11);
            ebd = (x7_d - x7_db)/TSI;
            x_ds         =  x7_d - x7_s;

            //Approximations for extremely small x7_ds: capacitance calculation
            Udse         =  (Vds)*inv_nVt;
            k_ds         =  lexp(-Udse);
            if (x_ds < 1.0e-10) begin
                T0  = lexp((x7_s * nVt - phic_s)/nVt);
                T1  = lexp((sp_vfb * nVt - phic_s)/nVt);
                T2  = ln_one_plus_exp((x7_s * nVt - phic_s) / nVt) - ln_one_plus_exp((sp_vfb * nVt - phic_s)/nVt);
                T6  = lexp(-x7_s);
                T7  = x7_s * x7_s;
                T8  = 1.0 / (T7 + 2.0);
                T9  = lexp(-Udse - phisf);
                T10 = lexp(x7_s - Udse - phisf);
                if (GMCMOD == 0) begin
                    T11 = (1.0 + RC);
                end else begin
                    T11 = (1.0 + 1.0 / lexp((((sp_dd1 * nVt) / phic_s) - 1.0) * gmesp)) * (1.0 + RC);
                end
                T12 = (1.0 + T0) * T11;
                T3  = -(phisb0 / nVt + T2 / T11);
                T4  = lexp(T3);

                pC   = -((2.0 * T0 * (vgfbb + T3) * RT * RT) / T12 - 2.0 * vgfb1 + 2.0 * x7_s - gam2 * (T10 + T9 * (-2.0 * x7_s * T8 + 2.0 * x7_s * x7_s * x7_s * T8 * T8 - 1.0) - T6 - T0 / T12 + (T0 * T4) / T12 + 1.0));

                qC    =  gam2 *(1.0 - k_ds)* Ds;
                tempc =  2.0 * RT * RT * T0 * (vgfbb + T3) / T12 - 2.0 * RT * RT * T0 * T0 / (T12 * T12) - gam2 * (T6 + T10 - 2.0 * T9 * T8 * (1.0 - T7 * T8 * (5.0 - 4.0 * T7 * T8)) - T0 / T12 * (1.0 - T0 / (1.0 + T0) - T4 + T0 * T4 / (1.0 + T0) * (1.0 + 1.0 / T11))) - 2.0 * RT * RT * T0 * T0 * (vgfbb + T3) / (T12 * (1.0 + T0)) + 2.0;
                tempc        =  pC * pC - 2.0 * (tempc * qC);
                if (tempc >= 0.0) begin
                    x_ds         =  2.0 * (qC / (pC + sqrt(tempc)));
                end
                x7_d         = x7_s + x_ds;
            end

            dps          =  x_ds * nVt;
            xi0d         =  x7_d * x7_d / (2.0 + x7_d * x7_d);
            Ed           =  lexp(-x7_d);
            Dd           =  lexp(x7_d - phidf) - lexp(-phidf) * (x7_d + 1.0 + xi0d);
            Pd           = (vgfb1 - x7_d )*(vgfb1 - x7_d )*(1.0/gam2) -  Dd;
            Pd           =  hypsmooth(Pd - 1.0e-3, 1.0e-5) + 1.0e-3;
            sqd          =  sqrt(Pd);

            //--------------------------------------
            xgd          =  gam * sqrt(Pd + Dd);
            qid          =  gam2 * Dd * nVt / (xgd + gam * sqd);

            // Mid-point surface potential
            x_m          =  0.5 * (x7_s + x7_d);
            tempc         =  abs(Ed * Es1);
            Em           =  sqrt(tempc);
            D_bar        =  0.5 * (Ds + Dd);
            Dm           =  D_bar + 0.125 * (x_ds * x_ds * (Em - 2.0 * inv_gam2));
            Pm           =  (vgfb1-x_m )*(vgfb1-x_m )*(1.0/gam2) - Dm;
            xgm          =  gam * sqrt(Dm + Pm);
            Pm           =  hypsmooth(Pm - 1.0e-3, 1.0e-5) + 1.0e-3;
            sqm          =  sqrt(Pm);

            if (PDEMOD==1) begin
            //Poly depletion effect
                pdef =2 * Cox * Cox * nVt /(`P_Q_NIST1998 * epssi * NGATE_i);
                d0  =  1.0 - Em + 2.0 * (xgm * (1/gam2));
                eta_p        =  1.0 / sqrt(1.0 + pdef * xgm);
                tempc         =  eta_p / (eta_p + 1.0);
                x_pm         =  pdef * (tempc * tempc *xgm  *xgm)*(Dm /(Dm  + Pm)) ;
                p_pd         =  2.0 * (xgm - x_pm) + gam2 * (1.0 - Em + Dm);
                q_pd         =  x_pm * (x_pm - 2.0 * xgm);
                xi_pd        =  1.0 - 0.5 * (gam2 * (Em + Dm));
                u_pd         =  q_pd * p_pd / (p_pd * p_pd - xi_pd * q_pd);
                x_m          =  x_m + u_pd;
                km           =  lexp(u_pd);
                Em           =  Em / km;
                Dm           =  Dm * km;
                Pm           =  ( vgfb1-x_m+ u_pd )*( vgfb1-x_m+ u_pd)*(1/gam2) -  Dm/ km ;
                xgm          =  gam * sqrt(Dm + Pm);
                km0          =  1.0 - Em + 2.0 * (xgm * eta_p * inv_gam2);
                x_ds         =  x_ds * km * (d0 + D_bar) / (km0 + km * D_bar);
                dps          =  x_ds * nVt;
                Pm           =  hypsmooth(Pm - 1.0e-3, 1.0e-5) + 1.0e-3;
                sqm          =  sqrt(Pm);
            end

            if (abs(dps) > 1e-35) begin
                alpha_DD    =  (qis - qid) / dps;
            end

            qim          =  nVt * (gam2 * Dm / (xgm + gam * sqm));
            qbm          =  sqm * gam * nVt;
            Voxm         =  xgm * nVt ;
            ebm = 0.5 * (ebs + ebd);
            // Mobility degradation, Ref: BSIM4

            T2  =  (qbm + eta_mu * qim + EBA*ebm * (epsratio * TOXE));
            T3    = 0.5 * (T2 + sqrt(T2 * T2 + 0.001));
            Eeffm = EeffFactor * T3;

            T2    = lexp(UCS_a * lln(0.5 * (1.0 + (qim / qbm))));
            T3    = (UA_a + UC_a * Vbsx) * pow(Eeffm, EU_t) + (UD_a + UDB_a* Vbsx)/ T2;
            T4    = 1.0 + T3;
            `Smooth(T4, 1.0, 0.0015, Dmob)

            // Output conductance
            Esat  = 2.0 * VSAT_a / (U0_a / Dmob);
            EsatL = Esat * Leff;
            if (PVAG_i > 0.0) begin
                PVAGfactor = 1.0 + PVAG_i * qim / EsatL;
            end else begin
                PVAGfactor = 1.0 / (1.0 - PVAG_i * qim / EsatL);
            end

            // Output conductance due to DIBL, Ref: BSIM4
            DIBLfactor = PDIBLC_a;
            diffVds    = Vds - Vdseff;
            Vgst2Vtm   = qim + 2.0 * nVt;
            if (DIBLfactor > 0.0) begin
                T3     = Vgst2Vtm / (Vdsat + Vgst2Vtm);
                T4     = hypsmooth((1.0 + PDIBLCB_i * Vbsx), 1.0e-3);
                T5     = 1.0 / T4;
                VaDIBL = Vgst2Vtm / DIBLfactor * T3 * PVAGfactor * T5;
                Moc    = 1.0 + diffVds / VaDIBL;
            end else begin
                Moc = 1.0;
            end

            // Degradation factor due to pocket implants, Ref: BSIM4
            if (FPROUT_i <= 0.0) begin
                Fp = 1.0;
            end else begin
                T9 = FPROUT_i * sqrt(Leff) / Vgst2Vtm;
                Fp = 1.0 / (1.0 + T9);
            end

            // Channel length modulation, Ref: BSIM4
            Vasat = Vdsat + EsatL;
            if (PCLM_a > 0.0) begin
                if (PCLMG < 0.0) begin
                    T1 = PCLM_a / (1.0 - PCLMG * qim / EsatL) / Fp;
                end else begin
                    T1 = PCLM_a * (1.0 + PCLMG * qim / EsatL) / Fp;
                end
                MdL = 1.0 + T1 * lln(1.0 + diffVds / T1 / Vasat);
            end else begin
                if (PCLMG < 0.0) begin
                    T1 = PCLM_a / (1.0 - PCLMG * qim / EsatL) / Fp;
                end else begin
                    T1 = PCLM_a * (1.0 + PCLMG * qim / EsatL) / Fp;
                end
                MdL = 1.0 + T1;
            end
            Moc = Moc * MdL;

            // Calculate Va_DITS, Ref: BSIM4
            T1 = lexp(PDITSD_i * Vds);
            if (PDITS_i > 0.0) begin
                T2      = 1.0 + PDITSL * Leff;
                VaDITS  = (1.0 + T2 * T1) / PDITS_i;
                VaDITS  = VaDITS * Fp;
            end else begin
                VaDITS  = `MAX_EXPL;
            end
            T4  = diffVds / VaDITS;
            T0  = 1.0 + T4;
            Moc = Moc * T0;

            // Calculate Va_SCBE, Ref: BSIM4
            if (PSCBE2_i > 0.0) begin
                if (diffVds > PSCBE1_i * litl / `EXPL_THRESHOLD) begin
                    T0     = PSCBE1_i * litl / diffVds;
                    VaSCBE = Leff * lexp(T0) / PSCBE2_i;
                end else begin
                    VaSCBE = `MAX_EXPL * Leff/PSCBE2_i;
                end
            end else begin
                VaSCBE = `MAX_EXPL;
            end
            Mscbe = 1.0 + (diffVds / VaSCBE);
            Moc   = Moc * Mscbe;

            // Velocity saturation (ref. BSIM-BULK)
            if ((PSATB_i || PSATE_i) < 0) begin
                zetasb      = 1.0 / (1.0 - PSATB_i * Vbsx - PSATE_i * Vesx);
            end else begin
                zetasb      = 1.0 + PSATB_i * Vbsx +  PSATE_i * Vesx;
            end
            T0      =  qim * zetasb;
            wsat       =  100.0 * (T0 / (100.0 + T0));
            inv_VP = 1.0/VP;
            T0         =  ln((1.0 + (Vds - dps) * inv_VP) / (1.0 + (Vdseff  - dps) * inv_VP));
            dL         =  ALP * T0;
            DdL        =  1.0 / (1.0 + dL + dL * dL);
            Dmob_dL    =  Dmob*DdL;

            if (PSAT_i < 0) begin
                T1       = 1 / (1 - PSAT_i * wsat);
            end else begin
                T1       = 1 + PSAT_i * wsat;
            end
            thesat1    =  THESAT_i * (T1 / Dmob_dL);
            zsat       =  thesat1 * thesat1 * dps * dps;
            if (TYPE == `ptype) begin
                zsat       =  zsat / (1.0 + thesat1 * dps);
            end
            Dvsat      =  0.5 * (Dmob_dL * (1.0 + sqrt(1.0 + 2.0 * zsat)));
            Dvsatinv   =  1.0 / Dvsat;

            // S/D series resistances, Ref: BSIM4
            Rsource = 0.0;
            Rdrain  = 0.0;
            qia   = (qis + qid);
            if (RDSMOD == 1) begin
                Rdsi = 0.0;
                Dr   = 1.0;
                // Rs (Source side resistance for all fingers)
                T2      = Vgs_noswap - Vfbsdr;
                T3      = sqrt(T2 * T2 + 0.01);
                Vgs_eff = 0.5 * (T2 + T3);
                T5      = 1.0 + PRWG_i * Vgs_eff;
                T6      = (1.0 / T5) + PRWB_i * Vsb_noswap;
                T4      = 0.5 * (T6 + sqrt(T6 * T6 + 0.01));
                Rsource = rdstemp * (RSourceGeo + (RSWMIN_i + RSW_i * T4) * WeffWRFactor);
                // Rd (Drain side resistance for all fingers)
                T2      = Vgd_noswap - Vfbsdr;
                T3      = sqrt(T2 * T2 + 0.01);
                Vgd_eff = 0.5 * (T2 + T3);
                T5      = 1.0 + PRWG_i * Vgd_eff;
                T6      = (1.0 / T5) + PRWB_i * Vdb_noswap;
                T4      = 0.5 * (T6 + sqrt(T6 * T6 + 0.01));
                Rdrain  = rdstemp * (RDrainGeo + (RDWMIN_i + RDW_i * T4) * WeffWRFactor);
            end else begin
                // Ref: (1) BSIM4 (2) "Operation and Modeling of the MOS Transistor" by Yannis Tsividis
                T0      = 1.0 + PRWG_i * qia;
                T1      = PRWB_i * (sqrtPhistVbs - sqrtPhist);
                T2      = 1.0 / T0 + T1;
                T3      = 0.5 * (T2 + sqrt(T2 * T2 + 0.01));
                Rdsi    = rdstemp * (RDSWMIN_i + RDSW_i * T3) * WeffWRFactor * NF;
                Rdrain  = RDrainGeo;
                Rsource = RSourceGeo;
                Dr      = 1.0 + U0_a /(Dvsat ) * Cox * Weff / Leff * qia * Rdsi;
                if (RDSMOD == 2) begin
                    Rdsi    = rdstemp * (RSourceGeo + (RDSWMIN_i + RDSW_i * T3) * WeffWRFactor * NF + RDrainGeo);
                    Rdrain  = 0.0;
                    Rsource = 0.0;
                    Dr      = 1.0 + U0_a /(Dvsat) * Cox * Weff / Leff * qia * Rdsi;
                end
            end

            // Non-saturation effect

            T0   = A1_t + A2_t / (qia + 2.0 * n * Vtm);
            DQSD = qis - qid;
            T1   = T0 * DQSD * DQSD;
            T2   = T1 + 1.0 - 0.001;
            T3   = -1.0 + 0.5 * (T2 + sqrt(T2 * T2 + 0.004));
            Nsat = 0.5 * (1.0 + sqrt(1.0 + T3));
            `Smooth2(Nsat, 1.0, 0.01, Nsat)

            // MNUD model to enhance Id-Vd fitting flexibility
            T0   =  (qis + qid);
            T1   = qis - qid;
            T2   = T1 / (T0 + M0_t);
            T3   = K0_t * T2 * T2;
            Mnud = 1.0 + T3;

            // MNUD1 to enhance the fitting flexibility for the gm/Id - similar approach used in BSIM-CMG
            T9    = C0_t / (max(0, C0SI_t + C0SISAT_t * T1 * T1) * T0 + 2.0 * n * Vtm);
            Mnud1 = lexp(-T9);
            T0       =  Dmob_dL * Dvsatinv;
            alpha1       =  alpha_DD *  (1.0 + 0.5 * (zsat * T0 * T0));
            alpha1       =  hypsmooth(alpha1 - 1.0e-3, 1.0e-5) + 1.0e-3;
            qim1         =  qim + nVt * alpha_DD;
            H_fact  = ( qim1 / alpha1) * (Dmob_dL / Dvsat);

        end//upto this

        // DD Core drain  Current
        ids = NF*(U0_a)*(Weff / Leff)*Cox*qim1*dps *(DdL*Dvsatinv/(Dr)) * Moc / Nsat * Mnud * Mnud1;

        // Rgate Model Modules. Ref. BSIM-4, BSIM-BULK
        Dtot = Dmob*Dvsat*Dr;
        ueff = U0_a / Dtot;
        Gcrg = 0.0;
        if (RGATEMOD > 1) begin
            idsovvds = ueff * Weff / Leff * Cox * qia;
            T9       = XRCRG2 * Vt;
            T0       = T9 * ueff * Weff / Leff * Cox;
            Gcrg     = XRCRG1 * NF * (T0 + idsovvds);
            if (RGATEMOD == 2) begin
                Rgeltd = 1.0 / Grgeltd;
                if (Rgeltd < minr) begin
                    Rgeltd = minr ;
                    Grgeltd = 1.0 / Rgeltd;
                end
                T11  = Grgeltd + Gcrg;
                Gcrg = Grgeltd * Gcrg / T11;
            end
        end

        // Junction currents and capacitances
        //Diode and BJT Current
        wdiod = Weff / NSEG + PDBCP;
        wdios = Weff / NSEG + PSBCP;
        WsTsi = wdios * TSI;
        WdTsi = wdiod * TSI;

        NVtm1 = Vtm * NDIODE_i;
        T0 = Vbs_jct / NVtm1;
        ExpVbsNVtm = lexp(T0);

        NVtm2 = Vtm * NDIODE_i;
        T0 = Vbd_jct / NVtm2;
        ExpVbdNVtm = lexp(T0);

        T4 = `Eg300 / Vtm * (TRatio-1);

        //Ibs1 : Diffusion current as per SOI
        if (ISDIF_i == 0.0) begin
            Ibs1 = 0.0;
        end else begin
            T7 = XDIF_i * T4 / NDIODE_i;
            T1 = lexp(T7);
            JDIFS = ISDIF_i * T1;
            T0 = WsTsi * JDIFS;
            Ibs1 = T0 * (ExpVbsNVtm - 1);
        end

        //Ibd1 : Diffusion Current as per SOI
        if (IDDIF_i == 0.0) begin
            Ibd1 = 0.0;
        end else begin
            T7 = XDIF_i * T4 / NDIODE_i;
            T1 = lexp(T7);
            JDIFD = IDDIF_i * T1;
            T0 = WdTsi * JDIFD;
            Ibd1 = T0 * (ExpVbdNVtm - 1);
        end

        // Ibs2 and Ibd2: Recombination / Trap-assisted tunneling current
        if (ISREC_i == 0.0) begin
            Ibs2 = 0.0;
        end else begin
            T7 = XREC_i * T4 / NRECF0_i;
            T2 = lexp(T7);
            JRECS = ISREC_i * T2;
            //forward bias
            NVtmf = VTM00 * NRECF0_i * (1 + NTRECF_i * (TRatio - 1));
            NVtmr = VTM00 * NRECR0_i * (1 + NTRECR_i * (TRatio - 1));

            T0 = Vbs_jct / NVtmf;
            T10 = lexp(T0);

            //reverse bias
            if (( VREC0_i - Vbs_jct) < 1e-3) begin
                T1 = 1e3;
                T0 = - Vbs_jct / NVtmr * VREC0_i * T1;
                T11 = lexp(T0);
                T11 = -T11;
            end else begin
                T1 = 1 / (VREC0_i - Vbs_jct);
                T0 = -Vbs_jct / NVtmr * VREC0_i * T1;
                T11 = lexp(T0);

                T11 = -T11;
            end

            T3 = WsTsi * JRECS;
            Ibs2 = T3 * (T10 + T11);
        end

        if (IDREC_i == 0.0) begin
            Ibd2 = 0.0;
        end else begin
            T7 = XREC_i * T4 / NRECF0_i;
            T2 = lexp(T7);
            JRECD = IDREC_i * T2;
            NVtmf = VTM00 * NRECF0_i * (1 + NTRECF_i * (TRatio - 1));
            NVtmr = VTM00 * NRECR0_i * (1 + NTRECR_i * (TRatio - 1));

            T0 = Vbd_jct / NVtmf;
            T10 = lexp(T0);

            if (( VREC0D_i - Vbd_jct) < 1e-3) begin

                T1 = 1e3;
                T0 = - Vbd_jct / NVtmr * VREC0D_i * T1;
                T11 = lexp(T0);
                T11 = -T11;
            end else begin
                T1 = 1 / (VREC0D_i - Vbd_jct);
                T0 = -Vbd_jct / NVtmr * VREC0D_i * T1;
                T11 = lexp(T0);

                T11 = -T11;
            end

            T3 = WdTsi * JRECD;
            Ibd2 = T3 * (T10 + T11);
        end

        //Ibs3 and Ibd3 - Recombination current in neutral body
        WTsi = Weff / NSEG * TSI;

        if (ISBJT_i == 0.0 && IDBJT_i == 0.0 ) begin
            Ibs3 =0.0;
            Ibd3 =0.0;
            Ic = 0.0;
        end else begin
            T7 = XBJT_i * T4 / NDIODE_i;
            T0 = lexp(T7);
            Ahlis = AHLI_i * T0; /* high level injection */
            JBJTS = ISBJT_i * T0;
            T7 = XBJT_i * T4 / NDIODE_i;
            T0 = lexp(T7);
            Ahlid = AHLID_i * T0; /* high level injection */
            JBJTD = IDBJT_i * T0;
            //High level injection on Source Side
            Ehlis = Ahlis * (ExpVbsNVtm - 1);
            if (Ehlis < 1e-5) begin
                Ehlis = 0;
                EhlisFactor = 1;
            end else begin
                EhlisFactor = 1.0 / sqrt(1 + Ehlis);
            end

            // high level injection of drain side
            Ehlid = Ahlid * (ExpVbdNVtm - 1);
            if (Ehlid < 1e-5) begin
                Ehlid = 0;
                EhlidFactor = 1;
            end else begin
                EhlidFactor = 1.0 / sqrt(1 + Ehlid);
            end

            T0 = -0.5 * Leff * Leff / LN / LN;
            ALPHABJT = lexp(T0);
            T2 = 1 - ALPHABJT;
            T0 = LBJT0_i * (1.0 / Leff + 1.0 / LN);
            lratio = pow(T0,NBJT_i);

            Ien = WTsi * JBJTS * lratio;
            T1 = T0 * Ien;
            Ibs3 = T1 * (ExpVbsNVtm -1) * EhlisFactor;

            Ien = WTsi * JBJTD * lratio;
            T1 = T0 * Ien;
            Ibd3 = T1 * (ExpVbdNVtm -1) * EhlidFactor;

            //Terms for diffusion charge
            lratiodif = 1.0 + LDIF0 * pow(T0,NDIF_i);

            Iendif = WTsi * JBJTS * lratiodif;
            Ibsdif = Iendif * (ExpVbsNVtm - 1) * EhlisFactor;

            Iendif = WTsi * JBJTD * lratiodif;
            Ibddif = Iendif * (ExpVbdNVtm - 1) * EhlidFactor;

            //BJT collector Current Ic
            Vearly = VABJT_i + AELY_i * Leff;

            if (Vearly < 1)
                Vearly = 1;
            if (BJTOFF == 1) begin
                Ic = 0.0;
            end else begin
                // second order effects
                T0 = 1 + (Vbs_jct + Vbd_jct) / Vearly;
                T1 = Ehlis + Ehlid;
                T3 = sqrt(T0 * T0 + 4 * T1);
                T2 = (T0 + T3) / 2.0;

                if (T2 < 0.1) begin
                    E2ndFactor = 10.0;
                end else begin
                    E2ndFactor = 1.0 /T2;
                end
                T0 = ALPHABJT * Ien;
                Ic = NF * T0 * (ExpVbsNVtm - ExpVbdNVtm) * E2ndFactor;
            end
        end

        //Ibs4 and Ibd4 : tunneling
        if (ISTUN_i == 0.0 && IDTUN_i == 0.0) begin
            Ibs4 = 0.0;
            Ibd4 = 0.0;
        end else begin
            T7 = XTUN_i * (TRatio - 1);
            T0 = lexp(T7);
            JTUNS = ISTUN_i * T0;
            T7 = XTUND_i * (TRatio - 1);
            T0 = lexp(T7);

            JTUND = IDTUN_i * T0;
            NVtm2 = VTM00 * NTUN_i;
            if (( VTUN0_i - Vbs_jct) < 1e-3) begin
                T1 = 1e3;
                T0 = -Vbs_jct / NVtm2 * VTUN0_i * T1;
                T1 = lexp(T0);

                T3 = WsTsi * JTUNS;
                Ibs4 = T3 * (1 - T1);
            end else begin
                T1 = 1 / (VTUN0_i - Vbs_jct);
                T0 = -Vbs_jct / NVtm2 * VTUN0_i * T1;
                T1 = lexp(T0);

                T3 = WsTsi * JTUNS;
                Ibs4 = T3 * (1 - T1);
            end

            NVtm2 = VTM00 * NTUND_i;
            if (( VTUN0D_i - Vbd_jct) < 1e-3) begin
                T1 = 1e3;
                T0 = -Vbd_jct / NVtm2 * VTUN0D_i * T1;
                T1 = lexp(T0);

                T3 = WsTsi * JTUND;
                Ibd4 = T3 * (1 - T1);
            end else begin
                T1 = 1 / (VTUN0D_i - Vbd_jct);
                T0 = -Vbd_jct / NVtm2 * VTUN0D_i * T1;
                T1 = lexp(T0);

                T3 = WsTsi * JTUND;
                Ibd4 = T3 * (1 - T1);
            end
        end

        Ibs = NF * (Ibs1 + Ibs2 + Ibs3 + Ibs4);
        Ibd = NF * (Ibd1 + Ibd2 + Ibd3 + Ibd4);

        // GIDL and GISL currents, Ref: BSIM4 and BSIM-SOI
        igisl = 0.0;
        igidl = 0.0;
        if (GIDLMOD == 0) begin
            T0 = epsratio * TOXE;
            // GIDL
            if ((AGIDL_i <= 0.0) || (BGIDL_t <= 0.0) || (CGIDL_i < 0.0)) begin
                T6 = 0.0;
            end else begin
                T1 = (-Vgd_noswap - EGIDL_i + Vfbsdr) / T0;
                T1 = hypsmooth(T1, 1.0e-2);
                T2 = BGIDL_t / (T1 + 1.0e-3);
                if (CGIDL_i != 0.0) begin
                    T3 = Vdb_noswap * Vdb_noswap * Vdb_noswap;
                    T4 = CGIDL_i + abs(T3) + 1.0e-4;
                    T5 = hypsmooth(T3 / T4, 1.0e-6) - 1.0e-6;
                end else begin
                    T5 = 1.0;
                end
                T6 = AGIDL_i * wdiod * T1 * lexp(-T2) * T5;
            end
            igidl = T6;
            // GISL
            if ((AGISL_i <= 0.0) || (BGISL_t <= 0.0) || (CGISL_i < 0.0)) begin
                T6 = 0.0;
            end else begin
                T1 = (-Vgs_noswap - EGISL_i + Vfbsdr) / T0;
                T1 = hypsmooth(T1, 1.0e-2);
                T2 = BGISL_t / (T1 + 1.0e-3);
                if (CGISL_i != 0.0) begin
                    T3 = Vsb_noswap * Vsb_noswap * Vsb_noswap;
                    T4 = CGISL_i + abs(T3) + 1.0e-4;
                    T5 = hypsmooth(T3 / T4, 1.0e-6) - 1.0e-6;
                end else begin
                    T5 = 1.0;
                end
                T6 = AGISL_i * wdios * T1 * lexp(-T2) * T5;
            end
            igisl = T6;
        end else begin
            //GIDLMOD = 1
            T0 = epsratio * TOXE;
            Vgd_noswap_1    = RGISL_i * Vg - Vd;
            Vgs_noswap_1    = RGIDL_i * Vg - Vs;
            T2      = Vgs_noswap - Vfbsdr;
            Vgs_eff = sqrt(T2 * T2 + 1.0e-4);
            //GIDL
            if ((AGIDL_i <= 0.0) || (BGIDL_t <= 0.0)) begin
                T6 = 0.0;
            end else begin
                T1 = (-Vgd_noswap_1 - EGIDL_i + Vfbsdr) / T0;
                T1 = hypsmooth(T1, 1.0e-2);
                T2 = BGIDL_t / (T1 + 1.0e-3);

                if (KGIDL_i != 0.0) begin
                    T3 = -Vdb_noswap-FGIDL_i;
                    T4 = T3 + 1.0e-4;
                    T5 = hypsmooth(KGIDL_i / T4, 1.0e-6) - 1.0e-6;
                end else begin
                    T5 = 1.0;
                end
                T6 = AGIDL_i * wdiod * T1 * lexp(-T2) * lexp(T5);
            end
            igidl = T6;

            //GISL
            if ((AGISL_i <= 0.0) || (BGISL_t <= 0.0)) begin
                T6 = 0.0;
            end else begin
                T1 = (-Vgs_noswap_1 - EGISL_i + Vfbsdr) / T0;
                T1 = hypsmooth(T1, 1.0e-2);
                T2 = BGISL_t / (T1 + 1.0e-3);

                if (KGISL_i != 0.0) begin
                    T3 = -Vsb_noswap-FGISL_i;
                    T4 = T3 + 1.0e-4;
                    T5 = hypsmooth(KGISL_i / T4, 1.0e-6) - 1.0e-6;
                end else begin
                    T5 = 1.0;
                end
                T6 = AGISL_i * wdios * T1 * lexp(-T2) * lexp(T5);
            end
            igisl = T6;
        end

        IGIDL = devsign * NF * MULT_I * igidl;
        IGISL = devsign * NF * MULT_I * igisl;

        // Impact ionization currents, Ref: BSIM4 and BSIM-SOI
        //BULK MOSFET
        if (IIIMOD == 0) begin
            if ((ALPHA0_i <= 0.0) || (BETA0_t <= 0.0)) begin
                Iii = 0.0;
            end else if (diffVds > BETA0_t / `EXPL_THRESHOLD) begin
                T1  = -BETA0_t / diffVds;
                Iii = ALPHA0_i * diffVds * ids * lexp(T1) / Mscbe;
            end else begin
                Iii = ALPHA0_i * diffVds * ids * `MIN_EXPL / Mscbe;
            end

        //SOI
        end else if (IIIMOD == 1) begin
            if ((ALPHA0_i <= 0.0) || (BETA2_i == 0.0 && BETA1_i == 0.0 && BETA0_t == 0.0)) begin
                Iii = 0.0;
            end else begin
                Vdsatii0 = VDSATII0_i * (1 + TII * (TRatio - 1.0)) - (LII_i / Leff);
                T0 = ESATII_i * Leff;
                T1 = SII0_i * T0 / (1.0 + T0);

                T0 = 1.0 / (1.0 + hypsmooth((SII1_i * vgsfb * nVt), IIMOD2CLAMP1));
                T3 = T0 + SII2_i;
                T2 = hypsmooth((vgsfb * nVt * T3), IIMOD2CLAMP2);
                T3 = 1.0 / (1.0 + SIID_i * Vdsx);

                VgsStep = T1 * T2 * T3;
                Vdsatii = Vdsatii0 + VgsStep;
                Vdiff = Vdsx - Vdsatii;

                T0 = BETA2_i + BETA1_i * Vdiff + BETA0_t * Vdiff * Vdiff;
                T1 = sqrt(T0 * T0 + 1.0e-10);
                Ratio = -hypmax(-ALPHA0_i * lexp(Vdiff / T1), -10.0, IIMOD2CLAMP3);
                Iii = Ratio * (ids + FBJTII_i * sigvds * Ic);
            end

        //IIIMOD = 2
        //two components have the different impact ionization rate.
        end else begin
            if ((ALPHA0_i <= 0.0) || (BETA2_i == 0.0 && BETA1_i == 0.0 && BETA0_t == 0.0)) begin
                Iii = 0.0;
            end else begin
                //Idsmosfet
                Vdsatii0 = VDSATII0_i * (1 + TII * (TRatio - 1.0)) - (LII_i / Leff);
                T0 = ESATII_i * Leff;
                T1 = SII0_i * T0 / (1.0 + T0);

                T0 = 1.0 / (1.0 + hypsmooth((SII1_i * vgsfb * nVt), IIMOD2CLAMP1));
                T3 = T0 + SII2_i;
                T2 = hypsmooth((vgsfb * nVt * T3), IIMOD2CLAMP2);
                T3 = 1.0 / (1.0 + SIID_i * Vdsx);

                VgsStep = T1 * T2 * T3;
                Vdsatii = Vdsatii0 + VgsStep;
                Vdiff = Vdsx - Vdsatii;

                T0 = BETA2_i + BETA1_i * Vdiff + BETA0_t * Vdiff * Vdiff;
                T1 = sqrt(T0 * T0 + 1.0e-10);
                Ratio = -hypmax(-ALPHA0_i * lexp(Vdiff / T1), -10.0, IIMOD2CLAMP3);
                Idsmosfet = Ratio * ids;
            end

            //Iiibjt
            T0 = (CBJTII_i + EBJTII_i * Leff) / Leff;
            Vbc = VBCI_i * (1.0 + TVBCI * (TRatio - 1));

            if (sigvds > 0)
                T1 = Vbc - Vbd_jct;
            else
                T1 = Vbc - Vbs_jct;

            T2 = MBJTII_i - 1.0;

            if (T1 > 0.0)
                T3 = -ABJTII_i * pow(T1,T2);
            else
                T3 = 0.0;

            T4 = lexp(T3);
            Iiibjt = T0 * sigvds * Ic * T1 * T4;

            //Total Iii
            Iii = Idsmosfet + Iiibjt;
        end

        ISUB = Iii * MULT_I * devsign;

        // Junction capacitances (no swapping)
        // Source-to-bulk junction
        Czbs       = CJS_t * ASeff;
        Czbssw     = CJSWS_t * PSeff;
        Czbsswg    = CJSWGS_t * Weffcj * NF;
        czbs_p1    = pow(0.1, -MJS);

        if (MJS == 1) begin
            czbs_p2    = 1.5 - ln(0.1);
        end else begin
            czbs_p2    = 1.0 / (1.0 - MJS) * (1.0 - 0.05 * MJS * (1.0 + MJS) * czbs_p1);
        end
        czbssw_p1  = pow(0.1, -MJSWS);
        if (MJSWS == 1) begin
            czbssw_p2    = 1.5 - ln(0.1);
        end else begin
            czbssw_p2  = 1.0 / (1.0 - MJSWS) * (1.0 - 0.05 * MJSWS * (1.0 + MJSWS) * czbssw_p1);
        end
        czbsswg_p1 = pow(0.1, -MJSWGS);
        if (MJSWGS == 1) begin
            czbsswg_p2    = 1.5 - ln(0.1);
        end else begin
            czbsswg_p2 = 1.0 / (1.0 - MJSWGS) * (1.0 - 0.05 * MJSWGS * (1.0 + MJSWGS) * czbsswg_p1);
        end

        `JunCap(Czbs, Vbs_jct, PBS_t, MJS, czbs_p1, czbs_p2, Qbsj1)
        `JunCap(Czbssw, Vbs_jct, PBSWS_t, MJSWS, czbssw_p1, czbssw_p2, Qbsj2)
        `JunCap(Czbsswg, Vbs_jct, PBSWGS_t, MJSWGS, czbsswg_p1, czbsswg_p2, Qbsj3)

        Qbsj4 = TT * Ibsdif * NF;
        Qbsj = Qbsj1 + Qbsj2 + Qbsj3 + Qbsj4;

        // Drain-to-bulk junction
        Czbd       = CJD_t * ADeff;
        Czbdsw     = CJSWD_t * PDeff;
        Czbdswg    = CJSWGD_t * Weffcj * NF;
        czbd_p1    = pow(0.1, -MJD);

        if (MJD == 1) begin
            czbd_p2    = 1.5 - ln(0.1);
        end else begin
            czbd_p2    = 1.0 / (1.0 - MJD) * (1.0 - 0.05 * MJD * (1.0 + MJD) * czbd_p1);
        end
        czbdsw_p1  = pow(0.1, -MJSWD);
        if (MJSWD == 1) begin
            czbdsw_p2  = 1.5 - ln(0.1);
        end else begin
            czbdsw_p2  = 1.0 / (1.0 - MJSWD) * (1.0 - 0.05 * MJSWD * (1.0 + MJSWD) * czbdsw_p1);
        end
        czbdswg_p1 = pow(0.1, -MJSWGD);
        if (MJSWGD == 1) begin
            czbdswg_p2 = 1.5 - ln(0.1);
        end else begin
            czbdswg_p2 = 1.0 / (1.0 - MJSWGD) * (1.0 - 0.05 * MJSWGD * (1.0 + MJSWGD) * czbdswg_p1);
        end

        `JunCap(Czbd, Vbd_jct, PBD_t, MJD, czbd_p1, czbd_p2, Qbdj1)
        `JunCap(Czbdsw, Vbd_jct, PBSWD_t, MJSWD, czbdsw_p1, czbdsw_p2, Qbdj2)
        `JunCap(Czbdswg, Vbd_jct, PBSWGD_t, MJSWGD, czbdswg_p1, czbdswg_p2, Qbdj3)

        Qbdj4 = TT * Ibddif * NF;
        Qbdj = Qbdj1 + Qbdj2 + Qbdj3 + Qbdj4;
        if (CVMOD == 1) begin
            // Normalization of terminal and flatband voltage by nVt
            VFBCV_i = VFBCV_i + DELVTO;
            vg    = Vg * inv_nVt;
            vs    = Vs * inv_nVt;
            vfb   = VFBCV_i * inv_nVt;
            vfbb  = VFBBCV_i * inv_nVt;
            ve = Ve * inv_nVt;

            //Normalized terminal voltages for DDMOD
            vgfb1 = vg - vfb ; // - Vth_shift * inv_nVt;
            vgfbb = ve - vfbb;
            phibCV  = lln(NDEPCV_i / ni);
            // Normalized body factor
            gam     = sqrt(2.0 * `P_Q_NIST1998 * epssi * NDEPCV_i * inv_nVt) / Cox;
            inv_gam = 1.0 / gam;
            gam2 = gam * gam;
            inv_gam2 = 1.0 / gam2;
            // DD Model Back potential solved independently for PD decoupled case.
            CB = epssi / TSI;
            CBOX = epsox / TBOX;
            RC= (CBOX +CDSBS_i) / CB;
            RT = TOXE / TBOX;
            gam_sb = gam / RT;
            x1_sb = 1.0 + gam_sb * `invSqrt2;
            limit_sb = 1.0e-7 * x1_sb;
            x1_csb         =  5.0/4.0;
            inv_xi_sb = (1.0/gam_sb);
            gam_sb2 = gam_sb*gam_sb;
            inv_xg1_sb  =  1.0 / (x1_csb + gam_sb * 7.324648775608221e-1);
            if (abs(vgfbb) <= limit_sb) begin
                pd_sb        =  ((-vgfbb ) * inv_xi_sb)*(1.0+gam_sb*((-vgfbb /(6.0*sqrt(2.0)*x1_sb*x1_sb))));
            end else begin
                if (vgfbb  < (-limit_sb)) begin
                    PD_yg    =  -vgfbb;
                    PD_z     =  x1_csb * PD_yg  * inv_xi_sb;
                    PD_eta   =  0.5 * (PD_z  + 10.0 - sqrt((PD_z  - 6.0) * (PD_z  - 6.0) + 64.0));
                    PD_a     =  (PD_yg   - PD_eta) * (PD_yg   - PD_eta) + gam_sb2 * (PD_eta  + 1.0);
                    PD_c     =  2.0 * (PD_yg   - PD_eta) - gam_sb2;
                    PD_tau   =  lln(PD_a  / gam_sb2) - PD_eta;
                    `sigma0(PD_a, PD_c, PD_tau, PD_eta, PD_y0)
                    PD_D0    =  lexp(PD_y0);
                    PD_temp  =  PD_yg  - PD_y0 ;
                    PD_p     =  2.0 * PD_temp  + gam_sb2 * (PD_D0  - 1.0);
                    PD_q     =  PD_temp  * PD_temp  + gam_sb2 * (PD_y0  + 1.0 - PD_D0 );
                    PD_xi    =  1.0 - gam_sb2 * 0.5 * PD_D0 ;
                    PD_temp  =  PD_p  * PD_p  - 4.0 * (PD_xi  * PD_q );
                    PD_w     =  2.0 * (PD_q  / (PD_p  + sqrt(PD_temp )));
                    pd_sb    = -(PD_y0  + PD_w);
                end else begin
                    PD_Afac  =  (x1_sb * x1_csb * inv_xg1_sb - 1.0) * inv_xg1_sb;
                    PD_xbar  =  vgfbb  * inv_xi_sb * (1.0 + PD_Afac * vgfbb );
                    PD_temp1 = lexp(-PD_xbar);
                    PD_w1    =  1.0 - PD_temp1;
                    PD_x0    =  vgfbb  + gam_sb2 * 0.5 - gam_sb * sqrt(vgfbb  + gam_sb2 * 0.25 - PD_w1 );
                    PD_D01   =  lexp(-PD_x0);
                    PD_p1    =  2.0 * (vgfbb - PD_x0 ) + gam_sb2 * (1.0 - PD_D01 );
                    PD_q1    =  (vgfbb  - PD_x0 ) * (vgfbb  - PD_x0 ) - gam_sb2 * (PD_x0  - 1.0 + PD_D01 );
                    PD_xi1   =  1.0 - gam_sb2 * 0.5 * PD_D01 ;
                    PD_temp1 =  PD_p1  * PD_p1  - 4.0 * (PD_xi1  * PD_q1 );
                    PD_u     =  2.0 * (PD_q1  / (PD_p1  + sqrt(PD_temp1 )));
                    pd_sb    =  PD_x0  + PD_u ;
                end
            end
            // One iteration given to correct value even at 10th decimal point
            if (abs(vgfbb)  < (limit_sb)) begin
                phisb0=((-vgfbb ) * inv_xi_sb)*(1.0+gam_sb*((-vgfbb /(6.0*sqrt(2.0)*x1_sb*x1_sb))));
                pd_sb=((-vgfbb ) * inv_xi_sb)*(1.0+gam_sb*((-vgfbb /(6.0*sqrt(2.0)*x1_sb*x1_sb))));
            end else begin
                fx = RT*RT*(vgfbb - pd_sb)*(vgfbb - pd_sb)*(1.0/gam)*(1.0/gam) -(lexp(-pd_sb) + pd_sb -1.0);
                f_x = lexp(-pd_sb) + (RT*RT*(2.0*pd_sb - 2.0*vgfbb))/(gam*gam) - 1.0;
                phisb0 =(pd_sb)-(fx /f_x );
            end
            phisb0=phisb0* nVt;

            // DD-MODEL core source side surface potential
            /* Surface potential at source side  DD-MODEL*/
            x1           =  1.0 + gam * `invSqrt2;
            inv_x1       =  1.0 /  x1;
            phisf         =  2.0 * phibCV/n + vs;
            exp_ns     =  lexp(-phisf);
            limit       =  1.0e-3 * x1;
            T0 = -DVBD1_i * Leff / litl;
            T1 = DVBD0_i * (lexp(0.5*T0) + 2.0*lexp(T0)) * (0.0 + VSCE_i);
            phic_star  = (1.0 + LPE1_i / Leff)*(`P_Q_NIST1998 * NDEPCV_i * TSI * TSI) / (2.0 * epssi * nVt) + VBSA/nVt - RC * (vgfbb);
            vg_FD = phic_star + gam * sqrt(lexp(-phic_star) + phic_star -1.0);

            if (vgfb1 < (vg_FD)) begin
                //PD initial Guess
                if (abs(vgfb1) <= limit) begin
                    T0 =  inv_x1 * inv_x1 * `oneSixth * `invSqrt2;
                    sp_dd         =  vgfb1 * inv_x1 * (1.0 + vgfb1 * (1.0 - (exp_ns)) * gam * T0);
                end else begin
                    if (vgfb1 < (-limit)) begin
                        SP_S_yg   = -vgfb1;
                        SP_S_ysub   = 1.25 * (SP_S_yg * inv_x1);
                        SP_S_eta  =  0.5 * (SP_S_ysub + 10.0 - sqrt((SP_S_ysub - 6.0) * (SP_S_ysub - 6.0) + 64.0));
                        SP_S_temp   = SP_S_yg - SP_S_eta;
                        SP_S_a      = SP_S_temp * SP_S_temp + gam2 * (SP_S_eta + 1.0);
                        SP_S_c      = 2.0 * SP_S_temp - gam2;
                        SP_S_tau    = -SP_S_eta + lln(SP_S_a * inv_gam2);
                        `sigma0(SP_S_a, SP_S_c, SP_S_tau, SP_S_eta, SP_S_y0)
                        SP_S_delta0 = lexp(SP_S_y0);
                        SP_S_delta1 = 1.0 / SP_S_delta0;
                        SP_S_temp   = 1.0 / (2.0 + SP_S_y0 * SP_S_y0);
                        SP_S_xi0    = SP_S_y0 * SP_S_y0 * SP_S_temp;
                        SP_S_xi1    = 4.0 * (SP_S_y0 * SP_S_temp * SP_S_temp);
                        SP_S_xi2    = (8.0 * SP_S_temp - 12.0 * SP_S_xi0) * SP_S_temp * SP_S_temp;
                        SP_S_temp   = SP_S_yg - SP_S_y0;
                        SP_S_temp1  = (exp_ns) * SP_S_delta1;
                        SP_S_pC     = 2.0 * SP_S_temp + gam2 * (SP_S_delta0 - 1.0 - SP_S_temp1 + (exp_ns) * (1.0 - SP_S_xi1));
                        SP_S_qC     = SP_S_temp * SP_S_temp - gam2 * (SP_S_delta0 - SP_S_y0 - 1.0 + SP_S_temp1 + (exp_ns) * (SP_S_y0 - 1.0 - SP_S_xi0));
                        SP_S_temp   = 2.0 - gam2 * (SP_S_delta0 + SP_S_temp1 - (exp_ns) * SP_S_xi2);
                        SP_S_temp   = SP_S_pC * SP_S_pC - 2.0 * (SP_S_qC * SP_S_temp);
                        SP_S_temp   = sqrt(SP_S_temp * SP_S_temp + 64e-8) - 8e-4;
                        sp_dd          = -SP_S_y0 - 2.0 * (SP_S_qC / (SP_S_pC + sqrt(SP_S_temp)));
                    end else begin
                        SP_xg1    = 1.0 / (1.25 + gam * 7.324648775608221e-001);
                        SP_S_A_fac= (x1 * 1.25 * SP_xg1 - 1.0) * SP_xg1;
                        SP_S_xbar = vgfb1 * inv_x1 * (1.0 + SP_S_A_fac * vgfb1);
                        SP_S_temp = lexp(-SP_S_xbar);
                        SP_S_w    = 1.0 - SP_S_temp;
                        SP_S_x1   = vgfb1 + gam2 * 0.5 - gam * sqrt(vgfb1 + gam2 * 0.25 - SP_S_w);
                        SP_S_bx   = (phisf) + 3.0;
                        SP_S_eta  = `MINF(SP_S_x1, SP_S_bx, 5.0) - 0.5 * (SP_S_bx - sqrt(SP_S_bx * SP_S_bx + 5.0));
                        SP_S_temp = vgfb1 - SP_S_eta;
                        SP_S_temp1= lexp(-SP_S_eta);
                        SP_S_temp2= 1.0 / (2.0 + SP_S_eta * SP_S_eta);
                        SP_S_xi0  = SP_S_eta * SP_S_eta * SP_S_temp2;
                        SP_S_xi1  = 4.0 * (SP_S_eta * SP_S_temp2 * SP_S_temp2);
                        SP_S_xi2  = (8.0 * SP_S_temp2 - 12.0 * SP_S_xi0) * SP_S_temp2 * SP_S_temp2;
                        SP_S_a    = max(1.0e-40, SP_S_temp * SP_S_temp - gam2 * (SP_S_temp1 + SP_S_eta - 1.0 - (exp_ns) * (SP_S_eta + 1.0 + SP_S_xi0)));
                        SP_S_b    = 1.0 - 0.5 * (gam2 * (SP_S_temp1 - (exp_ns) * SP_S_xi2));
                        SP_S_c    = 2.0 * SP_S_temp + gam2 * (1.0 - SP_S_temp1 - (exp_ns) * (1.0 + SP_S_xi1));
                        SP_S_tau  = (phisf) - SP_S_eta + lln(SP_S_a / gam2);
                        `sigma1(SP_S_a, SP_S_b, SP_S_c, SP_S_tau, SP_S_eta, SP_S_x0)
                        SP_S_delta0 = lexp(SP_S_x0);
                        SP_S_delta1 = 1.0 / SP_S_delta0;
                        SP_S_delta0 = lexp(SP_S_x0 - phisf);
                        SP_S_temp   = 1.0 / (2.0 + SP_S_x0 * SP_S_x0);
                        SP_S_xi0    = SP_S_x0 * SP_S_x0 * SP_S_temp;
                        SP_S_xi1    = 4.0 * (SP_S_x0 * SP_S_temp * SP_S_temp);
                        SP_S_xi2    = (8.0 * SP_S_temp - 12.0 * SP_S_xi0) * SP_S_temp * SP_S_temp;
                        SP_S_temp   = vgfb1 - SP_S_x0;
                        SP_S_pC     = 2.0 * SP_S_temp + gam2 * (1.0 - SP_S_delta1 + SP_S_delta0 - (exp_ns) * (1.0 + SP_S_xi1));
                        SP_S_qC     = SP_S_temp * SP_S_temp - gam2 * (SP_S_delta1 + SP_S_x0 - 1.0 + SP_S_delta0 - (exp_ns) * (SP_S_x0 + 1.0 + SP_S_xi0));
                        SP_S_temp   = 2.0 - gam2 * (SP_S_delta1 + SP_S_delta0 - (exp_ns) * SP_S_xi2);
                        SP_S_temp   = SP_S_pC * SP_S_pC - 2.0 * (SP_S_qC * SP_S_temp);
                        SP_S_temp   = sqrt(SP_S_temp * SP_S_temp + 64e-8) - 8e-4;
                        sp_dd       = SP_S_x0 + 2.0 * (SP_S_qC / (SP_S_pC + sqrt(SP_S_temp)));
                    end
                end
            end else begin
                //FD initial Guess
                zeta    = RT;
                zeta2   = zeta * zeta;
                u_crit  = phic_star - phisb0 * inv_nVt;
                usf_FD  = vgfb1 - gam * sqrt(lexp(-u_crit) + u_crit -1.0);
                SP_S_bx = (phisf) + 3.0;
                SP_S_Z0 =  `MINF(usf_FD, SP_S_bx, 40.0);
                a_fd = ((vgfb1-SP_S_Z0) * (vgfb1-SP_S_Z0) - zeta2 * (vgfbb-SP_S_Z0 + phic_star) * (vgfbb-SP_S_Z0+phic_star) - gam2 * (phic_star));
                c_fd = 2.0 * (vgfb1 - SP_S_Z0 ) - 2.0 * zeta2 * (vgfbb - SP_S_Z0 + phic_star);
                c_fd2 = c_fd * c_fd;
                d_fd = 1.0 - zeta2;
                if (a_fd < 0) begin
                    a_fd = 0.0;
                end
                tau_fd = phisf - SP_S_Z0  + lln(a_fd * inv_gam2);
                v_fd = a_fd + c_fd;
                v_fd2 = v_fd * v_fd;
                mu_fd = v_fd2 / tau_fd  + 0.5 * c_fd2 - a_fd * d_fd;
                temp1_fd = (c_fd * v_fd) / mu_fd;
                temp2_fd = ( `oneThird * c_fd2 - a_fd * d_fd);
                u_first_r = (v_fd * a_fd) / (mu_fd + temp1_fd * temp2_fd);
                u0_first_FD = SP_S_Z0  + u_first_r;
                delta0_fd = lexp(u0_first_FD - phisf);
                p_fd = 2 *(vgfb1-u0_first_FD)- 2.0 * zeta2 * (vgfbb-u0_first_FD + phic_star)+ gam2 * delta0_fd;
                q_fd = (vgfb1-u0_first_FD) * (vgfb1-u0_first_FD) - zeta2 * (vgfbb-u0_first_FD + phic_star) * (vgfbb-u0_first_FD+phic_star)- gam2 * (phic_star+delta0_fd);
                temp3_fd = 2.0 * q_fd * (2.0- 2.0 * zeta2 - gam2 * delta0_fd);
                w_fd= (2.0 * q_fd) / (p_fd + sqrt(p_fd * p_fd - temp3_fd));
                sp_dd  = u0_first_FD + w_fd;
            end

            phisf_smooth      =  2.0 * phibCV / n - sqrt(vs * vs + 0.000064) + 0.008;
            exp_ns_smooth     =  lexp(-phisf_smooth);

            if (abs(vgfb1) <= limit) begin
                T0 =  inv_x1 * inv_x1 * `oneSixth * `invSqrt2;
                sp_dd1         =  vgfb1 * inv_x1 * (1.0 + vgfb1 * (1.0 - (lexp(-phisf_smooth))) * gam * T0); // sp-> sp_dd
            end else begin
                if (vgfb1 < (-limit)) begin
                    SP_S_yg   = -vgfb1;
                    SP_S_ysub   = 1.25 * (SP_S_yg * inv_x1);
                    SP_S_eta  =  0.5 * (SP_S_ysub + 10.0 - sqrt((SP_S_ysub - 6.0) * (SP_S_ysub - 6.0) + 64.0));
                    SP_S_temp   = SP_S_yg - SP_S_eta;
                    SP_S_a      = SP_S_temp * SP_S_temp + gam2 * (SP_S_eta + 1.0);
                    SP_S_c      = 2.0 * SP_S_temp - gam2;
                    SP_S_tau    = -SP_S_eta + lln(SP_S_a * inv_gam2);
                    `sigma0(SP_S_a, SP_S_c, SP_S_tau, SP_S_eta, SP_S_y0)
                    SP_S_delta0 = lexp(SP_S_y0);
                    SP_S_delta1 = 1.0 / SP_S_delta0;
                    SP_S_temp   = 1.0 / (2.0 + SP_S_y0 * SP_S_y0);
                    SP_S_xi0    = SP_S_y0 * SP_S_y0 * SP_S_temp;
                    SP_S_xi1    = 4.0 * (SP_S_y0 * SP_S_temp * SP_S_temp);
                    SP_S_xi2    = (8.0 * SP_S_temp - 12.0 * SP_S_xi0) * SP_S_temp * SP_S_temp;
                    SP_S_temp   = SP_S_yg - SP_S_y0;
                    SP_S_temp1  = (exp_ns_smooth) * SP_S_delta1;
                    SP_S_pC     = 2.0 * SP_S_temp + gam2 * (SP_S_delta0 - 1.0 - SP_S_temp1 + (exp_ns_smooth) * (1.0 - SP_S_xi1));
                    SP_S_qC     = SP_S_temp * SP_S_temp - gam2 * (SP_S_delta0 - SP_S_y0 - 1.0 + SP_S_temp1 + (exp_ns_smooth) * (SP_S_y0 - 1.0 - SP_S_xi0));
                    SP_S_temp   = 2.0 - gam2 * (SP_S_delta0 + SP_S_temp1 - (exp_ns_smooth) * SP_S_xi2);
                    SP_S_temp   = SP_S_pC * SP_S_pC - 2.0 * (SP_S_qC * SP_S_temp);
                    SP_S_temp   = sqrt(SP_S_temp * SP_S_temp + 64e-8) - 8e-4;
                    sp_dd1          = -SP_S_y0 - 2.0 * (SP_S_qC / (SP_S_pC + sqrt(SP_S_temp)));
                end else begin
                    SP_xg1    = 1.0 / (1.25 + gam * 7.324648775608221e-001);
                    SP_S_A_fac= (x1 * 1.25 * SP_xg1 - 1.0) * SP_xg1;
                    SP_S_xbar = vgfb1 * inv_x1 * (1.0 + SP_S_A_fac * vgfb1);
                    SP_S_temp = lexp(-SP_S_xbar);
                    SP_S_w    = 1.0 - SP_S_temp;
                    SP_S_x1   = vgfb1 + gam2 * 0.5 - gam * sqrt(vgfb1 + gam2 * 0.25 - SP_S_w);
                    SP_S_bx   = (phisf_smooth) + 3.0;
                    SP_S_eta  = `MINF(SP_S_x1, SP_S_bx, 5.0) - 0.5 * (SP_S_bx - sqrt(SP_S_bx * SP_S_bx + 5.0));
                    SP_S_temp = vgfb1 - SP_S_eta;
                    SP_S_temp1= lexp(-SP_S_eta);
                    SP_S_temp2= 1.0 / (2.0 + SP_S_eta * SP_S_eta);
                    SP_S_xi0  = SP_S_eta * SP_S_eta * SP_S_temp2;
                    SP_S_xi1  = 4.0 * (SP_S_eta * SP_S_temp2 * SP_S_temp2);
                    SP_S_xi2  = (8.0 * SP_S_temp2 - 12.0 * SP_S_xi0) * SP_S_temp2 * SP_S_temp2;
                    SP_S_a    = max(1.0e-40, SP_S_temp * SP_S_temp - gam2 * (SP_S_temp1 + SP_S_eta - 1.0 - (exp_ns_smooth) * (SP_S_eta + 1.0 + SP_S_xi0)));
                    SP_S_b    = 1.0 - 0.5 * (gam2 * (SP_S_temp1 - (exp_ns_smooth) * SP_S_xi2));
                    SP_S_c    = 2.0 * SP_S_temp + gam2 * (1.0 - SP_S_temp1 - (exp_ns_smooth) * (1.0 + SP_S_xi1));
                    SP_S_tau  = (phisf_smooth) - SP_S_eta + lln(SP_S_a / gam2);
                    `sigma1(SP_S_a, SP_S_b, SP_S_c, SP_S_tau, SP_S_eta, SP_S_x0)
                    SP_S_delta0 = lexp(SP_S_x0);
                    SP_S_delta1 = 1.0 / SP_S_delta0;
                    SP_S_delta0 = (lexp(SP_S_x0-phisf_smooth));
                    SP_S_temp   = 1.0 / (2.0 + SP_S_x0 * SP_S_x0);
                    SP_S_xi0    = SP_S_x0 * SP_S_x0 * SP_S_temp;
                    SP_S_xi1    = 4.0 * (SP_S_x0 * SP_S_temp * SP_S_temp);
                    SP_S_xi2    = (8.0 * SP_S_temp - 12.0 * SP_S_xi0) * SP_S_temp * SP_S_temp;
                    SP_S_temp   = vgfb1 - SP_S_x0;
                    SP_S_pC     = 2.0 * SP_S_temp + gam2 * (1.0 - SP_S_delta1 + SP_S_delta0 - (exp_ns_smooth) * (1.0 + SP_S_xi1));
                    SP_S_qC     = SP_S_temp * SP_S_temp - gam2 * (SP_S_delta1 + SP_S_x0 - 1.0 + SP_S_delta0 - (exp_ns_smooth) * (SP_S_x0 + 1.0 + SP_S_xi0));
                    SP_S_temp   = 2.0 - gam2 * (SP_S_delta1 + SP_S_delta0 - (exp_ns_smooth) * SP_S_xi2);
                    SP_S_temp   = SP_S_pC * SP_S_pC - 2.0 * (SP_S_qC * SP_S_temp);
                    SP_S_temp   = sqrt(SP_S_temp * SP_S_temp + 64e-8) - 8e-4;
                    sp_dd1      = SP_S_x0 + 2.0 * (SP_S_qC / (SP_S_pC + sqrt(SP_S_temp)));
                end
            end

            xs = sp_dd;
            limit1 = 1.0e-7;
            K11 = 2.0;
            SP_S_tempc =  inv_x1 * inv_x1 * `oneSixth * `invSqrt2;

            T0 = -DVBD1_i * Leff / litl;
            T1 = DVBD0_i * (lexp(0.5*T0) + 2.0*lexp(T0)) * (0.0 + VSCE_i);
            PHIC =  (1.0 + LPE1_i / Leff)*(`P_Q_NIST1998 * NDEPCV_i * (TSI * TSI)) / (2.0 * epssi)+ VBSA;
            phic_s = PHIC-RC*(vgfbb*nVt)*CDSBS1_i+ (1.0+RC)*(phisb0);
            gmesp = (8.0 + (7.0) * tanh(10.0 * ((phic_s/nVt) - phisf) + 50.0))*(1.0-lexp( -GMVD*(sqrt((Vdsx*Vdsx) +1.0e-10))));

            //First Iteration of final Poisson's expression
            if (abs(vgfb1)<= (limit1)) begin
                T0 =  inv_x1 * inv_x1 * `oneSixth * `invSqrt2;
                x7_s         =  vgfb1 * inv_x1 * (1.0 + vgfb1 * (1.0 - (exp_ns)) * gam * T0); // sp-> sp_dd
            end else begin
                T0= (0.5 * (tanh(-5.0 * (vgfb1 - K11)) +  tanh(5.0 * (vgfb1 + K11)) ));
                sp_vfb       =vgfb1 * inv_x1 * (1.0 + vgfb1 * (1.0 - (exp_ns)) * gam * SP_S_tempc) * T0;

                T0  = lexp((xs * nVt - phic_s)/nVt);
                T1  = lexp((sp_vfb * nVt - phic_s)/nVt);
                T2  = ln_one_plus_exp((xs * nVt - phic_s) / nVt) - ln_one_plus_exp((sp_vfb * nVt - phic_s)/nVt);
                T6  = lexp(-xs);
                T7  = xs * xs;
                T8  = 1.0 / (T7 + 2.0);
                T9  = lexp(-phisf);
                T10 = lexp(xs - phisf);
                if (GMCMOD == 0) begin
                    T11 = (1.0 + RC);
                end else begin
                    T11 = (1.0 + 1.0 / (LNDEPCV1*lexp((((sp_dd1 * nVt) / phic_s) - 1.0) * gmesp))) * (1.0 + RC);
                end
                T12 = (1.0 + T0) * T11;
                T3  = -(phisb0 / nVt + T2 / T11);
                T4  = lexp(T3);

                fx   = (vgfb1 - xs) * (vgfb1 - xs) - RT * RT * (vgfbb + T3) * (vgfbb + T3) - gam2 * (T6 - T4 + xs + T3 + T10 - T9 * (xs + 1.0 + T8 * T7));
                f_x  = (2.0 * T0 * (vgfbb + T3) * RT * RT) / T12 - 2.0 * vgfb1 + 2.0 * xs - gam2 * (T10 + T9 * (-2.0 * xs * T8 + 2.0 * xs * xs * xs * T8 * T8 - 1.0) - T6 - T0 / T12 + (T0 * T4) / T12 + 1.0);
                f_xx = 2.0 * RT * RT * T0 * (vgfbb + T3) / T12 - 2.0 * RT * RT * T0 * T0 / (T12 * T12) - gam2 * (T6 + T10 - 2.0 * T9 * T8 * (1.0 - T7 * T8 * (5.0 - 4.0 * T7 * T8)) - T0 / T12 * (1.0 - T0 / (1.0 + T0) - T4 + T0 * T4 / (1.0 + T0) * (1.0 + 1.0 / T11))) - 2.0 * RT * RT * T0 * T0 * (vgfbb + T3) / (T12 * (1.0 + T0)) + 2.0;

                x7_s=xs-(fx/f_x)*(1.0 + ((fx*f_xx)/(2.0*f_x*f_x)));

            end

            //Second Iteration of final Poisson's expression
            xs=x7_s;
            if (abs(vgfb1)<= (limit1)) begin
                T0 =  inv_x1 * inv_x1 * `oneSixth * `invSqrt2;
                x7_s         =  vgfb1 * inv_x1 * (1.0 + vgfb1 * (1.0 - (exp_ns)) * gam * T0); // sp-> sp_dd
            end else begin
                T0= (0.5 * (tanh(-5.0 * (vgfb1 - K11)) +  tanh(5.0 * (vgfb1 + K11)) ));
                sp_vfb       =vgfb1 * inv_x1 * (1.0 + vgfb1 * (1.0 - (exp_ns)) * gam * SP_S_tempc) * T0;

                T0  = lexp((xs * nVt - phic_s)/nVt);
                T1  = lexp((sp_vfb * nVt - phic_s)/nVt);
                T2  = ln_one_plus_exp((xs * nVt - phic_s) / nVt) - ln_one_plus_exp((sp_vfb * nVt - phic_s)/nVt);
                T6  = lexp(-xs);
                T7  = xs * xs;
                T8  = 1.0 / (T7 + 2.0);
                T9  = lexp(-phisf);
                T10 = lexp(xs - phisf);
                if (GMCMOD == 0) begin
                    T11 = (1.0 + RC);
                end else begin
                    T11 = (1.0 + 1.0 / (LNDEPCV1*lexp((((sp_dd1 * nVt) / phic_s) - 1.0) * gmesp))) * (1.0 + RC);
                end
                T12 = (1.0 + T0) * T11;
                T3  = -(phisb0 / nVt + T2 / T11);
                T4  = lexp(T3);

                fx   = (vgfb1 - xs) * (vgfb1 - xs) - RT * RT * (vgfbb + T3) * (vgfbb + T3) - gam2 * (T6 - T4 + xs + T3 + T10 - T9 * (xs + 1.0 + T8 * T7));
                f_x  = (2.0 * T0 * (vgfbb + T3) * RT * RT) / T12 - 2.0 * vgfb1 + 2.0 * xs - gam2 * (T10 + T9 * (-2.0 * xs * T8 + 2.0 * xs * xs * xs * T8 * T8 - 1.0) - T6 - T0 / T12 + (T0 * T4) / T12 + 1.0);
                f_xx = 2.0 * RT * RT * T0 * (vgfbb + T3) / T12 - 2.0 * RT * RT * T0 * T0 / (T12 * T12) - gam2 * (T6 + T10 - 2.0 * T9 * T8 * (1.0 - T7 * T8 * (5.0 - 4.0 * T7 * T8)) - T0 / T12 * (1.0 - T0 / (1.0 + T0) - T4 + T0 * T4 / (1.0 + T0) * (1.0 + 1.0 / T11))) - 2.0 * RT * RT * T0 * T0 * (vgfbb + T3) / (T12 * (1.0 + T0)) + 2.0;

                x7_s=xs-(fx/f_x)*(1.0 + ((fx*f_xx)/(2.0*f_x*f_x)));

            end

            //Third Iteration of final Poisson's expression
            xs=x7_s;
            if (abs(vgfb1)<= (limit1)) begin
                T0 =  inv_x1 * inv_x1 * `oneSixth * `invSqrt2;
                x7_s         =  vgfb1 * inv_x1 * (1.0 + vgfb1 * (1.0 - (exp_ns)) * gam * T0); // sp-> sp_dd
            end else begin
                T0= (0.5 * (tanh(-5.0 * (vgfb1 - K11)) +  tanh(5.0 * (vgfb1 + K11)) ));
                sp_vfb       =vgfb1 * inv_x1 * (1.0 + vgfb1 * (1.0 - (exp_ns)) * gam * SP_S_tempc) * T0;

                T0  = lexp((xs * nVt - phic_s)/nVt);
                T1  = lexp((sp_vfb * nVt - phic_s)/nVt);
                T2  = ln_one_plus_exp((xs * nVt - phic_s) / nVt) - ln_one_plus_exp((sp_vfb * nVt - phic_s)/nVt);
                T6  = lexp(-xs);
                T7  = xs * xs;
                T8  = 1.0 / (T7 + 2.0);
                T9  = lexp(-phisf);
                T10 = lexp(xs - phisf);
                if (GMCMOD == 0) begin
                    T11 = (1.0 + RC);
                end else begin
                    T11 = (1.0 + 1.0 / (LNDEPCV1*lexp((((sp_dd1 * nVt) / phic_s) - 1.0) * gmesp))) * (1.0 + RC);
                end
                T12 = (1.0 + T0) * T11;
                T3  = -(phisb0 / nVt + T2 / T11);
                T4  = lexp(T3);

                fx   = (vgfb1 - xs) * (vgfb1 - xs) - RT * RT * (vgfbb + T3) * (vgfbb + T3) - gam2 * (T6 - T4 + xs + T3 + T10 - T9 * (xs + 1.0 + T8 * T7));
                f_x  = (2.0 * T0 * (vgfbb + T3) * RT * RT) / T12 - 2.0 * vgfb1 + 2.0 * xs - gam2 * (T10 + T9 * (-2.0 * xs * T8 + 2.0 * xs * xs * xs * T8 * T8 - 1.0) - T6 - T0 / T12 + (T0 * T4) / T12 + 1.0);
                f_xx = 2.0 * RT * RT * T0 * (vgfbb + T3) / T12 - 2.0 * RT * RT * T0 * T0 / (T12 * T12) - gam2 * (T6 + T10 - 2.0 * T9 * T8 * (1.0 - T7 * T8 * (5.0 - 4.0 * T7 * T8)) - T0 / T12 * (1.0 - T0 / (1.0 + T0) - T4 + T0 * T4 / (1.0 + T0) * (1.0 + 1.0 / T11))) - 2.0 * RT * RT * T0 * T0 * (vgfbb + T3) / (T12 * (1.0 + T0)) + 2.0;

                x7_s=xs-(fx/f_x)*(1.0 + ((fx*f_xx)/(2.0*f_x*f_x)));

            end
            T2  = ln_one_plus_exp((x7_s * nVt - phic_s) / nVt) - ln_one_plus_exp((sp_vfb * nVt - phic_s)/nVt);
            if (GMCMOD == 0) begin
                T11 = (1.0 + RC);
            end else begin
                T11 = (1.0 + 1.0 / lexp((((sp_dd1 * nVt) / phic_s) - 1.0) * gmesp)) * (1.0 + RC);
            end
            x7_sb = (phisb0 / nVt + T2/T11);
            ebs   = (x7_s - x7_sb)/TSI;

            // Drain current and Charge calculation part starts
            Vdsat_lim    =  3.912023005 * nVt;
            if (x7_s <= 0.0) begin
                qis          =  0.0;
                xgm          =  vgfb1 - x7_s;
                Voxm         =  xgm * nVt;
                Vdsat        =  Vdsat_lim;
                ebs = 0.0;
                Dr = 1.0;
                Nsat = 1.0;
                Mnud = 1.0;
                Mnud1 = 1.0;
                Dvsat = 1.0;
                Dmob  = 1.0;
                Moc = 1.0;
                Mscbe = 1.0;
                Rdrain = RDrainGeo;
                Rsource = RSourceGeo;
            end else begin //vgfb1 >0

                tempc        =  1.0 / (2.0 + x7_s * x7_s);
                xi0s         =  x7_s * x7_s * tempc;
                delta_1s     =  lexp(x7_s);
                Es1          =  1.0 / delta_1s;
                delta_1s     =  lexp(x7_s - phisf);
                Ds           =  delta_1s - lexp(-phisf) * (x7_s + 1.0 + xi0s);
                Ps           =  (vgfb1-x7_s)*(vgfb1-x7_s)*(1.0/gam2) - Ds;
                Ps           =  hypsmooth(Ps - 1.0e-3, 1.0e-5) + 1.0e-3;
                sqms         =  sqrt(Ps);
                xgs          =  gam * sqrt(Ps + Ds);
                qis          =  gam2 * Ds * nVt / (xgs + gam * sqms);
                qbs          =  sqms * gam * nVt;
                Em           =  Es1;

                Dm           =  Ds;

                //Drain saturation voltage part implementation (Ref. BSIM4,BSIM-CMG)
                EeffFactor = 1.0e-8 / (epsratio * TOXE);
                T2 = (qbs  + eta_mu * qis + EBA*ebs * (epsratio * TOXE));
                T3 = 0.5*(T2+sqrt(T2*T2 + 0.001));
                Eeffs = EeffFactor * T3;
                // Ref: BSIM4 mobility model

                T2 = lexp(UCS_a * lln(0.5 * (1.0 + (qis / qbs))));

                T3 = (UA_a + UC_a * Vbsx) * pow(Eeffs, EU_t); //(following BSIM-BULK Decoupled mode)
                T4 = 1.0 + T3;
                `Smooth(T4, 1.0, 0.0015, Dmobs)

                WeffWRFactor = 1.0 / (pow(Weff * 1.0e6, WR_i) * NF);

                Esat = 2.0 * VSATCV_t / U0_a * Dmobs;
                EsatL = Esat * Leff;
                T6 = KSATCV_i * (qis + 2.0 * nVt);

                Vdsat = EsatL * T6 / (EsatL + T6);

                Vdsat   = hypsmooth(Vdsat - 1.0e-3, 1.0e-5) + 1.0e-3;
                T7      = pow((Vds / Vdsat) + 1.0e-6, 1.0 / DELTA_t);
                T8      = pow(1.0 + T7, -DELTA_t);
                Vdseff  = Vds * T8;
                vdeff   = (Vdseff +Vs) * inv_nVt;

                /* Surface potential at Drain side  DD-MODEL*/
                phidf         =  2 * phibCV/n + vdeff;
                exp_nd     =  lexp(-phidf);
                limit       =  1.0e-3 * x1;
                T0 = -DVBD1_i * Leff / litl;
                T1 = DVBD0_i * (lexp(0.5*T0) + 2.0*lexp(T0)) * (Vds* inv_nVt + VSCE_i* inv_nVt);
                phic_star  = (1.0 + LPE1_i / Leff)*(`P_Q_NIST1998 * NDEPCV_i * TSI * TSI) / (2.0 * epssi * nVt) + VBSA/nVt - RC * (vgfbb)*CDSBS1_i + (1.0+RC)*T1;

                vg_FD = phic_star + gam * sqrt(lexp(-phic_star) + phic_star -1.0 );

                if (vgfb1 < (vg_FD)) begin
                    //PD initial Guess
                    if (abs(vgfb1) <= limit) begin
                        T0 =  inv_x1 * inv_x1 * `oneSixth * `invSqrt2;
                        sp_dd         =  vgfb1 * inv_x1 * (1.0 + vgfb1 * (1.0 - (exp_nd)) * gam * T0);// sp-> sp_dd
                    end else begin
                        if (vgfb1 < (-limit)) begin
                            SP_S_yg   = -vgfb1;
                            SP_S_ysub   = 1.25 * (SP_S_yg * inv_x1);
                            SP_S_eta  =  0.5 * (SP_S_ysub + 10.0 - sqrt((SP_S_ysub - 6.0) * (SP_S_ysub - 6.0) + 64.0));
                            SP_S_temp   = SP_S_yg - SP_S_eta;
                            SP_S_a      = SP_S_temp * SP_S_temp + gam2 * (SP_S_eta + 1.0);
                            SP_S_c      = 2.0 * SP_S_temp - gam2;
                            SP_S_tau    = -SP_S_eta + lln(SP_S_a * inv_gam2);
                            `sigma0(SP_S_a, SP_S_c, SP_S_tau, SP_S_eta, SP_S_y0)
                            SP_S_delta0 = lexp(SP_S_y0);
                            SP_S_delta1 = 1.0 / SP_S_delta0;
                            SP_S_temp   = 1.0 / (2.0 + SP_S_y0 * SP_S_y0);
                            SP_S_xi0    = SP_S_y0 * SP_S_y0 * SP_S_temp;
                            SP_S_xi1    = 4.0 * (SP_S_y0 * SP_S_temp * SP_S_temp);
                            SP_S_xi2    = (8.0 * SP_S_temp - 12.0 * SP_S_xi0) * SP_S_temp * SP_S_temp;
                            SP_S_temp   = SP_S_yg - SP_S_y0;
                            SP_S_temp1  = (exp_nd) * SP_S_delta1;
                            SP_S_pC     = 2.0 * SP_S_temp + gam2 * (SP_S_delta0 - 1.0 - SP_S_temp1 + (exp_nd) * (1.0 - SP_S_xi1));
                            SP_S_qC     = SP_S_temp * SP_S_temp - gam2 * (SP_S_delta0 - SP_S_y0 - 1.0 + SP_S_temp1 + (exp_nd) * (SP_S_y0 - 1.0 - SP_S_xi0));
                            SP_S_temp   = 2.0 - gam2 * (SP_S_delta0 + SP_S_temp1 - (exp_nd) * SP_S_xi2);
                            SP_S_temp   = SP_S_pC * SP_S_pC - 2.0 * (SP_S_qC * SP_S_temp);
                            sp_dd          = -SP_S_y0 - 2.0 * (SP_S_qC / (SP_S_pC + sqrt(SP_S_temp)));
                        end else begin
                            SP_xg1    = 1.0 / (1.25 + gam * 7.324648775608221e-001);
                            SP_S_A_fac= (x1 * 1.25 * SP_xg1 - 1.0) * SP_xg1;
                            SP_S_xbar = vgfb1 * inv_x1 * (1.0 + SP_S_A_fac * vgfb1);
                            SP_S_temp = lexp(-SP_S_xbar);
                            SP_S_w    = 1.0 - SP_S_temp;
                            SP_S_x1   = vgfb1 + gam2 * 0.5 - gam * sqrt(vgfb1 + gam2 * 0.25 - SP_S_w);
                            SP_S_bx   = (phidf) + 3.0;
                            SP_S_eta  = `MINF(SP_S_x1, SP_S_bx, 5.0) - 0.5 * (SP_S_bx - sqrt(SP_S_bx * SP_S_bx + 5.0));
                            SP_S_temp = vgfb1 - SP_S_eta;
                            SP_S_temp1= lexp(-SP_S_eta);
                            SP_S_temp2= 1.0 / (2.0 + SP_S_eta * SP_S_eta);
                            SP_S_xi0  = SP_S_eta * SP_S_eta * SP_S_temp2;
                            SP_S_xi1  = 4.0 * (SP_S_eta * SP_S_temp2 * SP_S_temp2);
                            SP_S_xi2  = (8.0 * SP_S_temp2 - 12.0 * SP_S_xi0) * SP_S_temp2 * SP_S_temp2;
                            SP_S_a    = max(1.0e-40, SP_S_temp * SP_S_temp - gam2 * (SP_S_temp1 + SP_S_eta - 1.0 - (exp_nd) * (SP_S_eta + 1.0 + SP_S_xi0)));
                            SP_S_b    = 1.0 - 0.5 * (gam2 * (SP_S_temp1 - (exp_nd) * SP_S_xi2));
                            SP_S_c    = 2.0 * SP_S_temp + gam2 * (1.0 - SP_S_temp1 - (exp_nd) * (1.0 + SP_S_xi1));
                            SP_S_tau  = (phidf) - SP_S_eta + lln(SP_S_a / gam2);
                            `sigma1(SP_S_a, SP_S_b, SP_S_c, SP_S_tau, SP_S_eta, SP_S_x0)
                            SP_S_delta0 = lexp(SP_S_x0);
                            SP_S_delta1 = 1.0 / SP_S_delta0;
                            SP_S_delta0 = lexp(SP_S_x0 - phidf);
                            SP_S_temp   = 1.0 / (2.0 + SP_S_x0 * SP_S_x0);
                            SP_S_xi0    = SP_S_x0 * SP_S_x0 * SP_S_temp;
                            SP_S_xi1    = 4.0 * (SP_S_x0 * SP_S_temp * SP_S_temp);
                            SP_S_xi2    = (8.0 * SP_S_temp - 12.0 * SP_S_xi0) * SP_S_temp * SP_S_temp;
                            SP_S_temp   = vgfb1 - SP_S_x0;
                            SP_S_pC     = 2.0 * SP_S_temp + gam2 * (1.0 - SP_S_delta1 + SP_S_delta0 - (exp_nd) * (1.0 + SP_S_xi1));
                            SP_S_qC     = SP_S_temp * SP_S_temp - gam2 * (SP_S_delta1 + SP_S_x0 - 1.0 + SP_S_delta0 - (exp_nd) * (SP_S_x0 + 1.0 + SP_S_xi0));
                            SP_S_temp   = 2.0 - gam2 * (SP_S_delta1 + SP_S_delta0 - (exp_nd) * SP_S_xi2);
                            SP_S_temp   = SP_S_pC * SP_S_pC - 2.0 * (SP_S_qC * SP_S_temp);
                            sp_dd          = SP_S_x0 + 2.0 * (SP_S_qC / (SP_S_pC + sqrt(SP_S_temp)));
                        end
                    end
                end else begin
                    //FD initial Guess
                    zeta    = RT;
                    zeta2   = zeta * zeta;
                    u_crit  = phic_star - phisb0 * inv_nVt;
                    usf_FD  = vgfb1 - gam * sqrt(lexp(-u_crit) + u_crit -1.0);
                    SP_S_bx = (phidf) + 3.0;
                    SP_S_Z0 =  `MINF(usf_FD, SP_S_bx, 40.0);
                    a_fd = ((vgfb1-SP_S_Z0) * (vgfb1-SP_S_Z0) - zeta2 * (vgfbb-SP_S_Z0 + phic_star) * (vgfbb-SP_S_Z0+phic_star) - gam2 * (phic_star));
                    c_fd = 2.0 * (vgfb1 - SP_S_Z0 ) - 2.0 * zeta2 * (vgfbb - SP_S_Z0 + phic_star) ;
                    c_fd2 = c_fd * c_fd;
                    d_fd = 1.0 - zeta2;
                    if (a_fd < 0) begin
                        a_fd = 0.0;
                    end
                    tau_fd = phidf - SP_S_Z0  + lln(a_fd * inv_gam2);
                    v_fd = a_fd + c_fd;
                    v_fd2 = v_fd * v_fd;
                    mu_fd = v_fd2 / tau_fd  + 0.5 * c_fd2 - a_fd * d_fd;
                    temp1_fd = (c_fd * v_fd) / mu_fd;
                    temp2_fd = ( `oneThird * c_fd2 - a_fd * d_fd);
                    u_first_r = (v_fd * a_fd) / (mu_fd + temp1_fd * temp2_fd);
                    u0_first_FD = SP_S_Z0  + u_first_r;
                    delta0_fd = lexp(u0_first_FD - phidf);
                    p_fd = 2.0 *(vgfb1-u0_first_FD)- 2.0 * zeta2 * (vgfbb-u0_first_FD + phic_star)+ gam2 * delta0_fd;
                    q_fd = (vgfb1-u0_first_FD) * (vgfb1-u0_first_FD) - zeta2 * (vgfbb-u0_first_FD + phic_star) * (vgfbb-u0_first_FD+phic_star)- gam2 * (phic_star+delta0_fd);
                    temp3_fd = 2.0 * q_fd * (2.0- 2.0 * zeta2 - gam2 * delta0_fd);
                    w_fd= (2.0 * q_fd) / (p_fd + sqrt(p_fd * p_fd - temp3_fd));
                    sp_dd  = u0_first_FD + w_fd;
                end

                xs = sp_dd;
                limit1 = 1e-7;
                K11 = 2.0;
                SP_S_tempc =  inv_x1 * inv_x1 * `oneSixth * `invSqrt2 ;
                PHIC =  (1.0 + LPE1_i / Leff)*(`P_Q_NIST1998 * NDEPCV_i * (TSI * TSI)) / (2.0 * epssi) + VBSA;
                T0 = -DVBD1_i * Leff / litl;
                T1 = DVBD0_i * (lexp(0.5*T0) + 2.0*lexp(T0)) * (Vds* inv_nVt + VSCE_i* inv_nVt);
                phic_s =PHIC-RC*(vgfbb*nVt)*CDSBS1_i + (1.0+RC)*T1*nVt+ (1.0+RC)*(phisb0);
                gmesp = (8.0 + (7.0) * tanh(10.0 * ((phic_s/nVt) - phisf) + 50.0))*(1.0-lexp( -GMVD*(sqrt((Vdsx*Vdsx/(1.0)) +1.0e-10))));

                //First Iteration of final Poisson's expression
                if (abs(vgfb1)<= (limit1)) begin
                    T0 =  inv_x1 * inv_x1 * `oneSixth * `invSqrt2;
                    x7_d         =  vgfb1 * inv_x1 * (1.0 + vgfb1 * (1.0 - (exp_ns)) * gam * T0);
                end else begin
                    T0= (0.5 * (tanh(-5.0 * (vgfb1 - K11)) +  tanh(5.0 * (vgfb1 + K11)) ));
                    sp_vfb       =vgfb1 * inv_x1 * (1.0 + vgfb1 * (1.0 - (lexp(-phidf))) * gam * SP_S_tempc) * T0;

                    T0  = lexp((xs * nVt - phic_s)/nVt);
                    T1  = lexp((sp_vfb * nVt - phic_s)/nVt);
                    T2  = ln_one_plus_exp((xs * nVt - phic_s) / nVt) - ln_one_plus_exp((sp_vfb * nVt - phic_s)/nVt);
                    T6  = lexp(-xs);
                    T7  = xs * xs;
                    T8  = 1.0 / (T7 + 2.0);
                    T9  = lexp(-phidf);
                    T10 = lexp(xs - phidf);
                    if (GMCMOD == 0) begin
                        T11 = (1.0 + RC);
                    end else begin
                        T11 = (1.0 + 1.0 / (LNDEPCV1*lexp((((sp_dd1 * nVt) / phic_s) - 1.0) * gmesp))) * (1.0 + RC);
                    end
                    T12 = (1.0 + T0) * T11;
                    T3  = -(phisb0 / nVt + T2 / T11);
                    T4  = lexp(T3);

                    fx   = (vgfb1 - xs) * (vgfb1 - xs) - RT * RT * (vgfbb + T3) * (vgfbb + T3) - gam2 * (T6 - T4 + xs + T3 + T10 - T9 * (xs + 1.0 + T8 * T7));
                    f_x  = (2.0 * T0 * (vgfbb + T3) * RT * RT) / T12 - 2.0 * vgfb1 + 2.0 * xs - gam2 * (T10 + T9 * (-2.0 * xs * T8 + 2.0 * xs * xs * xs * T8 * T8 - 1.0) - T6 - T0 / T12 + (T0 * T4) / T12 + 1.0);
                    f_xx = 2.0 * RT * RT * T0 * (vgfbb + T3) / T12 - 2.0 * RT * RT * T0 * T0 / (T12 * T12) - gam2 * (T6 + T10 - 2.0 * T9 * T8 * (1.0 - T7 * T8 * (5.0 - 4.0 * T7 * T8)) - T0 / T12 * (1.0 - T0 / (1.0 + T0) - T4 + T0 * T4 / (1.0 + T0) * (1.0 + 1.0 / T11))) - 2.0 * RT * RT * T0 * T0 * (vgfbb + T3) / (T12 * (1.0 + T0)) + 2.0;

                    x7_d=xs-(fx/f_x)*(1.0 + ((fx*f_xx)/(2.0*f_x*f_x)));
                end

                //Second Iteration of final Poisson's expression
                xs=x7_d;
                if (abs(vgfb1)<= (limit1)) begin
                    T0 =  inv_x1 * inv_x1 * `oneSixth * `invSqrt2;
                    x7_d         =  vgfb1 * inv_x1 * (1.0 + vgfb1 * (1.0 - (exp_ns)) * gam * T0);
                end else begin
                    T0= (0.5 * (tanh(-5.0 * (vgfb1 - K11)) +  tanh(5.0 * (vgfb1 + K11)) ));
                    sp_vfb       =vgfb1 * inv_x1 * (1.0 + vgfb1 * (1.0 - (lexp(-phidf))) * gam * SP_S_tempc) * T0;

                    T0  = lexp((xs * nVt - phic_s)/nVt);
                    T1  = lexp((sp_vfb * nVt - phic_s)/nVt);
                    T2  = ln_one_plus_exp((xs * nVt - phic_s) / nVt) - ln_one_plus_exp((sp_vfb * nVt - phic_s)/nVt);
                    T6  = lexp(-xs);
                    T7  = xs * xs;
                    T8  = 1.0 / (T7 + 2.0);
                    T9  = lexp(-phidf);
                    T10 = lexp(xs - phidf);
                    if (GMCMOD == 0) begin
                        T11 = (1.0 + RC);
                    end else begin
                        T11 = (1.0 + 1.0 / (LNDEPCV1*lexp((((sp_dd1 * nVt) / phic_s) - 1.0) * gmesp))) * (1.0 + RC);
                    end
                    T12 = (1.0 + T0) * T11;
                    T3  = -(phisb0 / nVt + T2 / T11);
                    T4  = lexp(T3);

                    fx   = (vgfb1 - xs) * (vgfb1 - xs) - RT * RT * (vgfbb + T3) * (vgfbb + T3) - gam2 * (T6 - T4 + xs + T3 + T10 - T9 * (xs + 1.0 + T8 * T7));
                    f_x  = (2.0 * T0 * (vgfbb + T3) * RT * RT) / T12 - 2.0 * vgfb1 + 2.0 * xs - gam2 * (T10 + T9 * (-2.0 * xs * T8 + 2.0 * xs * xs * xs * T8 * T8 - 1.0) - T6 - T0 / T12 + (T0 * T4) / T12 + 1.0);
                    f_xx = 2.0 * RT * RT * T0 * (vgfbb + T3) / T12 - 2.0 * RT * RT * T0 * T0 / (T12 * T12) - gam2 * (T6 + T10 - 2.0 * T9 * T8 * (1.0 - T7 * T8 * (5.0 - 4.0 * T7 * T8)) - T0 / T12 * (1.0 - T0 / (1.0 + T0) - T4 + T0 * T4 / (1.0 + T0) * (1.0 + 1.0 / T11))) - 2.0 * RT * RT * T0 * T0 * (vgfbb + T3) / (T12 * (1.0 + T0)) + 2.0;

                    x7_d=xs-(fx/f_x)*(1.0 + ((fx*f_xx)/(2.0*f_x*f_x)));
                end

                //Third Iteration of final Poisson's expression
                xs=x7_d;
                if (abs(vgfb1)<= (limit1)) begin
                    T0 =  inv_x1 * inv_x1 * `oneSixth * `invSqrt2;
                    x7_d         =  vgfb1 * inv_x1 * (1.0 + vgfb1 * (1.0 - (exp_ns)) * gam * T0);
                end else begin
                    T0= (0.5 * (tanh(-5.0 * (vgfb1 - K11)) +  tanh(5.0 * (vgfb1 + K11)) ));
                    sp_vfb       =vgfb1 * inv_x1 * (1.0 + vgfb1 * (1.0 - (lexp(-phidf))) * gam * SP_S_tempc) * T0;

                    T0  = lexp((xs * nVt - phic_s)/nVt);
                    T1  = lexp((sp_vfb * nVt - phic_s)/nVt);
                    T2  = ln_one_plus_exp((xs * nVt - phic_s) / nVt) - ln_one_plus_exp((sp_vfb * nVt - phic_s)/nVt);
                    T6  = lexp(-xs);
                    T7  = xs * xs;
                    T8  = 1.0 / (T7 + 2.0);
                    T9  = lexp(-phidf);
                    T10 = lexp(xs - phidf);
                    if (GMCMOD == 0) begin
                        T11 = (1.0 + RC);
                    end else begin
                        T11 = (1.0 + 1.0 / (LNDEPCV1*lexp((((sp_dd1 * nVt) / phic_s) - 1.0) * gmesp))) * (1.0 + RC);
                    end
                    T12 = (1.0 + T0) * T11;
                    T3  = -(phisb0 / nVt + T2 / T11);
                    T4  = lexp(T3);

                    fx   = (vgfb1 - xs) * (vgfb1 - xs) - RT * RT * (vgfbb + T3) * (vgfbb + T3) - gam2 * (T6 - T4 + xs + T3 + T10 - T9 * (xs + 1.0 + T8 * T7));
                    f_x  = (2.0 * T0 * (vgfbb + T3) * RT * RT) / T12 - 2.0 * vgfb1 + 2.0 * xs - gam2 * (T10 + T9 * (-2.0 * xs * T8 + 2.0 * xs * xs * xs * T8 * T8 - 1.0) - T6 - T0 / T12 + (T0 * T4) / T12 + 1.0);
                    f_xx = 2.0 * RT * RT * T0 * (vgfbb + T3) / T12 - 2.0 * RT * RT * T0 * T0 / (T12 * T12) - gam2 * (T6 + T10 - 2.0 * T9 * T8 * (1.0 - T7 * T8 * (5.0 - 4.0 * T7 * T8)) - T0 / T12 * (1.0 - T0 / (1.0 + T0) - T4 + T0 * T4 / (1.0 + T0) * (1.0 + 1.0 / T11))) - 2.0 * RT * RT * T0 * T0 * (vgfbb + T3) / (T12 * (1.0 + T0)) + 2.0;

                    x7_d=xs-(fx/f_x)*(1.0 + ((fx*f_xx)/(2.0*f_x*f_x)));
                end
                T2  = ln_one_plus_exp((x7_d * nVt - phic_s) / nVt) - ln_one_plus_exp((sp_vfb * nVt - phic_s)/nVt);
                if (GMCMOD == 0) begin
                    T11 = (1.0 + RC);
                end else begin
                    T11 = (1.0 + 1.0 / lexp((((sp_dd1 * nVt) / phic_s) - 1.0) * gmesp)) * (1.0 + RC);
                end
                x7_db  = (phisb0 / nVt + T2/T11);
                ebd = (x7_d - x7_db)/TSI;
                x_ds         =  x7_d - x7_s;

                //Approximations for extremely small x7_ds: capacitance calculation
                Udse         =  (Vds)*inv_nVt;
                k_ds         =  lexp(-Udse);
                if (x_ds < 1.0e-10) begin
                    T0  = lexp((xs * nVt - phic_s)/nVt);
                    T1  = lexp((sp_vfb * nVt - phic_s)/nVt);
                    T2  = ln_one_plus_exp((xs * nVt - phic_s) / nVt) - ln_one_plus_exp((sp_vfb * nVt - phic_s)/nVt);
                    T6  = lexp(-xs);
                    T7  = xs * xs;
                    T8  = 1.0 / (T7 + 2.0);
                    T9  = lexp(-Udse - phidf);
                    T10 = lexp(xs - Udse - phidf);
                    if (GMCMOD == 0) begin
                        T11 = (1.0 + RC);
                    end else begin
                        T11 = (1.0 + 1.0 / lexp((((sp_dd1 * nVt) / phic_s) - 1.0) * gmesp)) * (1.0 + RC);
                    end
                    T12 = (1.0 + T0) * T11;
                    T3  = -(phisb0 / nVt + T2 / T11);
                    T4  = lexp(T3);

                    pC   = -((2.0 * T0 * (vgfbb + T3) * RT * RT) / T12 - 2.0 * vgfb1 + 2.0 * xs - gam2 * (T10 + T9 * (-2.0 * xs * T8 + 2.0 * xs * xs * xs * T8 * T8 - 1.0) - T6 - T0 / T12 + (T0 * T4) / T12 + 1.0));

                    qC    =  gam2 *(1.0 - k_ds)* Ds;
                    tempc =  2.0 * RT * RT * T0 * (vgfbb + T3) / T12 - 2.0 * RT * RT * T0 * T0 / (T12 * T12) - gam2 * (T6 + T10 - 2.0 * T9 * T8 * (1.0 - T7 * T8 * (5.0 - 4.0 * T7 * T8)) - T0 / T12 * (1.0 - T0 / (1.0 + T0) - T4 + T0 * T4 / (1.0 + T0) * (1.0 + 1.0 / T11))) - 2.0 * RT * RT * T0 * T0 * (vgfbb + T3) / (T12 * (1.0 + T0)) + 2.0;
                    tempc        =  pC * pC - 2.0 * (tempc * qC);
                    if (tempc >= 0.0) begin
                        x_ds         =  2.0 * (qC / (pC + sqrt(tempc)));
                    end
                    x7_d         = x7_s + x_ds;
                end
                dps          =  x_ds * nVt;
                xi0d         =  x7_d * x7_d / (2.0 + x7_d * x7_d);
                Ed           =  lexp(-x7_d);
                Dd           =  lexp(x7_d - phidf) - lexp(-phidf) * (x7_d + 1.0 + xi0d);
                Pd           =  (vgfb1 - x7_d )*(vgfb1 - x7_d )*(1.0/gam2) -  Dd;
                Pd           =  hypsmooth(Pd - 1.0e-3, 1.0e-5) + 1.0e-3;
                sqd          =  sqrt(Pd);

                //--------------------------------------
                xgd          =  gam * sqrt(Pd + Dd);
                qid          =  gam2 * Dd * nVt / (xgd + gam * sqd);

                // Mid-point surface potential
                x_m          =  0.5 * (x7_s + x7_d);
                tempc        =  abs(Ed * Es1);
                Em           =  sqrt(tempc);
                D_bar        =  0.5 * (Ds + Dd);
                Dm           =  D_bar + 0.125 * (x_ds * x_ds * (Em - 2.0 * inv_gam2));
                Pm           =  (vgfb1-x_m )*(vgfb1-x_m )*(1.0/gam2) - Dm;
                xgm          =  gam * sqrt(Dm + Pm);
                Pm           =  hypsmooth(Pm - 1.0e-3, 1.0e-5) + 1.0e-3;
                sqm          =  sqrt(Pm);

                if (PDEMOD==1) begin
                //Poly depletion effect
                    pdef =2 * Cox * Cox * nVt /(`P_Q_NIST1998 * epssi * NGATE_i);
                    d0  =  1.0 - Em + 2.0 * (xgm * (1/gam2));
                    eta_p        =  1.0 / sqrt(1.0 + pdef * xgm);
                    tempc         =  eta_p / (eta_p + 1.0);
                    x_pm         =  pdef * (tempc * tempc *xgm  *xgm)*(Dm /(Dm  + Pm)) ;
                    p_pd         =  2.0 * (xgm - x_pm) + gam2 * (1.0 - Em + Dm);
                    q_pd         =  x_pm * (x_pm - 2.0 * xgm);
                    xi_pd        =  1.0 - 0.5 * (gam2 * (Em + Dm));
                    u_pd         =  q_pd * p_pd / (p_pd * p_pd - xi_pd * q_pd);
                    x_m          =  x_m + u_pd;
                    km           =  lexp(u_pd);
                    Em           =  Em / km;
                    Dm           =  Dm * km;
                    Pm           =  ( vgfb1-x_m+ u_pd )*( vgfb1-x_m+ u_pd)*(1/gam2) -  Dm/ km ;
                    xgm          =  gam * sqrt(Dm + Pm);
                    km0          =  1.0 - Em + 2.0 * (xgm * eta_p * inv_gam2);
                    x_ds         =  x_ds * km * (d0 + D_bar) / (km0 + km * D_bar);
                    dps          =  x_ds * nVt;
                    Pm           =  hypsmooth(Pm - 1.0e-3, 1.0e-5) + 1.0e-3;
                    sqm          =  sqrt(Pm);
                end

                if (abs(dps) > 1e-35) begin
                    alpha_DD    =  (qis - qid) / dps;
                end

                qim          =  nVt * (gam2 * Dm / (xgm + gam * sqm));
                qbm          =  sqm * gam * nVt;
                Voxm         =  xgm * nVt ;
                ebm          = 0.5 * (ebs + ebd);
                // Mobility degradation, Ref: BSIM4
                T2    =  (qbm + eta_mu * qim + EBA*ebm * (epsratio * TOXE));
                T3    = 0.5 * (T2 + sqrt(T2 * T2 + 0.001));
                Eeffm = EeffFactor * T3;

                T2    = pow(0.5 * (1.0 + (qim / qbm)), UCS_a);
                T3    = (UA_a + UC_a * Vbsx) * pow(Eeffm, EU_t); //(following BSIM-BULK Decoupled mode)
                T4    = 1.0 + T3;
                `Smooth(T4, 1.0, 0.0015, Dmob)

                // Velocity saturation (ref. BSIM-BULK) Added PSATE_i
                if ( (PSATBCV_i || PSATECV_i) < 0) begin
                    zetasb      = 1.0 / (1.0 - PSATBCV_i * Vbsx - PSATECV_i * Vesx);
                end else begin
                    zetasb      = 1.0 + PSATBCV_i * Vbsx +  PSATECV_i * Vesx;
                end
                T0      =  qim * zetasb;
                wsat       =  100.0 * (T0 / (100.0 + T0));
                inv_VP = 1.0/VPCV;
                T0         =  ln((1.0 + (Vds - dps) * inv_VP) / (1.0 + (Vdseff  - dps) * inv_VP));
                dL         =  ALPCV * T0;
                DdL        =  1.0 / (1.0 + dL + dL * dL);
                Dmob_dL    =  Dmob*DdL;

                if (PSATCV_i < 0) begin
                    T1       = 1 / (1 - PSATCV_i * wsat);
                end else begin
                    T1       = 1 + PSATCV_i * wsat;
                end
                thesat1    =  THESATCV_i * (T1 / Dmob_dL);
                zsat       =  thesat1 * thesat1 * dps * dps;
                if (TYPE == `ptype) begin
                    zsat       =  zsat / (1.0 + thesat1 * dps);
                end
                Dvsat      =  0.5 * (Dmob_dL * (1.0 + sqrt(1.0 + 2.0 * zsat)));
                Dvsatinv   =  1.0 / Dvsat;

                T0           =  Dmob_dL * Dvsatinv;
                alpha1       =  alpha_DD *  (1.0 + 0.5 * (zsat * T0 * T0));
                alpha1       =  hypsmooth(alpha1 - 1.0e-3, 1.0e-5) + 1.0e-3;
                qim1         =  qim + nVt * alpha_DD;

                H_fact  = ( qim1 / alpha1) * (Dmob_dL / Dvsat);

            end//decoupled CVMOD ends

            // DD  Core Charge/Capacitances CVMOD=1
            if (x7_s <= 0.0) begin
                QG_1           =  Voxm;

                QD_1           =  0.0;
                QB_1           =  QG_1;
                QS_1=0.0;
            end else begin
                Fj         =  0.5 * (dps / H_fact);
                Fj2        =  Fj * Fj;
                QCLM       =  (1.0 - DdL) * (qim - 0.5 * (alpha_DD * dps));
                QG_1       =  Voxm + 0.5 * (eta_p * dps * (Fj * DdL * `oneThird - 1.0 + DdL));
                tempc      =  alpha_DD * dps * `oneSixth;
                QI         =  DdL * (qim + tempc * Fj) + QCLM;
                QD_1       =  0.5 * (DdL * DdL * (qim - tempc * (1.0 - Fj - 0.2 * Fj2)) + QCLM * (1.0 + DdL));
                QB_1       =  QG_1 - QI;
                QS_1       =  (QG_1 - QB_1 - QD_1 );
            end
        end else begin
        // DD  Core Capacitances
            if (x7_s <= 0.0) begin
                QG_1           =  Voxm;

                QD_1           =  0.0;
                QB_1           =  QG_1;
                QS_1=0.0;
            end else begin
                Fj         =  0.5 * (dps / H_fact);
                Fj2        =  Fj * Fj;
                QCLM       =  (1.0 - DdL) * (qim - 0.5 * (alpha_DD * dps));
                QG_1       =  Voxm + 0.5 * (eta_p * dps * (Fj * DdL * `oneThird - 1.0 + DdL));
                tempc      =  alpha_DD * dps * `oneSixth;
                QI         =  DdL * (qim + tempc * Fj) + QCLM;
                QD_1       =  0.5 * (DdL * DdL * (qim - tempc * (1.0 - Fj - 0.2 * Fj2)) + QCLM * (1.0 + DdL));
                QB_1       =  QG_1 - QI;
                QS_1       =  (QG_1 - QB_1 - QD_1 );
            end
        end

        // Quantum mechanical effects
        `Smooth(QB_1, 0.0, 0.1, qbaCV)
        qiaCV      =  (QS_1 + QD_1);
        T0         = (qiaCV + ETAQM * (qbaCV)) / QM0;
        T0 = hypsmooth(T0,1.0e-3);
        T1         = 1.0 + pow(T0, 0.7 * BDOS);
        XDCinv     = ADOS * 1.9e-9 / T1;
        Coxeffinv  = 3.9 * `P_EPS0 / (BSIMBULKTOXP * 3.9 / EPSROX + XDCinv / epsratio);
        QBi        = - (NF * Wact * Lact + AGBCP) * (`P_EPS0 * EPSROX / BSIMBULKTOXP) * QB_1;
        WLCOXVtinv = (NF * Wact * Lact + AGBCP) * Coxeffinv;
        if (sigvds > 0) begin
            QSi = -WLCOXVtinv * QS_1;
            QDi = -WLCOXVtinv * QD_1;
        end else begin
            QSi = -WLCOXVtinv * QD_1;
            QDi = -WLCOXVtinv * QS_1;
        end

        QGi        = - (QBi + QSi + QDi);

        // Outer fringing capacitances
        if (!$param_given(CF)) begin
            CF_i = 2.0 * EPSROX * `P_EPS0 / `M_PI * lln(CFRCOEFF * (1.0 + 0.4e-6 / TOXE));
        end
        Cgsof = CGSO + CF_i;
        Cgdof = CGDO + CF_i;

        // Overlap capacitances
        wdiosCV = Wact / NSEG + PSBCP;
        wdiodCV = Wact / NSEG + PDBCP;
        if (COVMOD == 0) begin
            Qovs = -wdiosCV * NF * Cgsof * Vgs_ov_noswap;
            Qovd = -wdiodCV * NF * Cgdof * Vgd_ov_noswap;
        end else begin
            T0    = sqrt((Vgs_ov_noswap - Vfbsdr + `DELTA_1) * (Vgs_ov_noswap - Vfbsdr + `DELTA_1) + 4.0 * `DELTA_1);
            Vgsov = 0.5 * (Vgs_ov_noswap - Vfbsdr + `DELTA_1 - T0);
            T6    = Vgsov / pow(1.0 + pow((-Vgsov / CKAPPAS1), CKAPPAS2), 1.0 / CKAPPAS2);
            T1    = sqrt(1.0 - 4.0 * T6 / CKAPPAS_i);
            Qovs  = -wdiosCV * NF * (Cgsof * Vgs_ov_noswap + CGSL_i * (Vgs_ov_noswap - Vfbsdr - Vgsov - 0.5 * CKAPPAS_i * (-1.0 + T1)));
            T0    = sqrt((Vgd_ov_noswap - Vfbsdr + `DELTA_1) * (Vgd_ov_noswap - Vfbsdr + `DELTA_1) + 4.0 * `DELTA_1);
            Vgdov = 0.5 * (Vgd_ov_noswap - Vfbsdr + `DELTA_1 - T0);
            T6    = Vgdov / pow(1.0 + pow((-Vgdov / CKAPPAD1), CKAPPAD2), 1.0 / CKAPPAD2);
            T2    = sqrt(1.0 - 4.0 * T6 / CKAPPAD_i);
            Qovd  = -wdiodCV * NF * (Cgdof * Vgd_ov_noswap + CGDL_i * (Vgd_ov_noswap - Vfbsdr - Vgdov - 0.5 * CKAPPAD_i * (-1.0 + T2)));
        end
        Qovb = -devsign * NF * Lact * CGBO * V(gm, bi);
        Qovg = -(Qovs + Qovd + Qovb);

        //Backgate Charges --- related to new introduced substrate terminal
        LeffCVb = Lnew - 2.0 * dLCV - DLCB;
        LeffCVbg = LeffCVb + 2 * DLBG;
        if (NSUB_i > 0) begin
            T0 = lln(NDEP_i / NSUB_i);
            vfbb = -devsign * Vtm * T0;
        end else begin
            T0 = lln(-NDEP_i * NSUB_i / ni / ni);
            vfbb = -devsign * Vtm * T0;
        end

        Vesfb = Ves - vfbb;
        Cbox = 3.453133e-11 / TBOX;
        CboxWL = KB1_i * FBODY * Cbox * (Wact / NSEG * NF * LeffCVbg + AEBCP);
        Qe1 = CboxWL * (Vesfb - Vbs);
        Qsub = Qe1;

        //Sidewall Fringing Capacitance
        if (FBODY1 != 0) begin
            T0 = CSDESW * lln(CFRCOEFF * (1 + TSI / TBOX));
            T1 = PS - W;
            if (T1 > 0.0)
                csesw = T0 * T1;
            else
                csesw = 0.0;

            T1 = PD - W;
            if (T1 > 0.0)
                cdesw = T0 * T1;
            else
                cdesw = 0.0;

            // Extrinsic Bottom S/D to Substrate Charge
            csbox = Cbox * AS;
            csmin = CSDMIN * AS;
            cdbox = Cbox * AD;
            cdmin = CSDMIN * AD;

            //T10 is vse without type conversion
            //T11 is vde without type conversion
            T10 = -devsign * ves;
            T11 = -devsign * ved;

            if (CSDMIN != 0) begin
                T1 = -0.5 * (cdbox - cdmin) / ACEDB;
                T2 = lln(cosh(-ACEDB * T11 + BCEDB));
                T3 = 0.5 * (cdbox + cdmin) * T11;
                qde = T1 * T2 + T3;

                T1 = -0.5 * (csbox - csmin) / ACESB;
                T2 = lln(cosh(-ACESB * T10 + BCESB));
                T3 = 0.5 * (csbox + csmin) * T10;
                qse = T1 * T2 + T3;
            end else begin
                qse = csbox * T10;
                qde = cdbox * T11;
            end
            qse = qse + csesw * T10;
            qde = qde + cdesw * T11;

        end else begin
            qse = 0.0;
            qde = 0.0;
        end

        //AGBCP2 Cap, 4 terminal Capacitor
        if (MODAGBCP2 == 1) begin
            VFBAGBCP2_i = VFBAGBCP2 + DELVTO;
            vg1      = Vg1 * inv_Vt;
            vs1      = Vs1 * inv_Vt;
            vfb      = VFBAGBCP2_i * inv_Vt;
            ve1      = Ve1 * inv_Vt;
            vgfbAGBCP2  = vg1 - vfb;
            phibAGBCP2  = lln(NDEPAGBCP2_d / ni);
            // Normalized body factor
            gamAGBCP2      = sqrt(2.0 * `P_Q_NIST1998 * epssi * NDEPAGBCP2_d * inv_Vt) / Cox;
            //Input conversion for AGBCP2
            gam = gamAGBCP2;
            vgfb1 =vgfbAGBCP2;
            vfbb = VFBB_i * inv_Vt;
            vgfbb = ve1 - vfbb;
            inv_gam = 1.0 / gam;
            gam2 = gam * gam;
            inv_gam2 = 1.0 / gam2;
            phib = phibAGBCP2;
            //Normalized terminal voltages for DDMOD
            NDEP_i = NDEPAGBCP2_d;
            gam_sb = gam / RT;
            x1_sb = 1.0 + gam_sb * `invSqrt2;
            limit_sb = 1.0e-7 * x1_sb;
            x1_csb         =  5.0/4.0;
            inv_xi_sb = (1.0/gam_sb);
            gam_sb2 = gam_sb*gam_sb;
            inv_xg1_sb  =  1.0 / (x1_csb + gam_sb * 7.324648775608221e-1);
            if (abs(vgfbb) <= limit_sb) begin
                pd_sb          =  ((-vgfbb ) * inv_xi_sb)*(1.0+gam_sb*((-vgfbb /(6.0*sqrt(2.0)*x1_sb*x1_sb))));
            end else begin
                if (vgfbb  < (-limit_sb)) begin
                    PD_yg    = -vgfbb ;
                    PD_z     =  x1_csb * PD_yg  * inv_xi_sb;
                    PD_eta   =  0.5 * (PD_z  + 10.0 - sqrt((PD_z  - 6.0) * (PD_z  - 6.0) + 64.0));
                    PD_a     =  (PD_yg   - PD_eta) * (PD_yg   - PD_eta) + gam_sb2 * (PD_eta  + 1.0);
                    PD_c     =  2.0 * (PD_yg   - PD_eta) - gam_sb2;
                    PD_tau   =  lln(PD_a  / gam_sb2) - PD_eta ;
                    `sigma0(PD_a, PD_c, PD_tau, PD_eta, PD_y0)
                    PD_D0    =  lexp(PD_y0);
                    PD_temp  =  PD_yg  - PD_y0 ;
                    PD_p     =  2.0 * PD_temp  + gam_sb2 * (PD_D0  - 1.0);
                    PD_q     =  PD_temp  * PD_temp  + gam_sb2 * (PD_y0  + 1.0 - PD_D0 );
                    PD_xi    =  1.0 - gam_sb2 * 0.5 * PD_D0 ;
                    PD_temp  =  PD_p  * PD_p  - 4.0 * (PD_xi  * PD_q );
                    PD_w     =  2.0 * (PD_q  / (PD_p  + sqrt(PD_temp )));
                    pd_sb    = -(PD_y0  + PD_w );
                end else begin
                    PD_Afac  =  (x1_sb * x1_csb * inv_xg1_sb - 1.0) * inv_xg1_sb;
                    PD_xbar  =  vgfbb  * inv_xi_sb * (1.0 + PD_Afac * vgfbb );
                    PD_temp1 =  lexp(-PD_xbar);
                    PD_w1    =  1.0 - PD_temp1 ;
                    PD_x0    =  vgfbb  + gam_sb2 * 0.5 - gam_sb * sqrt(vgfbb  + gam_sb2 * 0.25 - PD_w1 );
                    PD_D01   =  lexp(-PD_x0);
                    PD_p1    =  2.0 * (vgfbb  - PD_x0 ) + gam_sb2 * (1.0 - PD_D01 );
                    PD_q1    =  (vgfbb  - PD_x0 ) * (vgfbb  - PD_x0 ) - gam_sb2 * (PD_x0  - 1.0 + PD_D01 );
                    PD_xi1   =  1.0 - gam_sb2 * 0.5 * PD_D01 ;
                    PD_temp1 =  PD_p1  * PD_p1  - 4.0 * (PD_xi1  * PD_q1 );
                    PD_u     =  2.0 * (PD_q1  / (PD_p1  + sqrt(PD_temp1 )));
                    pd_sb    =  PD_x0  + PD_u ;
                end
            end
            // One iteration given to correct value even at 10th decimal point
            if (abs(vgfbb)  < (limit_sb)) begin
                phisb0=((-vgfbb ) * inv_xi_sb)*(1.0+gam_sb*((-vgfbb /(6.0*sqrt(2.0)*x1_sb*x1_sb))));
                pd_sb=((-vgfbb ) * inv_xi_sb)*(1.0+gam_sb*((-vgfbb /(6.0*sqrt(2.0)*x1_sb*x1_sb))));
            end else begin
                fx = RT*RT*(vgfbb - pd_sb)*(vgfbb - pd_sb)*(1.0/gam)*(1.0/gam) -(lexp(-pd_sb) + pd_sb -1.0);
                f_x = lexp(-pd_sb) + (RT*RT*(2.0*pd_sb - 2.0*vgfbb))/(gam*gam) - 1.0;
                phisb0 =(pd_sb)-(fx /f_x );
            end
            phisb0=phisb0* Vt;

            // DD-MODEL core source side surface potential
            /* Surface potential at source side  DD-MODEL*/
            x1           =  1.0 + gam * `invSqrt2;
            inv_x1       =  1.0 /  x1;
            phisf         =  2 * phib/n + vs1 ;
            exp_ns     =  lexp(-phisf);
            limit       =  1.0e-3 * x1;
            T0 = -DVBD1_i * Leff / litl;

            phic_star  = (1.0 + LPE1_i / Leff)*(`P_Q_NIST1998 * NDEP_i * TSI * TSI) / (2 * epssi * Vt) + VBSA/Vt - RC * (vgfbb);
            vg_FD = phic_star + gam * sqrt(lexp(-phic_star) + phic_star -1.0) ;

            if (vgfb1 < (vg_FD)) begin
                //PD initial Guess
                if (abs(vgfb1) <= limit) begin
                    T0 =  inv_x1 * inv_x1 * `oneSixth * `invSqrt2;
                    sp_dd         =  vgfb1 * inv_x1 * (1.0 + vgfb1 * (1.0 - (exp_ns)) * gam * T0); // sp-> sp_dd
                end else begin
                    if (vgfb1 < (-limit)) begin
                        SP_S_yg   = -vgfb1;
                        SP_S_ysub   = 1.25 * (SP_S_yg * inv_x1);
                        SP_S_eta  =  0.5 * (SP_S_ysub + 10.0 - sqrt((SP_S_ysub - 6.0) * (SP_S_ysub - 6.0) + 64.0));
                        SP_S_temp   = SP_S_yg - SP_S_eta;
                        SP_S_a      = SP_S_temp * SP_S_temp + gam2 * (SP_S_eta + 1.0);
                        SP_S_c      = 2.0 * SP_S_temp - gam2;
                        SP_S_tau    = -SP_S_eta + lln(SP_S_a * inv_gam2);
                        `sigma0(SP_S_a, SP_S_c, SP_S_tau, SP_S_eta, SP_S_y0)
                        SP_S_delta0 = lexp(SP_S_y0);
                        SP_S_delta1 = 1.0 / SP_S_delta0;
                        SP_S_temp   = 1.0 / (2.0 + SP_S_y0 * SP_S_y0);
                        SP_S_xi0    = SP_S_y0 * SP_S_y0 * SP_S_temp;
                        SP_S_xi1    = 4.0 * (SP_S_y0 * SP_S_temp * SP_S_temp);
                        SP_S_xi2    = (8.0 * SP_S_temp - 12.0 * SP_S_xi0) * SP_S_temp * SP_S_temp;
                        SP_S_temp   = SP_S_yg - SP_S_y0;
                        SP_S_temp1  = (exp_ns) * SP_S_delta1;
                        SP_S_pC     = 2.0 * SP_S_temp + gam2 * (SP_S_delta0 - 1.0 - SP_S_temp1 + (exp_ns) * (1.0 - SP_S_xi1));
                        SP_S_qC     = SP_S_temp * SP_S_temp - gam2 * (SP_S_delta0 - SP_S_y0 - 1.0 + SP_S_temp1 + (exp_ns) * (SP_S_y0 - 1.0 - SP_S_xi0));
                        SP_S_temp   = 2.0 - gam2 * (SP_S_delta0 + SP_S_temp1 - (exp_ns) * SP_S_xi2);
                        SP_S_temp   = SP_S_pC * SP_S_pC - 2.0 * (SP_S_qC * SP_S_temp);
                        SP_S_temp   = sqrt(SP_S_temp * SP_S_temp + 64e-8) - 8e-4;
                        sp_dd          = -SP_S_y0 - 2.0 * (SP_S_qC / (SP_S_pC + sqrt(SP_S_temp)));
                    end else begin
                        SP_xg1    = 1.0 / (1.25 + gam * 7.324648775608221e-001);
                        SP_S_A_fac= (x1 * 1.25 * SP_xg1 - 1.0) * SP_xg1;
                        SP_S_xbar = vgfb1 * inv_x1 * (1.0 + SP_S_A_fac * vgfb1);
                        SP_S_temp = lexp(-SP_S_xbar);
                        SP_S_w    = 1.0 - SP_S_temp;
                        SP_S_x1   = vgfb1 + gam2 * 0.5 - gam * sqrt(vgfb1 + gam2 * 0.25 - SP_S_w);
                        SP_S_bx   = (phisf) + 3.0;
                        SP_S_eta  = `MINF(SP_S_x1, SP_S_bx, 5.0) - 0.5 * (SP_S_bx - sqrt(SP_S_bx * SP_S_bx + 5.0));
                        SP_S_temp = vgfb1 - SP_S_eta;
                        SP_S_temp1= lexp(-SP_S_eta);
                        SP_S_temp2= 1.0 / (2.0 + SP_S_eta * SP_S_eta);
                        SP_S_xi0  = SP_S_eta * SP_S_eta * SP_S_temp2;
                        SP_S_xi1  = 4.0 * (SP_S_eta * SP_S_temp2 * SP_S_temp2);
                        SP_S_xi2  = (8.0 * SP_S_temp2 - 12.0 * SP_S_xi0) * SP_S_temp2 * SP_S_temp2;
                        SP_S_a    = max(1.0e-40, SP_S_temp * SP_S_temp - gam2 * (SP_S_temp1 + SP_S_eta - 1.0 - (exp_ns) * (SP_S_eta + 1.0 + SP_S_xi0)));
                        SP_S_b    = 1.0 - 0.5 * (gam2 * (SP_S_temp1 - (exp_ns) * SP_S_xi2));
                        SP_S_c    = 2.0 * SP_S_temp + gam2 * (1.0 - SP_S_temp1 - (exp_ns) * (1.0 + SP_S_xi1));
                        SP_S_tau  = (phisf) - SP_S_eta + lln(SP_S_a / gam2);
                        `sigma1(SP_S_a, SP_S_b, SP_S_c, SP_S_tau, SP_S_eta, SP_S_x0)
                        SP_S_delta0 = lexp(SP_S_x0);
                        SP_S_delta1 = 1.0 / SP_S_delta0;
                        SP_S_delta0 = lexp(SP_S_x0 - phisf);
                        SP_S_temp   = 1.0 / (2.0 + SP_S_x0 * SP_S_x0);
                        SP_S_xi0    = SP_S_x0 * SP_S_x0 * SP_S_temp;
                        SP_S_xi1    = 4.0 * (SP_S_x0 * SP_S_temp * SP_S_temp);
                        SP_S_xi2    = (8.0 * SP_S_temp - 12.0 * SP_S_xi0) * SP_S_temp * SP_S_temp;
                        SP_S_temp   = vgfb1 - SP_S_x0;
                        SP_S_pC     = 2.0 * SP_S_temp + gam2 * (1.0 - SP_S_delta1 + SP_S_delta0 - (exp_ns) * (1.0 + SP_S_xi1));
                        SP_S_qC     = SP_S_temp * SP_S_temp - gam2 * (SP_S_delta1 + SP_S_x0 - 1.0 + SP_S_delta0 - (exp_ns) * (SP_S_x0 + 1.0 + SP_S_xi0));
                        SP_S_temp   = 2.0 - gam2 * (SP_S_delta1 + SP_S_delta0 - (exp_ns) * SP_S_xi2);
                        SP_S_temp   = SP_S_pC * SP_S_pC - 2.0 * (SP_S_qC * SP_S_temp);
                        SP_S_temp   = sqrt(SP_S_temp * SP_S_temp + 64e-8) - 8e-4;
                        sp_dd          = SP_S_x0 + 2.0 * (SP_S_qC / (SP_S_pC + sqrt(SP_S_temp)));
                    end
                end
            end else begin
                //FD initial Guess
                zeta    = RT;
                zeta2   = zeta * zeta;
                u_crit  = phic_star - phisb0 * inv_Vt;
                usf_FD  = vgfb1 - gam * sqrt(lexp(-u_crit) + u_crit -1);
                SP_S_bx = (phisf) + 3.0;
                SP_S_Z0 =  `MINF(usf_FD, SP_S_bx, 40);
                a_fd = ((vgfb1-SP_S_Z0) * (vgfb1-SP_S_Z0) - zeta2 * (vgfbb-SP_S_Z0 + phic_star) * (vgfbb-SP_S_Z0+phic_star) - gam2 * (phic_star));
                c_fd = 2 * (vgfb1 - SP_S_Z0 ) - 2 * zeta2 * (vgfbb - SP_S_Z0 + phic_star) ;
                c_fd2 = c_fd * c_fd;
                d_fd = 1 - zeta2;
                if (a_fd < 0) begin
                    a_fd = 0;
                end
                tau_fd = phisf - SP_S_Z0  + lln(a_fd * inv_gam2);
                v_fd = a_fd + c_fd;
                v_fd2 = v_fd * v_fd ;
                mu_fd = v_fd2 / tau_fd  + 0.5 * c_fd2 - a_fd * d_fd;
                temp1_fd = (c_fd * v_fd) / mu_fd;
                temp2_fd = ( `oneThird * c_fd2 - a_fd * d_fd) ;
                u_first_r = (v_fd * a_fd) / (mu_fd + temp1_fd * temp2_fd);
                u0_first_FD = SP_S_Z0  + u_first_r;
                delta0_fd = lexp(u0_first_FD - phisf);
                p_fd = 2 *(vgfb1-u0_first_FD)- 2 * zeta2 * (vgfbb-u0_first_FD + phic_star)+ gam2 * delta0_fd;
                q_fd = (vgfb1-u0_first_FD) * (vgfb1-u0_first_FD) - zeta2 * (vgfbb-u0_first_FD + phic_star) * (vgfbb-u0_first_FD+phic_star)- gam2 * (phic_star+delta0_fd);
                temp3_fd = 2 * q_fd * (2- 2 * zeta2 - gam2 * delta0_fd);
                w_fd= (2 * q_fd) / (p_fd + sqrt(p_fd * p_fd - temp3_fd));
                sp_dd  = u0_first_FD + w_fd;
            end

            phisf_smooth      =  2.0 * phib / n - sqrt(vs * vs + 0.000064) + 0.008;
            exp_ns_smooth     =  lexp(-phisf_smooth);

            if (abs(vgfb1) <= limit) begin
                T0 =  inv_x1 * inv_x1 * `oneSixth * `invSqrt2;
                sp_dd1         =  vgfb1 * inv_x1 * (1.0 + vgfb1 * (1.0 - (lexp(-phisf_smooth))) * gam * T0); // sp-> sp_dd
            end else begin
                if (vgfb1 < (-limit)) begin
                    SP_S_yg   = -vgfb1;
                    SP_S_ysub   = 1.25 * (SP_S_yg * inv_x1);
                    SP_S_eta  =  0.5 * (SP_S_ysub + 10.0 - sqrt((SP_S_ysub - 6.0) * (SP_S_ysub - 6.0) + 64.0));
                    SP_S_temp   = SP_S_yg - SP_S_eta;
                    SP_S_a      = SP_S_temp * SP_S_temp + gam2 * (SP_S_eta + 1.0);
                    SP_S_c      = 2.0 * SP_S_temp - gam2;
                    SP_S_tau    = -SP_S_eta + lln(SP_S_a * inv_gam2);
                    `sigma0(SP_S_a, SP_S_c, SP_S_tau, SP_S_eta, SP_S_y0)
                    SP_S_delta0 = lexp(SP_S_y0);
                    SP_S_delta1 = 1.0 / SP_S_delta0;
                    SP_S_temp   = 1.0 / (2.0 + SP_S_y0 * SP_S_y0);
                    SP_S_xi0    = SP_S_y0 * SP_S_y0 * SP_S_temp;
                    SP_S_xi1    = 4.0 * (SP_S_y0 * SP_S_temp * SP_S_temp);
                    SP_S_xi2    = (8.0 * SP_S_temp - 12.0 * SP_S_xi0) * SP_S_temp * SP_S_temp;
                    SP_S_temp   = SP_S_yg - SP_S_y0;
                    SP_S_temp1  = (exp_ns_smooth) * SP_S_delta1;
                    SP_S_pC     = 2.0 * SP_S_temp + gam2 * (SP_S_delta0 - 1.0 - SP_S_temp1 + (exp_ns_smooth) * (1.0 - SP_S_xi1));
                    SP_S_qC     = SP_S_temp * SP_S_temp - gam2 * (SP_S_delta0 - SP_S_y0 - 1.0 + SP_S_temp1 + (exp_ns_smooth) * (SP_S_y0 - 1.0 - SP_S_xi0));
                    SP_S_temp   = 2.0 - gam2 * (SP_S_delta0 + SP_S_temp1 - (exp_ns_smooth) * SP_S_xi2);
                    SP_S_temp   = SP_S_pC * SP_S_pC - 2.0 * (SP_S_qC * SP_S_temp);
                    SP_S_temp   = sqrt(SP_S_temp * SP_S_temp + 64e-8) - 8e-4;
                    sp_dd1      = -SP_S_y0 - 2.0 * (SP_S_qC / (SP_S_pC + sqrt(SP_S_temp)));
                end else begin
                    SP_xg1    = 1.0 / (1.25 + gam * 7.324648775608221e-001);
                    SP_S_A_fac= (x1 * 1.25 * SP_xg1 - 1.0) * SP_xg1;
                    SP_S_xbar = vgfb1 * inv_x1 * (1.0 + SP_S_A_fac * vgfb1);
                    SP_S_temp = lexp(-SP_S_xbar);
                    SP_S_w    = 1.0 - SP_S_temp;
                    SP_S_x1   = vgfb1 + gam2 * 0.5 - gam * sqrt(vgfb1 + gam2 * 0.25 - SP_S_w);
                    SP_S_bx   = (phisf_smooth) + 3.0;
                    SP_S_eta  = `MINF(SP_S_x1, SP_S_bx, 5.0) - 0.5 * (SP_S_bx - sqrt(SP_S_bx * SP_S_bx + 5.0));
                    SP_S_temp = vgfb1 - SP_S_eta;
                    SP_S_temp1= lexp(-SP_S_eta);
                    SP_S_temp2= 1.0 / (2.0 + SP_S_eta * SP_S_eta);
                    SP_S_xi0  = SP_S_eta * SP_S_eta * SP_S_temp2;
                    SP_S_xi1  = 4.0 * (SP_S_eta * SP_S_temp2 * SP_S_temp2);
                    SP_S_xi2  = (8.0 * SP_S_temp2 - 12.0 * SP_S_xi0) * SP_S_temp2 * SP_S_temp2;
                    SP_S_a    = max(1.0e-40, SP_S_temp * SP_S_temp - gam2 * (SP_S_temp1 + SP_S_eta - 1.0 - (exp_ns_smooth) * (SP_S_eta + 1.0 + SP_S_xi0)));
                    SP_S_b    = 1.0 - 0.5 * (gam2 * (SP_S_temp1 - (exp_ns_smooth) * SP_S_xi2));
                    SP_S_c    = 2.0 * SP_S_temp + gam2 * (1.0 - SP_S_temp1 - (exp_ns_smooth) * (1.0 + SP_S_xi1));
                    SP_S_tau  = (phisf_smooth) - SP_S_eta + lln(SP_S_a / gam2);
                    `sigma1(SP_S_a, SP_S_b, SP_S_c, SP_S_tau, SP_S_eta, SP_S_x0)
                    SP_S_delta0 = lexp(SP_S_x0);
                    SP_S_delta1 = 1.0 / SP_S_delta0;
                    SP_S_delta0 = (lexp(SP_S_x0-phisf_smooth));
                    SP_S_temp   = 1.0 / (2.0 + SP_S_x0 * SP_S_x0);
                    SP_S_xi0    = SP_S_x0 * SP_S_x0 * SP_S_temp;
                    SP_S_xi1    = 4.0 * (SP_S_x0 * SP_S_temp * SP_S_temp);
                    SP_S_xi2    = (8.0 * SP_S_temp - 12.0 * SP_S_xi0) * SP_S_temp * SP_S_temp;
                    SP_S_temp   = vgfb1 - SP_S_x0;
                    SP_S_pC     = 2.0 * SP_S_temp + gam2 * (1.0 - SP_S_delta1 + SP_S_delta0 - (exp_ns_smooth) * (1.0 + SP_S_xi1));
                    SP_S_qC     = SP_S_temp * SP_S_temp - gam2 * (SP_S_delta1 + SP_S_x0 - 1.0 + SP_S_delta0 - (exp_ns_smooth) * (SP_S_x0 + 1.0 + SP_S_xi0));
                    SP_S_temp   = 2.0 - gam2 * (SP_S_delta1 + SP_S_delta0 - (exp_ns_smooth) * SP_S_xi2);
                    SP_S_temp   = SP_S_pC * SP_S_pC - 2.0 * (SP_S_qC * SP_S_temp);
                    SP_S_temp   = sqrt(SP_S_temp * SP_S_temp + 64e-8) - 8e-4;
                    sp_dd1      = SP_S_x0 + 2.0 * (SP_S_qC / (SP_S_pC + sqrt(SP_S_temp)));
                end
            end

            xs = sp_dd;
            limit1 = 1e-7;
            K11 = 2;
            SP_S_tempc =  inv_x1 * inv_x1 * `oneSixth * `invSqrt2 ;
            T0 = -DVBD1_i * Leff / litl;

            PHIC =  (1.0 + LPE1_i / Leff)*(`P_Q_NIST1998 * NDEP_i * (TSI * TSI)) / (2 * epssi)+ VBSA;
            phic_s = PHIC-RC*(vgfbb*Vt)*CDSBS1_i+ (1+RC)*(phisb0);
            gmesp = (8.0 + (7.0) * tanh(10.0 * ((phic_s/nVt) - phisf) + 50.0))*(1.0-lexp( -GMVD*(sqrt((Vdsx*Vdsx/(1.0)) +1.0e-10))));

            //First Iteration of final Poisson's expression
            if (abs(vgfb1)<= (limit1)) begin
                T0 =  inv_x1 * inv_x1 * `oneSixth * `invSqrt2;
                x7_s         =  vgfb1 * inv_x1 * (1.0 + vgfb1 * (1.0 - (exp_ns)) * gam * T0); // sp-> sp_dd
            end else begin
                T0= (0.5 * (tanh(-5.0 * (vgfb1 - K11)) +  tanh(5.0 * (vgfb1 + K11)) ));
                sp_vfb       =vgfb1 * inv_x1 * (1.0 + vgfb1 * (1.0 - (exp_ns)) * gam * SP_S_tempc) * T0;

                T0  = lexp((xs * Vt - phic_s)/Vt);
                T1  = lexp((sp_vfb * Vt - phic_s)/Vt);
                T2  = ln_one_plus_exp((xs * Vt - phic_s) / Vt) - ln_one_plus_exp((sp_vfb * Vt - phic_s)/Vt);
                T6  = lexp(-xs);
                T7  = xs * xs;
                T8  = 1.0 / (T7 + 2.0);
                T9  = lexp(-phisf);
                T10 = lexp(xs - phisf);
                if (GMCMOD == 0) begin
                    T11 = (1.0 + RC);
                end else begin
                    T11 = (1.0 + 1.0 / (LNDEPCV1*lexp((((sp_dd1 * nVt) / phic_s) - 1.0) * gmesp))) * (1.0 + RC);
                end
                T12 = (1.0 + T0) * T11;
                T3  = -(phisb0 / Vt + T2 / T11);
                T4  = lexp(T3);

                fx   = (vgfb1 - xs) * (vgfb1 - xs) - RT * RT * (vgfbb + T3) * (vgfbb + T3) - gam2 * (T6 - T4 + xs + T3 + T10 - T9 * (xs + 1.0 + T8 * T7));
                f_x  = (2.0 * T0 * (vgfbb + T3) * RT * RT) / T12 - 2.0 * vgfb1 + 2.0 * xs - gam2 * (T10 + T9 * (-2.0 * xs * T8 + 2.0 * xs * xs * xs * T8 * T8 - 1.0) - T6 - T0 / T12 + (T0 * T4) / T12 + 1.0);
                f_xx = 2.0 * RT * RT * T0 * (vgfbb + T3) / T12 - 2.0 * RT * RT * T0 * T0 / (T12 * T12) - gam2 * (T6 + T10 - 2.0 * T9 * T8 * (1.0 - T7 * T8 * (5.0 - 4.0 * T7 * T8)) - T0 / T12 * (1.0 - T0 / (1.0 + T0) - T4 + T0 * T4 / (1.0 + T0) * (1.0 + 1.0 / T11))) - 2.0 * RT * RT * T0 * T0 * (vgfbb + T3) / (T12 * (1.0 + T0)) + 2.0;

                x7_s=xs-(fx/f_x)*(1.0 + ((fx*f_xx)/(2.0*f_x*f_x)));
            end

            //Second Iteration of final Poisson's expression
            xs=x7_s;
            if (abs(vgfb1)<= (limit1)) begin
                T0 =  inv_x1 * inv_x1 * `oneSixth * `invSqrt2;
                x7_s         =  vgfb1 * inv_x1 * (1.0 + vgfb1 * (1.0 - (exp_ns)) * gam * T0); // sp-> sp_dd
            end else begin
                T0= (0.5 * (tanh(-5.0 * (vgfb1 - K11)) +  tanh(5.0 * (vgfb1 + K11)) ));
                sp_vfb       =vgfb1 * inv_x1 * (1.0 + vgfb1 * (1.0 - (exp_ns)) * gam * SP_S_tempc) * T0;

                T0  = lexp((xs * Vt - phic_s)/Vt);
                T1  = lexp((sp_vfb * Vt - phic_s)/Vt);
                T2  = ln_one_plus_exp((xs * Vt - phic_s) / Vt) - ln_one_plus_exp((sp_vfb * Vt - phic_s)/Vt);
                T6  = lexp(-xs);
                T7  = xs * xs;
                T8  = 1.0 / (T7 + 2.0);
                T9  = lexp(-phisf);
                T10 = lexp(xs - phisf);
                if (GMCMOD == 0) begin
                    T11 = (1.0 + RC);
                end else begin
                    T11 = (1.0 + 1.0 / (LNDEPCV1*lexp((((sp_dd1 * nVt) / phic_s) - 1.0) * gmesp))) * (1.0 + RC);
                end
                T12 = (1.0 + T0) * T11;
                T3  = -(phisb0 / Vt + T2 / T11);
                T4  = lexp(T3);

                fx   = (vgfb1 - xs) * (vgfb1 - xs) - RT * RT * (vgfbb + T3) * (vgfbb + T3) - gam2 * (T6 - T4 + xs + T3 + T10 - T9 * (xs + 1.0 + T8 * T7));
                f_x  = (2.0 * T0 * (vgfbb + T3) * RT * RT) / T12 - 2.0 * vgfb1 + 2.0 * xs - gam2 * (T10 + T9 * (-2.0 * xs * T8 + 2.0 * xs * xs * xs * T8 * T8 - 1.0) - T6 - T0 / T12 + (T0 * T4) / T12 + 1.0);
                f_xx = 2.0 * RT * RT * T0 * (vgfbb + T3) / T12 - 2.0 * RT * RT * T0 * T0 / (T12 * T12) - gam2 * (T6 + T10 - 2.0 * T9 * T8 * (1.0 - T7 * T8 * (5.0 - 4.0 * T7 * T8)) - T0 / T12 * (1.0 - T0 / (1.0 + T0) - T4 + T0 * T4 / (1.0 + T0) * (1.0 + 1.0 / T11))) - 2.0 * RT * RT * T0 * T0 * (vgfbb + T3) / (T12 * (1.0 + T0)) + 2.0;

                x7_s=xs-(fx/f_x)*(1.0 + ((fx*f_xx)/(2.0*f_x*f_x)));
            end

            //Third Iteration of final Poisson's expression
            xs=x7_s;
            if (abs(vgfb1)<= (limit1)) begin
                T0 =  inv_x1 * inv_x1 * `oneSixth * `invSqrt2;
                x7_s         =  vgfb1 * inv_x1 * (1.0 + vgfb1 * (1.0 - (exp_ns)) * gam * T0);// sp-> sp_dd
            end else begin
                T0= (0.5 * (tanh(-5.0 * (vgfb1 - K11)) +  tanh(5.0 * (vgfb1 + K11)) ));
                sp_vfb       =vgfb1 * inv_x1 * (1.0 + vgfb1 * (1.0 - (exp_ns)) * gam * SP_S_tempc) * T0;

                T0  = lexp((xs * Vt - phic_s)/Vt);
                T1  = lexp((sp_vfb * Vt - phic_s)/Vt);
                T2  = ln_one_plus_exp((xs * Vt - phic_s) / Vt) - ln_one_plus_exp((sp_vfb * Vt - phic_s)/Vt);
                T6  = lexp(-xs);
                T7  = xs * xs;
                T8  = 1.0 / (T7 + 2.0);
                T9  = lexp(-phisf);
                T10 = lexp(xs - phisf);
                if (GMCMOD == 0) begin
                    T11 = (1.0 + RC);
                end else begin
                    T11 = (1.0 + 1.0 / (LNDEPCV1*lexp((((sp_dd1 * nVt) / phic_s) - 1.0) * gmesp))) * (1.0 + RC);
                end
                T12 = (1.0 + T0) * T11;
                T3  = -(phisb0 / Vt + T2 / T11);
                T4  = lexp(T3);

                fx   = (vgfb1 - xs) * (vgfb1 - xs) - RT * RT * (vgfbb + T3) * (vgfbb + T3) - gam2 * (T6 - T4 + xs + T3 + T10 - T9 * (xs + 1.0 + T8 * T7));
                f_x  = (2.0 * T0 * (vgfbb + T3) * RT * RT) / T12 - 2.0 * vgfb1 + 2.0 * xs - gam2 * (T10 + T9 * (-2.0 * xs * T8 + 2.0 * xs * xs * xs * T8 * T8 - 1.0) - T6 - T0 / T12 + (T0 * T4) / T12 + 1.0);
                f_xx = 2.0 * RT * RT * T0 * (vgfbb + T3) / T12 - 2.0 * RT * RT * T0 * T0 / (T12 * T12) - gam2 * (T6 + T10 - 2.0 * T9 * T8 * (1.0 - T7 * T8 * (5.0 - 4.0 * T7 * T8)) - T0 / T12 * (1.0 - T0 / (1.0 + T0) - T4 + T0 * T4 / (1.0 + T0) * (1.0 + 1.0 / T11))) - 2.0 * RT * RT * T0 * T0 * (vgfbb + T3) / (T12 * (1.0 + T0)) + 2.0;

                x7_s=xs-(fx/f_x)*(1.0 + ((fx*f_xx)/(2.0*f_x*f_x)));
            end

            // Drain current and Charge calculation part starts
            Vdsat_lim    =  3.912023005 * Vt;
            if (x7_s <= 0.0) begin
                qis          =  0.0;
                xgm          =  vgfb1 - x7_s;
                Voxm         =  xgm * Vt;
                Vdsat        =  Vdsat_lim;

                Dr = 1.0;

                Mnud = 1.0;
                Mnud1 = 1.0;
                Dvsat = 1.0;
                Dmob  = 1.0;
                Moc = 1.0;
                Mscbe = 1.0;
                Rdrain = RDrainGeo;
                Rsource = RSourceGeo;
            end else begin //vgfb1 >0

                tempc        =  1.0 / (2.0 + x7_s * x7_s);
                xi0s         =  x7_s * x7_s * tempc;
                delta_1s     =  lexp(x7_s);
                Es1          =  1.0 / delta_1s;
                delta_1s     =  lexp(x7_s - phisf);
                Ds           =  delta_1s - lexp(-phisf) * (x7_s + 1.0 + xi0s);
                Ps           =  (vgfb1-x7_s)*(vgfb1-x7_s)*(1/gam2) - Ds;
                Ps           =  hypsmooth(Ps - 1.0e-3, 1.0e-5) + 1.0e-3;
                sqms         =  sqrt(Ps);
                xgs          =  gam * sqrt(Ps + Ds);
                qis          =  gam2 * Ds * Vt / (xgs + gam * sqms);
                qbs          =  sqms * gam * Vt;
                Em           =  Es1;

                Dm           =  Ds;

                //Drain saturation voltage part implementation (Ref. BSIM4,BSIM-CMG)
                EeffFactor = 1.0e-8 / (epsratio * TOXE);
                Eeffs = EeffFactor * (qbs  + eta_mu * qis);

                //Ref: BSIM4 mobility model

                T2 = lexp(UCS_a * lln(0.5 * (1.0 + (qis / qbs))));

                T3 = (UA_a + UC_a * Vbsx1) * pow(Eeffs, EU_t) + UD_a / T2;
                T4 = 1.0 + T3;
                `Smooth(T4, 1.0, 0.0015, Dmobs)

                WeffWRFactor = 1.0 / (pow(Weff * 1.0e6, WR_i) * NF);

                `Smooth(Phist - Vbsx1, 0.05, 0.1, PhistVbs)
                sqrtPhistVbs = sqrt(PhistVbs);

                if (RDSMOD == 1) begin
                    Rdss = 0.0;
                end else begin
                    T0   = 1.0 + PRWG_i * qis;
                    T1   = PRWB_i * (sqrtPhistVbs - sqrtPhist);
                    T2   = 1.0 / T0 + T1;
                    T3   = T2 + sqrt(T2 * T2 + 0.01);
                    Rdss = (RDSWMIN_i + RDSW_i * T3) * WeffWRFactor * NF * rdstemp;
                    if (RDSMOD == 2) begin
                        Rdss = (RSourceGeo + (RDSWMIN_i + RDSW_i * T3) * WeffWRFactor * NF + RDrainGeo) * rdstemp;
                    end
                end

                Esat = 2.0 * VSAT_a / U0_a * Dmobs;
                EsatL = Esat * Leff;
                T6 = KSATIV_i * (qis + 2.0 * Vt);

                if (Rdss > 0.0) begin
                    WVCox = Weff * VSAT_a * Cox;
                    T0 = WVCox * Rdss;
                    Ta = 2.0 * T0;
                    Tb = T6 + EsatL + 3.0 * T6 * T0;
                    Tc = T6 * (EsatL + 2.0 * T6 * T0);
                    Vdsat = (Tb - sqrt(Tb * Tb - 2.0 * Ta * Tc)) / Ta;
                end else begin
                    Vdsat = EsatL * T6 / (EsatL + T6);
                end

                if (A0 == 0.0 && AGS == 0.0) begin
                    AbulkIV = 1.0;
                end else begin
                    T1  = Leff / (Leff + sqrt(XJ_i * Xdep));
                    AbulkIV = 1.0 + (A0 * T1 - AGS * T1 * pow(qis,AGS1) * Vt) / (1.0 + KETA * Vbsx1);
                    `Smooth(AbulkIV, 0.1, 0.0005, AbulkIV)
                end

                Vdsat   = hypsmooth(Vdsat - 1.0e-3, 1.0e-5) + 1.0e-3;
                Vdsat    = Vdsat / AbulkIV;
                T7      = pow((Vds / Vdsat) + 1.0e-6, 1.0 / DELTA_t);
                T8      = pow(1.0 + T7, -DELTA_t);
                Vdseff  = Vds * T8;
                vdeff   = (Vdseff +Vs1) * inv_Vt;

                /* Surface potential at Drain side  DD-MODEL*/
                phidf         =  2 * phib/n + vdeff;
                exp_nd     =  lexp(-phidf);
                limit       =  1.0e-3 * x1;

                T0 = -DVBD1_i * Leff / litl;
                T1 = DVBD0_i * (lexp(0.5*T0) + 2.0*lexp(T0)) * (Vds* inv_Vt + VSCE_i* inv_Vt);
                phic_star  = (1.0 + LPE1_i / Leff)*(`P_Q_NIST1998 * NDEP_i * TSI * TSI) / (2 * epssi * Vt) + VBSA/Vt - RC * (vgfbb)*CDSBS1_i + (1+RC)*T1;

                vg_FD = phic_star + gam * sqrt(lexp(-phic_star) + phic_star -1 ) ;

                if (vgfb1 < (vg_FD)) begin
                    //PD initial Guess
                    if (abs(vgfb1) <= limit) begin
                        T0 =  inv_x1 * inv_x1 * `oneSixth * `invSqrt2;
                        sp_dd         =  vgfb1 * inv_x1 * (1.0 + vgfb1 * (1.0 - (exp_nd)) * gam * T0); // sp-> sp_dd
                    end else begin
                        if (vgfb1 < (-limit)) begin
                            SP_S_yg   = -vgfb1;
                            SP_S_ysub   = 1.25 * (SP_S_yg * inv_x1);
                            SP_S_eta  =  0.5 * (SP_S_ysub + 10.0 - sqrt((SP_S_ysub - 6.0) * (SP_S_ysub - 6.0) + 64.0));
                            SP_S_temp   = SP_S_yg - SP_S_eta;
                            SP_S_a      = SP_S_temp * SP_S_temp + gam2 * (SP_S_eta + 1.0);
                            SP_S_c      = 2.0 * SP_S_temp - gam2;
                            SP_S_tau    = -SP_S_eta + lln(SP_S_a * inv_gam2);
                            `sigma0(SP_S_a, SP_S_c, SP_S_tau, SP_S_eta, SP_S_y0)
                            SP_S_delta0 = lexp(SP_S_y0);
                            SP_S_delta1 = 1.0 / SP_S_delta0;
                            SP_S_temp   = 1.0 / (2.0 + SP_S_y0 * SP_S_y0);
                            SP_S_xi0    = SP_S_y0 * SP_S_y0 * SP_S_temp;
                            SP_S_xi1    = 4.0 * (SP_S_y0 * SP_S_temp * SP_S_temp);
                            SP_S_xi2    = (8.0 * SP_S_temp - 12.0 * SP_S_xi0) * SP_S_temp * SP_S_temp;
                            SP_S_temp   = SP_S_yg - SP_S_y0;
                            SP_S_temp1  = (exp_nd) * SP_S_delta1;
                            SP_S_pC     = 2.0 * SP_S_temp + gam2 * (SP_S_delta0 - 1.0 - SP_S_temp1 + (exp_nd) * (1.0 - SP_S_xi1));
                            SP_S_qC     = SP_S_temp * SP_S_temp - gam2 * (SP_S_delta0 - SP_S_y0 - 1.0 + SP_S_temp1 + (exp_nd) * (SP_S_y0 - 1.0 - SP_S_xi0));
                            SP_S_temp   = 2.0 - gam2 * (SP_S_delta0 + SP_S_temp1 - (exp_nd) * SP_S_xi2);
                            SP_S_temp   = SP_S_pC * SP_S_pC - 2.0 * (SP_S_qC * SP_S_temp);
                            sp_dd          = -SP_S_y0 - 2.0 * (SP_S_qC / (SP_S_pC + sqrt(SP_S_temp)));
                        end else begin
                            SP_xg1    = 1.0 / (1.25 + gam * 7.324648775608221e-001);
                            SP_S_A_fac= (x1 * 1.25 * SP_xg1 - 1.0) * SP_xg1;
                            SP_S_xbar = vgfb1 * inv_x1 * (1.0 + SP_S_A_fac * vgfb1);
                            SP_S_temp = lexp(-SP_S_xbar);
                            SP_S_w    = 1.0 - SP_S_temp;
                            SP_S_x1   = vgfb1 + gam2 * 0.5 - gam * sqrt(vgfb1 + gam2 * 0.25 - SP_S_w);
                            SP_S_bx   = (phidf) + 3.0;
                            SP_S_eta  = `MINF(SP_S_x1, SP_S_bx, 5.0) - 0.5 * (SP_S_bx - sqrt(SP_S_bx * SP_S_bx + 5.0));
                            SP_S_temp = vgfb1 - SP_S_eta;
                            SP_S_temp1= lexp(-SP_S_eta);
                            SP_S_temp2= 1.0 / (2.0 + SP_S_eta * SP_S_eta);
                            SP_S_xi0  = SP_S_eta * SP_S_eta * SP_S_temp2;
                            SP_S_xi1  = 4.0 * (SP_S_eta * SP_S_temp2 * SP_S_temp2);
                            SP_S_xi2  = (8.0 * SP_S_temp2 - 12.0 * SP_S_xi0) * SP_S_temp2 * SP_S_temp2;
                            SP_S_a    = max(1.0e-40, SP_S_temp * SP_S_temp - gam2 * (SP_S_temp1 + SP_S_eta - 1.0 - (exp_nd) * (SP_S_eta + 1.0 + SP_S_xi0)));
                            SP_S_b    = 1.0 - 0.5 * (gam2 * (SP_S_temp1 - (exp_nd) * SP_S_xi2));
                            SP_S_c    = 2.0 * SP_S_temp + gam2 * (1.0 - SP_S_temp1 - (exp_nd) * (1.0 + SP_S_xi1));
                            SP_S_tau  = (phidf) - SP_S_eta + lln(SP_S_a / gam2);
                            `sigma1(SP_S_a, SP_S_b, SP_S_c, SP_S_tau, SP_S_eta, SP_S_x0)
                            SP_S_delta0 = lexp(SP_S_x0);
                            SP_S_delta1 = 1.0 / SP_S_delta0;
                            SP_S_delta0 = lexp(SP_S_x0 - phidf);
                            SP_S_temp   = 1.0 / (2.0 + SP_S_x0 * SP_S_x0);
                            SP_S_xi0    = SP_S_x0 * SP_S_x0 * SP_S_temp;
                            SP_S_xi1    = 4.0 * (SP_S_x0 * SP_S_temp * SP_S_temp);
                            SP_S_xi2    = (8.0 * SP_S_temp - 12.0 * SP_S_xi0) * SP_S_temp * SP_S_temp;
                            SP_S_temp   = vgfb1 - SP_S_x0;
                            SP_S_pC     = 2.0 * SP_S_temp + gam2 * (1.0 - SP_S_delta1 + SP_S_delta0 - (exp_nd) * (1.0 + SP_S_xi1));
                            SP_S_qC     = SP_S_temp * SP_S_temp - gam2 * (SP_S_delta1 + SP_S_x0 - 1.0 + SP_S_delta0 - (exp_nd) * (SP_S_x0 + 1.0 + SP_S_xi0));
                            SP_S_temp   = 2.0 - gam2 * (SP_S_delta1 + SP_S_delta0 - (exp_nd) * SP_S_xi2);
                            SP_S_temp   = SP_S_pC * SP_S_pC - 2.0 * (SP_S_qC * SP_S_temp);
                            sp_dd          = SP_S_x0 + 2.0 * (SP_S_qC / (SP_S_pC + sqrt(SP_S_temp)));
                        end
                    end
                end else begin
                    //FD initial Guess
                    zeta    = RT;
                    zeta2   = zeta * zeta;
                    u_crit  = phic_star - phisb0 * inv_Vt;
                    usf_FD  = vgfb1 - gam * sqrt(lexp(-u_crit) + u_crit -1) ;
                    SP_S_bx = (phidf) + 3.0;
                    SP_S_Z0 =  `MINF(usf_FD, SP_S_bx, 40.0);
                    a_fd = ((vgfb1-SP_S_Z0) * (vgfb1-SP_S_Z0) - zeta2 * (vgfbb-SP_S_Z0 + phic_star) * (vgfbb-SP_S_Z0+phic_star) - gam2 * (phic_star));
                    c_fd = 2 * (vgfb1 - SP_S_Z0 ) - 2 * zeta2 * (vgfbb - SP_S_Z0 + phic_star) ;
                    c_fd2 = c_fd * c_fd;
                    d_fd = 1 - zeta2;
                    if (a_fd < 0) begin
                        a_fd = 0;
                    end
                    tau_fd = phidf - SP_S_Z0  + lln(a_fd * inv_gam2);
                    v_fd = a_fd + c_fd;
                    v_fd2 = v_fd * v_fd ;
                    mu_fd = v_fd2 / tau_fd  + 0.5 * c_fd2 - a_fd * d_fd;
                    temp1_fd = (c_fd * v_fd) / mu_fd;
                    temp2_fd = ( `oneThird * c_fd2 - a_fd * d_fd) ;
                    u_first_r = (v_fd * a_fd) / (mu_fd + temp1_fd * temp2_fd);
                    u0_first_FD = SP_S_Z0  + u_first_r;
                    delta0_fd = lexp(u0_first_FD - phidf);
                    p_fd = 2.0 *(vgfb1-u0_first_FD)- 2.0 * zeta2 * (vgfbb-u0_first_FD + phic_star)+ gam2 * delta0_fd;
                    q_fd = (vgfb1-u0_first_FD) * (vgfb1-u0_first_FD) - zeta2 * (vgfbb-u0_first_FD + phic_star) * (vgfbb-u0_first_FD+phic_star)- gam2 * (phic_star+delta0_fd);
                    temp3_fd = 2.0 * q_fd * (2.0- 2.0 * zeta2 - gam2 * delta0_fd);
                    w_fd= (2.0 * q_fd) / (p_fd + sqrt(p_fd * p_fd - temp3_fd));
                    sp_dd  = u0_first_FD + w_fd;
                end

                xs = sp_dd;
                limit1 = 1e-7;
                K11 = 2.0;
                SP_S_tempc =  inv_x1 * inv_x1 * `oneSixth * `invSqrt2 ;
                PHIC =  (1.0 + LPE1_i / Leff)*(`P_Q_NIST1998 * NDEP_i * (TSI * TSI)) / (2 * epssi) + VBSA;
                T0 = -DVBD1_i * Leff / litl;
                T1 = DVBD0_i * (lexp(0.5*T0) + 2.0*lexp(T0)) * (Vds* inv_Vt + VSCE_i* inv_Vt);
                phic_s =PHIC-RC*(vgfbb*Vt)*CDSBS1_i + (1+RC)*T1*Vt+ (1+RC)*(phisb0);

                //First Iteration of final Poisson's expression
                if (abs(vgfb1)<= (limit1)) begin
                    T0 =  inv_x1 * inv_x1 * `oneSixth * `invSqrt2;
                    x7_d         =  vgfb1 * inv_x1 * (1.0 + vgfb1 * (1.0 - (exp_ns)) * gam * T0);
                end else begin
                    T0= (0.5 * (tanh(-5.0 * (vgfb1 - K11)) +  tanh(5.0 * (vgfb1 + K11)) ));
                    sp_vfb       =vgfb1 * inv_x1 * (1.0 + vgfb1 * (1.0 - (exp_ns)) * gam * SP_S_tempc) * T0;

                    T0  = lexp((xs * Vt - phic_s)/Vt);
                    T1  = lexp((sp_vfb * Vt - phic_s)/Vt);
                    T2  = ln_one_plus_exp((xs * Vt - phic_s) / Vt) - ln_one_plus_exp((sp_vfb * Vt - phic_s)/Vt);
                    T6  = lexp(-xs);
                    T7  = xs * xs;
                    T8  = 1.0 / (T7 + 2.0);
                    T9  = lexp(-phidf);
                    T10 = lexp(xs - phidf);
                    if (GMCMOD == 0) begin
                        T11 = (1.0 + RC);
                    end else begin
                        T11 = (1.0 + 1.0 / (LNDEPCV1*lexp((((sp_dd1 * nVt) / phic_s) - 1.0) * gmesp))) * (1.0 + RC);
                    end
                    T12 = (1.0 + T0) * T11;
                    T3  = -(phisb0 / Vt + T2 / T11);
                    T4  = lexp(T3);

                    fx   = (vgfb1 - xs) * (vgfb1 - xs) - RT * RT * (vgfbb + T3) * (vgfbb + T3) - gam2 * (T6 - T4 + xs + T3 + T10 - T9 * (xs + 1.0 + T8 * T7));
                    f_x  = (2.0 * T0 * (vgfbb + T3) * RT * RT) / T12 - 2.0 * vgfb1 + 2.0 * xs - gam2 * (T10 + T9 * (-2.0 * xs * T8 + 2.0 * xs * xs * xs * T8 * T8 - 1.0) - T6 - T0 / T12 + (T0 * T4) / T12 + 1.0);
                    f_xx = 2.0 * RT * RT * T0 * (vgfbb + T3) / T12 - 2.0 * RT * RT * T0 * T0 / (T12 * T12) - gam2 * (T6 + T10 - 2.0 * T9 * T8 * (1.0 - T7 * T8 * (5.0 - 4.0 * T7 * T8)) - T0 / T12 * (1.0 - T0 / (1.0 + T0) - T4 + T0 * T4 / (1.0 + T0) * (1.0 + 1.0 / T11))) - 2.0 * RT * RT * T0 * T0 * (vgfbb + T3) / (T12 * (1.0 + T0)) + 2.0;

                    x7_d=xs-(fx/f_x)*(1.0 + ((fx*f_xx)/(2.0*f_x*f_x)));
                end

                //Second Iteration of final Poisson's expression
                xs=x7_d;
                if (abs(vgfb1)<= (limit1)) begin
                    T0 =  inv_x1 * inv_x1 * `oneSixth * `invSqrt2;
                    x7_d         =  vgfb1 * inv_x1 * (1.0 + vgfb1 * (1.0 - (exp_ns)) * gam * T0);
                end else begin
                    T0= (0.5 * (tanh(-5.0 * (vgfb1 - K11)) +  tanh(5.0 * (vgfb1 + K11)) ));
                    sp_vfb       =vgfb1 * inv_x1 * (1.0 + vgfb1 * (1.0 - (exp_nd)) * gam * SP_S_tempc) * T0;

                    T0  = lexp((xs * Vt - phic_s)/Vt);
                    T1  = lexp((sp_vfb * Vt - phic_s)/Vt);
                    T2  = ln_one_plus_exp((xs * Vt - phic_s) / Vt) - ln_one_plus_exp((sp_vfb * Vt - phic_s)/Vt);
                    T6  = lexp(-xs);
                    T7  = xs * xs;
                    T8  = 1.0 / (T7 + 2.0);
                    T9  = lexp(-phidf);
                    T10 = lexp(xs - phidf);
                    if (GMCMOD == 0) begin
                        T11 = (1.0 + RC);
                    end else begin
                        T11 = (1.0 + 1.0 / (LNDEPCV1*lexp((((sp_dd1 * nVt) / phic_s) - 1.0) * gmesp))) * (1.0 + RC);
                    end
                    T12 = (1.0 + T0) * T11;
                    T3  = -(phisb0 / Vt + T2 / T11);
                    T4  = lexp(T3);

                    fx   = (vgfb1 - xs) * (vgfb1 - xs) - RT * RT * (vgfbb + T3) * (vgfbb + T3) - gam2 * (T6 - T4 + xs + T3 + T10 - T9 * (xs + 1.0 + T8 * T7));
                    f_x  = (2.0 * T0 * (vgfbb + T3) * RT * RT) / T12 - 2.0 * vgfb1 + 2.0 * xs - gam2 * (T10 + T9 * (-2.0 * xs * T8 + 2.0 * xs * xs * xs * T8 * T8 - 1.0) - T6 - T0 / T12 + (T0 * T4) / T12 + 1.0);
                    f_xx = 2.0 * RT * RT * T0 * (vgfbb + T3) / T12 - 2.0 * RT * RT * T0 * T0 / (T12 * T12) - gam2 * (T6 + T10 - 2.0 * T9 * T8 * (1.0 - T7 * T8 * (5.0 - 4.0 * T7 * T8)) - T0 / T12 * (1.0 - T0 / (1.0 + T0) - T4 + T0 * T4 / (1.0 + T0) * (1.0 + 1.0 / T11))) - 2.0 * RT * RT * T0 * T0 * (vgfbb + T3) / (T12 * (1.0 + T0)) + 2.0;

                    x7_d=xs-(fx/f_x)*(1.0 + ((fx*f_xx)/(2.0*f_x*f_x)));
                end

                //Third Iteration of final Poisson's expression
                xs=x7_d;
                if (abs(vgfb1)<= (limit1)) begin
                    T0 =  inv_x1 * inv_x1 * `oneSixth * `invSqrt2;
                    x7_d         =  vgfb1 * inv_x1 * (1.0 + vgfb1 * (1.0 - (exp_ns)) * gam * T0);
                end else begin
                    T0= (0.5 * (tanh(-5.0 * (vgfb1 - K11)) +  tanh(5.0 * (vgfb1 + K11)) ));
                    sp_vfb       =vgfb1 * inv_x1 * (1.0 + vgfb1 * (1.0 - (exp_nd)) * gam * SP_S_tempc) * T0;

                    T0  = lexp((xs * Vt - phic_s)/Vt);
                    T1  = lexp((sp_vfb * Vt - phic_s)/Vt);
                    T2  = ln_one_plus_exp((xs * Vt - phic_s) / Vt) - ln_one_plus_exp((sp_vfb * Vt - phic_s)/Vt);
                    T6  = lexp(-xs);
                    T7  = xs * xs;
                    T8  = 1.0 / (T7 + 2.0);
                    T9  = lexp(-phidf);
                    T10 = lexp(xs - phidf);
                    if (GMCMOD == 0) begin
                        T11 = (1.0 + RC);
                    end else begin
                        T11 = (1.0 + 1.0 / (LNDEPCV1*lexp((((sp_dd1 * nVt) / phic_s) - 1.0) * gmesp))) * (1.0 + RC);
                    end
                    T12 = (1.0 + T0) * T11;
                    T3  = -(phisb0 / Vt + T2 / T11);
                    T4  = lexp(T3);

                    fx   = (vgfb1 - xs) * (vgfb1 - xs) - RT * RT * (vgfbb + T3) * (vgfbb + T3) - gam2 * (T6 - T4 + xs + T3 + T10 - T9 * (xs + 1.0 + T8 * T7));
                    f_x  = (2.0 * T0 * (vgfbb + T3) * RT * RT) / T12 - 2.0 * vgfb1 + 2.0 * xs - gam2 * (T10 + T9 * (-2.0 * xs * T8 + 2.0 * xs * xs * xs * T8 * T8 - 1.0) - T6 - T0 / T12 + (T0 * T4) / T12 + 1.0);
                    f_xx = 2.0 * RT * RT * T0 * (vgfbb + T3) / T12 - 2.0 * RT * RT * T0 * T0 / (T12 * T12) - gam2 * (T6 + T10 - 2.0 * T9 * T8 * (1.0 - T7 * T8 * (5.0 - 4.0 * T7 * T8)) - T0 / T12 * (1.0 - T0 / (1.0 + T0) - T4 + T0 * T4 / (1.0 + T0) * (1.0 + 1.0 / T11))) - 2.0 * RT * RT * T0 * T0 * (vgfbb + T3) / (T12 * (1.0 + T0)) + 2.0;

                    x7_d=xs-(fx/f_x)*(1.0 + ((fx*f_xx)/(2.0*f_x*f_x)));
                end

                x_ds         =  x7_d - x7_s;

                //Approximations for extremely small x7_ds: capacitance calculation
                Udse         =  (Vds)*inv_Vt;
                k_ds         =  lexp(-Udse);
                if (x_ds < 1.0e-10) begin
                    T0  = lexp((xs * Vt - phic_s)/Vt);
                    T1  = lexp((sp_vfb * Vt - phic_s)/Vt);
                    T2  = ln_one_plus_exp((xs * Vt - phic_s) / Vt) - ln_one_plus_exp((sp_vfb * Vt - phic_s)/Vt);
                    T6  = lexp(-xs);
                    T7  = xs * xs;
                    T8  = 1.0 / (T7 + 2.0);
                    T9  = lexp(-Udse - phidf);
                    T10 = lexp(xs - Udse - phidf);
                    if (GMCMOD == 0) begin
                        T11 = (1.0 + RC);
                    end else begin
                        T11 = (1.0 + 1.0 / lexp((((sp_dd1 * Vt) / phic_s) - 1.0) * gmesp)) * (1.0 + RC);
                    end
                    T12 = (1.0 + T0) * T11;
                    T3  = -(phisb0 / Vt + T2 / T11);
                    T4  = lexp(T3);

                    pC   = -((2.0 * T0 * (vgfbb + T3) * RT * RT) / T12 - 2.0 * vgfb1 + 2.0 * xs - gam2 * (T10 + T9 * (-2.0 * xs * T8 + 2.0 * xs * xs * xs * T8 * T8 - 1.0) - T6 - T0 / T12 + (T0 * T4) / T12 + 1.0));

                    qC    =  gam2 *(1.0 - k_ds)* Ds;
                    tempc =  2.0 * RT * RT * T0 * (vgfbb + T3) / T12 - 2.0 * RT * RT * T0 * T0 / (T12 * T12) - gam2 * (T6 + T10 - 2.0 * T9 * T8 * (1.0 - T7 * T8 * (5.0 - 4.0 * T7 * T8)) - T0 / T12 * (1.0 - T0 / (1.0 + T0) - T4 + T0 * T4 / (1.0 + T0) * (1.0 + 1.0 / T11))) - 2.0 * RT * RT * T0 * T0 * (vgfbb + T3) / (T12 * (1.0 + T0)) + 2.0;
                    tempc        =  pC * pC - 2.0 * (tempc * qC);
                    if (tempc >= 0.0) begin
                        x_ds         =  2.0 * (qC / (pC + sqrt(tempc)));
                    end
                    x7_d         = x7_s + x_ds;
                end
                dps          =  x_ds * Vt;

                xi0d         =  x7_d * x7_d / (2.0 + x7_d * x7_d);
                Ed           =  lexp(-x7_d);
                Dd           =  lexp(x7_d - phidf) - lexp(-phidf) * (x7_d + 1.0 + xi0d);
                Pd           = (vgfb1 - x7_d )*(vgfb1 - x7_d )*(1.0/gam2) -  Dd;
                Pd           =  hypsmooth(Pd - 1.0e-3, 1.0e-5) + 1.0e-3;
                sqd          =  sqrt(Pd);

                //--------------------------------------
                xgd          =  gam * sqrt(Pd + Dd);
                qid          =  gam2 * Dd * Vt / (xgd + gam * sqd);

                // Mid-point surface potential

                x_m          =  0.5 * (x7_s + x7_d);

                tempc         =  abs(Ed * Es1);
                Em           =  sqrt(tempc);

                D_bar        =  0.5 * (Ds + Dd);
                Dm           =  D_bar + 0.125 * (x_ds * x_ds * (Em - 2.0 * inv_gam2));
                Pm           =  (vgfb1-x_m )*(vgfb1-x_m )*(1.0/gam2) -  Dm ;
                xgm          =  gam * sqrt(Dm + Pm);
                Pm           =  hypsmooth(Pm - 1.0e-3, 1.0e-5) + 1.0e-3;
                sqm          =  sqrt(Pm);

                if (abs(dps) > 1e-35) begin
                    alpha_DD    =  (qis - qid) / dps;
                end
                qim          =  Vt * (gam2 * Dm / (xgm + gam * sqm));

                Voxm         =  xgm * Vt ;
                alpha1       =  alpha_DD;
                alpha1       = hypsmooth(alpha1 - 1.0e-3, 1.0e-5) + 1.0e-3;
                qim1         =  qim + Vt * alpha1;
                H_fact  = ( qim1 / alpha1);
            end

            // DD  Core Capacitances
            if (x7_s <= 0.0) begin
                QGi_AGBCP3        =  Voxm;

                QDi_AGBCP3        =  0.0;
                QBi_AGBCP3        =  QGi_AGBCP3;
                QSi_AGBCP3        =  0.0;
            end else begin
                Fj         =  0.5 * (dps / H_fact);
                Fj2               =  Fj * Fj;
                QGi_AGBCP3        =  Voxm + 0.5 * (dps * (Fj * `oneThird));
                tempc             =  alpha_DD * dps * `oneSixth;
                Qi_AGBCP3         =  qim + tempc * Fj;
                QDi_AGBCP3        =  0.5 * (qim - tempc * (1.0 - Fj - 0.2 * Fj2));
                QBi_AGBCP3        =  QGi_AGBCP3 - Qi_AGBCP3;
                QSi_AGBCP3        =  (QGi_AGBCP3 - QBi_AGBCP3 - QDi_AGBCP3);
            end

            WLCOX          = AGBCP2 * (`P_EPS0 * EPSROX / BSIMBULKTOXP);
            WLCOXVtinv     = WLCOX;
            QBi_AGBCP2     = - WLCOXVtinv * QBi_AGBCP3;
            if (sigvds > 0) begin
                QSi_AGBCP2 = -WLCOXVtinv * QSi_AGBCP3;
                QDi_AGBCP2 = -WLCOXVtinv * QDi_AGBCP3;
            end else begin
                QSi_AGBCP2 = -WLCOXVtinv * QDi_AGBCP3;
                QDi_AGBCP2 = -WLCOXVtinv * QSi_AGBCP3;
            end
            QGi_AGBCP2     = - (QBi_AGBCP2 + QSi_AGBCP2 + QDi_AGBCP2);
        end else begin
            QBi_AGBCP2 = 0.0;
            QDi_AGBCP2 = 0.0;
            Qi_AGBCP2  = 0.0;
            QSi_AGBCP2 = 0.0;
            QGi_AGBCP2 = 0.0;
        end

        // Charge expressions including fringing and overlap capacitances
        QB = devsign * MULT_Q * (QBi + QBi_AGBCP2+ Qovb + Qbsj + Qbdj);
        QSI_1 = devsign * (QSi + QSi_AGBCP2);
        QSI = devsign * MULT_Q * (QSi + QSi_AGBCP2);
        QDI_1 = devsign * (QDi + QDi_AGBCP2);
        QDI = devsign * MULT_Q * (QDi + QDi_AGBCP2);
        QS  = devsign * MULT_Q * (QSi + QSi_AGBCP2 + Qovs - Qbsj);
        QD  = devsign * MULT_Q * (QDi + QDi_AGBCP2 + Qovd - Qbdj);
        QG = devsign * MULT_Q * (QGi + QGi_AGBCP2 + Qovg);
        // Output
        // Intrinsic charges
        QBI = devsign * MULT_Q * (QBi + QBi_AGBCP2);
        QGI = devsign * MULT_Q * (QGi + QGi_AGBCP2);
        QGIM = devsign * MULT_Q * QGi;
        QGIAGBCP2 = devsign * MULT_Q * QGi_AGBCP2;

        QSIM = devsign * MULT_Q * QSi;
        QSIAGBCP2 = devsign * MULT_Q * QSi_AGBCP2;

        QDIM = devsign * MULT_Q * QDi;
        QDIAGBCP2 = devsign * MULT_Q * QDi_AGBCP2;

        //Gate Current model for SOIMOD=1
        AIGC_i = AIGC_i + AIGC1_i * (TRatio - 1.0);
        AIGS_i = AIGS_i + AIGS1_i * (TRatio - 1.0);
        AIGD_i = AIGD_i + AIGD1_i * (TRatio - 1.0);
        ALPHAGB1_i = ALPHAGB1_i + ALPHAGB1_T_i * (TRatio - 1.0);
        ALPHAGB2_i = ALPHAGB2_i + ALPHAGB2_T_i * (TRatio - 1.0);
        AIGBCP2_i  = AIGBCP2_i + AIGBCP2_T_i * (TRatio - 1.0);

        igb = 0.0; igcs = 0.0;
        igcd   = 0.0; igs    = 0.0; igd = 0.0;

        // Gate-to-body tunneling components
        if ((IGCMOD != 0) || (IGBMOD != 0)) begin
            Voxm1    = nVt * (vgfb - 0.5 *(x7_s + x7_d));
            T1      = sqrt(Voxm1 * Voxm1 + 1.0e-4);
            Voxmacc = 0.5 * (-Voxm1 + T1);
            Voxminv = 0.5 * (Voxm1 + T1);
            if (IGBMOD != 0) begin
                //Igbacc
                T1     = Voxm1 / VECB;
                Vaux_Igbacc = VECB * ln_one_plus_exp(-T1);
                if (VGB2 != 0) begin
                    T0 = 1- Voxmacc / VGB2;
                end else begin
                    T0 = 1;
                end
                if (T0 < 0.01) begin
                    T0 = 0.01;
                end

                T1 = (Leff * Weff / NSEG + AGBCPD / NF ) * AGB2 * ToxRatio;
                T2 = BGB2 * TOXE;

                T3 = T2 * (ALPHAGB2_i - BETAGB2_i * Voxmacc) / T0;
                T4 = lexp(T3);

                igbacc = T1 * Vg * Vaux_Igbacc * T4;
                igbacc = igbacc * igtemp;

                //Igbinv
                T1     = (Voxm1 - EIGBINV_i) / VEVB;
                Vaux_Igbinv = VEVB * ln_one_plus_exp(T1);

                if (VGB1 != 0) begin
                    T0 = 1- Voxminv / VGB1;
                end else begin
                    T0 = 1;
                end

                if (T0 < 0.01) begin
                    T0 = 0.01;
                end

                T1 = (Leff * Weff / NSEG + AGBCPD / NF ) * AGB1 * ToxRatio;
                T2 = BGB1 * TOXE;
                T3 = T2 * (ALPHAGB1_i - BETAGB1_i * Voxminv) / T0;
                T4 = lexp(T3);
                igbinv = T1 * Vg * Vaux_Igbinv * T4;
                igbinv = igbinv * igtemp;
                igb    = NF * (igbacc + igbinv);
                Vfb2 = vfb * nVt + EGGBCP2;
            end

            //Gate tunneling component in the AGBCP2 region
            if ((BODYMOD !=0 && $port_connected(b) != 0 && !(TNODEOUT && !$port_connected(t)) && MODAGBCP2 ==1) && AGBCP2 > 0) begin
                Vgb = devsign * V(gi, bi2);
                T0 = Vgb - Vfb2;
                T1 = sqrt(T0 * T0 + 1.0e-4);
                Vgp_eff = 0.5 * (-T0 + T1 - 1.0e-2);
                T11 = (TYPE == `ntype) ? AGBC2N : AGBC2P;
                T12 = (TYPE == `ntype) ? BGBC2N : BGBC2P;
                T2 = Vgb * Vgp_eff;
                T3 = AIGBCP2_i * CIGBCP2_i - BIGBCP2_i;
                T4 = BIGBCP2_i * CIGBCP2_i;
                T5 = (-T12) * TOXE * (AIGBCP2_i + T3 * Vgp_eff -T4 * Vgp_eff * Vgp_eff);
                T6 = lexp(T5);
                T11 = T11 * AGBCP2 * ToxRatio;
                Ig_agbcp2 = T11 * T2 * T6 * igtemp;
            end else begin
                Ig_agbcp2 = 0.0;
            end

            //Gate to Channel Current
            if (IGCMOD != 0) begin
            // Igcinv
                T1   = AIGC_i - BIGC_i * Voxminv;
                T2   = 1.0 + CIGC_i * Voxminv;
                T3   = Bechvb * T1 * T2;
                T4   = nq * nVt * (qia) * lexp(T3);
                igc0 = NF * Aechvb * T4 * (Vg + 0.5 * Vdsx - 0.5 * (Vs + Vd)) * igtemp;
                // Gate-current partitioning
                Vdseffx = sqrt(Vdseff * Vdseff + 0.01) - 0.1;
                T1      = PIGCD_i * Vdseffx;
                T1_exp  = lexp(-T1);
                T3      = T1 + T1_exp -1.0 + 1.0e-4;
                T4      = 1.0 - (T1 + 1.0) * T1_exp + 1.0e-4;
                T5      = T1 * T1 + 2.0e-4;
                if (sigvds > 0) begin
                    igcd = igc0 * T4 / T5;
                    igcs = igc0 * T3 / T5;
                end else begin
                    igcs = igc0 * T4 / T5;
                    igcd = igc0 * T3 / T5;
                end
                    //Gate to S/D Current
                // Igs
                T2      = Vgs_noswap - Vfbsdr;
                Vgs_eff = sqrt(T2 * T2 + 1.0e-4);
                if (IGCLAMP == 1) begin
                    T1 = hypsmooth((AIGS_i - BIGS_i * Vgs_eff), 1.0e-6);
                    if (CIGS_i < 0.01) begin
                        CIGS_i = 0.01;
                    end
                end else begin
                    T1 = AIGS_i - BIGS_i * Vgs_eff;
                end
                T2       = 1.0 + CIGS_i * Vgs_eff;
                T3       = BechvbEdge * T1 * T2;
                T4       = lexp(T3);
                igs_mult = igtemp * NF * AechvbEdges * DLCIG_i;
                igs      = igs_mult * Vgs_noswap * Vgs_eff * T4;
                // Igd
                T2      = Vgd_noswap - Vfbsdr;
                Vgd_eff = sqrt(T2 * T2 + 1.0e-4);
                if (IGCLAMP == 1) begin
                    T1 = hypsmooth((AIGD_i - BIGD_i * Vgd_eff), 1.0e-6);
                    if (CIGD_i < 0.01) begin
                        CIGD_i = 0.01;
                    end
                end else begin
                    T1 = AIGD_i - BIGD_i * Vgd_eff;
                end
                T2       = 1.0 + CIGD_i * Vgd_eff;
                T3       = BechvbEdge * T1 * T2;
                T4       = lexp(T3);
                igd_mult = igtemp * NF * AechvbEdged * DLCIGD_i;
                igd      = igd_mult * Vgd_noswap * Vgd_eff * T4;
            end
        end
        IGS  = devsign * MULT_I * igs;
        IGD  = devsign * MULT_I * igd;
        IGB  = devsign * MULT_I * igb;
        IGCS = devsign * MULT_I * igcs;
        IGCD = devsign * MULT_I * igcd;

        //Flicker Noise
        Nt      = 4.0 * Vt * `P_Q_NIST1998;
        Esatnoi = 2.0 * VSAT_a / ueff;
        if (EM <= 0.0) begin
            DelClm = 0.0;
        end else begin
            T0     = (diffVds / litl + EM) / Esatnoi;
            DelClm = litl * lln(T0);
            if (DelClm < 0.0) begin
                DelClm = 0.0;
            end
        end
        Nstar = Vt / `P_Q_NIST1998 * (Cox + Cdep + CIT_i);
        Nl    = 2.0 * nq * Cox * Vt * qid * Mnud1 * Mnud / `P_Q_NIST1998;
        T0a   = `P_Q_NIST1998 * `P_Q_NIST1998 * `P_Q_NIST1998 * Vt * abs(ids) * ueff;
        T0b   = `P_Q_NIST1998 * Vt * ids * ids;
        T0c   = NOIA + NOIB * Nl + NOIC * Nl * Nl;
        T0d   = (Nl + Nstar) * (Nl + Nstar);
        T0e   = NOIA * `P_Q_NIST1998 * Vt;

        if (LINTNOI >= Leff/2.0) begin
            $strobe("Warning: LINTNOI = %e is too large - Leff for noise is negative. Re-setting LINTNOI = 0.", LINTNOI);
            LINTNOI_i = 0.0;
        end else begin
            LINTNOI_i = LINTNOI;
        end
        if (NOIA > 0.0 || NOIB > 0.0 || NOIC > 0.0) begin
            Leffnoi   = Leff - 2.0 * LINTNOI_i;
            Leffnoisq = Leffnoi * Leffnoi;
            T0        = 1.0e10 * Cox * Leffnoisq;
            N0        = 2.0 * nq * Cox * Vt * qis * Mnud1 * Mnud / `P_Q_NIST1998;
            T1        = NOIA * lln((N0 + Nstar) / (Nl + Nstar));
            T2        = NOIB * (N0 - Nl);
            T3        = 0.5 * NOIC * (N0 * N0 - Nl * Nl);
            T4        = 1.0e10 * Leffnoisq * Weff * NF;
            Ssi       = T0a / T0 * (T1 + T2 + T3) + T0b / T4 * DelClm * T0c / T0d;
            T5        = Weff * NF * Leffnoi * 1.0e10 * Nstar * Nstar;
            Swi       = T0e / T5 * ids * ids;
            T6        = Swi + Ssi;
            if (T6 > 0.0) begin
                FNPowerAt1Hz = (Ssi * Swi) / T6/(1.0+NOIA1*pow((qis-qid),NOIAX));
            end else begin
                FNPowerAt1Hz = 0.0;
            end
        end else begin
            FNPowerAt1Hz = 0.0;
        end
        I(di, si) <+ flicker_noise(sigvds*MULT_FN*FNPowerAt1Hz, EF, "1overf");

        //Thermal Noise
        T0         = qia / Esatnoi / Leff;
        T1         = T0 * T0;
        T3         = RNOIA * (1.0 + TNOIA * Leff * T1);
        T4         = RNOIB * (1.0 + TNOIB * Leff * T1);
        T5         = RNOIK * (1.0 + TNOIK * Leff * T1);
        ctnoi      = RNOIC * (1.0 + TNOIC * Leff * T1);
        betanoisq  = 3.0 * T3 * T3;
        betanoisq  = (betanoisq - 1.0) * lexp(-Leff / LP) + 1.0;
        betaLowId  = T5 * T5;
        thetanoisq = T4 * T4;
        cm_igid    = 0.0;
        Dptwg=Dvsat;
        case (TNOIMOD)
            0: begin
                QSi   = -NF * Weff * Leff * Cox * Vt * QSI_1;
                QDi   = -NF * Weff * Leff * Cox * Vt * QDI_1;
                T0    = ueff * abs(QSi + QDi);
                T1    = T0 * Rdsi + Leff * Leff;
                Gtnoi = (T0 / T1) * NTNOI;
                sidn  = Nt * Gtnoi;
                I(di, si) <+ white_noise(MULT_I * sidn, "id");
                V(N1) <+ 0.0;
            end
            1: begin
                Vtn   = 2.0 * nq * nVt;
                T0    = ueff * Dptwg * Moc * Cox * Vtn;
                T1    = 0.5 * (qis+qid);
                T3    = T1 + 0.5;
                T4    = T3 * T3;
                T5    = T4 * T3;
                T6    = (qis - qid);
                T7    = T6 * T6;
                T8    = T7 * T6;
                T9    = (6.0 * T1 + 0.5) * T7;
                Lvsat = Leff * Dptwg;
                T10   = Lvsat / Leff;
                T12   = 1.0 + (betaLowId * (Vdseff / Vdsat) / (TNOIK2 + qia));
                T12   = ((T12 - 1.0) * lexp(-Leff / LP)) + 1.0;
                `Smooth(T12, 0.0, 1.0e-1, T12)
                mid   = T0 * NF * Weff / Lvsat * (T1 * T12 + T7 * betanoisq / (12.0 * T3));
                mig   = Lvsat * T10 * T10 * (T1 / T4 - T9 / (60.0 * T4 * T4) + T7 * T7 / (144.0 * T4 * T5)) * 15.0 / 4.0 * thetanoisq / (NF * Weff * 12.0 * T0);
                migid = T10 * (T6 / (12.0 * T3) - T8 / (144.0 * T5)) * ctnoi / 0.395;
                sqid  = sqrt(Nt * mid);
                if (mig > 0.0) begin
                    sqig = sqrt(Nt / mig);
                    if (sqid > 0.0) begin
                        cm_igid = migid * sqig / sqid;
                    end else begin
                        cm_igid = 0.0;
                    end
                end else begin
                    sqig    = 0.0;
                    cm_igid = 0.0;
                end
                I(N2)     <+ white_noise(cm_igid, "corl");
                I(NI)     <+ white_noise(sqig * sqig * (1.0 - cm_igid), "corl");
                I(NI)     <+ -sqig * V(N2);
                I(NC)     <+ ddt(mig * Cox * Weff * NF * Leff * V(NC));
                I(di, si) <+ white_noise(MULT_I * sqid * sqid * (1.0 - cm_igid), "id");
                I(di, si) <+ sqid * MULT_I * V(N2);
                I(gi, si) <+ ddt(0.5 * MULT_Q * ((1.0 + sigvds) * mig * Cox * Weff * NF * Leff * V(NC)));
                I(gi, di) <+ ddt(0.5 * MULT_Q * ((1.0 - sigvds) * mig * Cox * Weff * NF * Leff * V(NC)));
            end
        endcase
        I(N2) <+ V(N2);
        I(NR) <+ V(NR);

        // Low frequency excess noise due to FBE
        I(bi,di) <+ white_noise( 2 * MULT_I * `P_Q_NIST1998 * NOIF * abs(Ibd), "ibd");
        I(bi,si) <+ white_noise( 2 * MULT_I * `P_Q_NIST1998 * NOIF * abs(Ibs), "ibs");

        // Gate current shot noise
        if (IGCMOD != 0) begin
            I(gi, si) <+ white_noise(2.0 * MULT_I * `P_Q_NIST1998 * abs(igcs + igs), "igs");
            I(gi, di) <+ white_noise(2.0 * MULT_I * `P_Q_NIST1998 * abs(igcd + igd), "igd");
        end
        if (IGBMOD != 0) begin
            I(gi, bi) <+ white_noise(2.0 * MULT_I * `P_Q_NIST1998 * abs(igb), "igb");
        end

        if (EDGEFET == 1) begin
            phib_edge     = lln(NDEPEDGE_i / ni);
            Phist         = max(0.4 + Vt * phib_edge + PHIN_i, 0.4);
            sqrtPhist     = sqrt(Phist);

            T1DEP         = sqrt(2.0 * epssi / (`P_Q_NIST1998 * NDEPEDGE_i));
            NFACTOREDGE_t = NFACTOREDGE_i * hypsmooth((1.0 + TNFACTOREDGE_i * (TRatio - 1.0)), 1e-3);
            ETA0EDGE_t    = ETA0EDGE_i * (1.0 + TETA0EDGE_i * (TRatio - 1.0));
            `Smooth(Phist - Vbsx, 0.05, 0.1, PhistVbs)
            sqrtPhistVbs  = sqrt(PhistVbs);
            Xdep          = T1DEP * sqrtPhistVbs;
            Cdep          = epssi / Xdep;
            T2            = CB * CBOX / (CB + CBOX);
            T3            = (CDSCDEDGE_a + CSECSEDEDGE * Vesx - CBCBDEDGE * Vbsx) * Vdsx;
            T4            = CSECSE0EDGE * Vesx + CSECSE0PEDGE * Vesx * Vesx - CBCB0EDGE *Vbsx - CBCB0PEDGE *Vbsx*Vbsx  + Theta_SCE * (CDSCEDGE_i + CSECSEEDGE_i * Vesx + CSECSEPEDGE * Vesx * Vesx + CBCBEDGE_i *Vbsx + CBCBPEDGE *Vbsx * Vbsx+ T3);
            T1            =  (Cox + T2 + CITEDGE_i + NFACTOREDGE_t + T4) / (Cox + T2);
            `Smooth(T1, 1.0, 0.05, n)
            nVt       = n * Vt;
            inv_nVt   = 1.0 / nVt;
            vg    = Vg * inv_nVt;
            vs    = Vs * inv_nVt;
            vfb   = VFB_i * inv_nVt;
            vfbb  = VFBB_i * inv_nVt;
            ve = Ve * inv_nVt;

            dVth_VNUD = K1EDGE_i * (sqrtPhistVbs - sqrtPhist) - (K2EDGE_i) * Vbsx;
            dvth_dibl   = -(ETA0EDGE_t + ETABEDGE_i * Vbsx) * Vdsx;
            dvth_temp = (KT1EDGE_i + KT1LEDGE_i / Leff + KT2EDGE_i * Vbsx) * (pow(TRatio, KT1EXPEDGE_i) - 1.0);
            litl_edge = litl * (1.0 + DVT2EDGE * Vbsx);
            if (litl_edge > 0) begin
                T0       = DVT1EDGE * Leff / litl_edge;
                if (T0 < 40.0) begin
                    theta_sce_edge = 0.5 * DVT0EDGE / (cosh(T0) - 1.0);
                end else begin
                    theta_sce_edge = DVT0EDGE * lexp(-T0);
                end
            end else begin
                theta_sce_edge = 0.0;
            end
            dvth_sce  = theta_sce_edge * (Vbi_edge - Phist);
            // Vth correction for pocket implants
            if (DVTP0EDGE_i > 0.0) begin
                T0 = -DVTP1EDGE_i * Vdsx;
                if (T0 < -`EXPL_THRESHOLD) begin
                    T2 = `MIN_EXPL;
                end else begin
                    T2 = lexp(T0);
                end
                T3        = Leff + DVTP0EDGE_i * (1.0 + T2);
                dVth_ldop = -nVt * lln(Leff / T3);
            end else begin
                dVth_ldop = 0.0;
            end
            T4        = DVTP5EDGE_i + DVTP2EDGE_i / pow(Leff, DVTP3EDGE_i);
            dVth_ldop = dVth_ldop - T4 * tanh(DVTP4EDGE_i * Vdsx);

            Vth_shift = dVth_VNUD + dVth_ldop + dvth_dibl - dvth_temp + dvth_sce + DVTEDGE + vth0_stress_EDGE + vth0_well_edge ;
            vgfb      = vg - vfb - Vth_shift * inv_nVt;

            vgsfb = vg - Vbsx * inv_nVt - vfb - Vth_shift * inv_nVt;

            //Normalized terminal voltages for DDMOD
            vgfb1 = vg - vfb  - Vth_shift * inv_nVt;
            vgfbb = ve - vfbb;

            // Normalized body factor
            gam     = sqrt(2.0 * `P_Q_NIST1998 * epssi * NDEPEDGE_i * inv_nVt) / Cox;
            DGAMMAEDGE_i = DGAMMAEDGE * (1.0 + DGAMMAEDGEL * pow(Leff, -DGAMMAEDGELEXP));
            gam          = gam * (1.0 + DGAMMAEDGE_i);
            inv_gam = 1.0 / gam;
            gam2 = gam * gam;
            inv_gam2 = 1.0 / gam2;
            // DD Model Back potential solved independently for PD decoupled case.
            CB = epssi / TSI;
            CBOX = epsox / TBOX;
            RC= (CBOX +CDSBS_i) / CB ;
            RT = TOXE / TBOX ;
            gam_sb = gam / RT;
            x1_sb = 1.0 + gam_sb * `invSqrt2;
            limit_sb = 1.0e-7 * x1_sb;
            x1_csb         =  5.0/4.0;
            inv_xi_sb = (1.0/gam_sb);
            gam_sb2 = gam_sb*gam_sb;
            inv_xg1_sb  =  1.0 / (x1_csb + gam_sb * 7.324648775608221e-1);
            if (abs(vgfbb) <= limit_sb) begin
                pd_sb        =  ((-vgfbb ) * inv_xi_sb)*(1.0+gam_sb*((-vgfbb /(6.0*sqrt(2.0)*x1_sb*x1_sb))));
            end else begin
                if (vgfbb  < (-limit_sb)) begin
                    PD_yg    =  -vgfbb ;
                    PD_z     =  x1_csb * PD_yg  * inv_xi_sb;
                    PD_eta   =  0.5 * (PD_z  + 10.0 - sqrt((PD_z  - 6.0) * (PD_z  - 6.0) + 64.0));
                    PD_a     =  (PD_yg   - PD_eta) * (PD_yg   - PD_eta) + gam_sb2 * (PD_eta  + 1.0);
                    PD_c     =  2.0 * (PD_yg   - PD_eta) - gam_sb2;
                    PD_tau   =  lln(PD_a  / gam_sb2) - PD_eta ;
                    `sigma0(PD_a, PD_c, PD_tau, PD_eta, PD_y0)
                    PD_D0    =  lexp(PD_y0);
                    PD_temp  =  PD_yg  - PD_y0 ;
                    PD_p     =  2.0 * PD_temp  + gam_sb2 * (PD_D0  - 1.0);
                    PD_q     =  PD_temp  * PD_temp  + gam_sb2 * (PD_y0  + 1.0 - PD_D0 );
                    PD_xi    =  1.0 - gam_sb2 * 0.5 * PD_D0 ;
                    PD_temp  =  PD_p  * PD_p  - 4.0 * (PD_xi  * PD_q );
                    PD_w     =  2.0 * (PD_q  / (PD_p  + sqrt(PD_temp )));
                    pd_sb    = -(PD_y0  + PD_w );
                end else begin
                    PD_Afac  =  (x1_sb * x1_csb * inv_xg1_sb - 1.0) * inv_xg1_sb;
                    PD_xbar  =  vgfbb  * inv_xi_sb * (1.0 + PD_Afac * vgfbb );
                    PD_temp1 = lexp(-PD_xbar);
                    PD_w1    =  1.0 - PD_temp1;
                    PD_x0    =  vgfbb  + gam_sb2 * 0.5 - gam_sb * sqrt(vgfbb  + gam_sb2 * 0.25 - PD_w1 );
                    PD_D01   =  lexp(-PD_x0);
                    PD_p1    =  2.0 * (vgfbb - PD_x0 ) + gam_sb2 * (1.0 - PD_D01 );
                    PD_q1    =  (vgfbb  - PD_x0 ) * (vgfbb  - PD_x0 ) - gam_sb2 * (PD_x0  - 1.0 + PD_D01 );
                    PD_xi1   =  1.0 - gam_sb2 * 0.5 * PD_D01 ;
                    PD_temp1 =  PD_p1  * PD_p1  - 4.0 * (PD_xi1  * PD_q1 );
                    PD_u     =  2.0 * (PD_q1  / (PD_p1  + sqrt(PD_temp1 )));
                    pd_sb    =  PD_x0  + PD_u ;
                end
            end
            // One iteration given to correct value even at 10th decimal point
            if (abs(vgfbb)  < (limit_sb)) begin
                phisb0=((-vgfbb ) * inv_xi_sb)*(1.0+gam_sb*((-vgfbb /(6.0*sqrt(2.0)*x1_sb*x1_sb))));
                pd_sb=((-vgfbb ) * inv_xi_sb)*(1.0+gam_sb*((-vgfbb /(6.0*sqrt(2.0)*x1_sb*x1_sb))));
            end else begin
                fx = RT*RT*(vgfbb - pd_sb)*(vgfbb - pd_sb)*(1.0/gam)*(1.0/gam) -(lexp(-pd_sb) + pd_sb -1.0);
                f_x = lexp(-pd_sb) + (RT*RT*(2.0*pd_sb - 2.0*vgfbb))/(gam*gam) - 1.0;
                phisb0 =(pd_sb)-(fx /f_x );
            end
            phisb0=phisb0* nVt;

            // DD-MODEL core source side surface potential
            /* Surface potential at source side  DD-MODEL*/
            x1           =  1.0 + gam * `invSqrt2;
            inv_x1       =  1.0 /  x1;
            phisf         =  2.0 * phib/n + vs ;
            exp_ns     =  lexp(-phisf);
            limit       =  1.0e-3 * x1;
            T0 = -DVBD1_i * Leff / litl;
            T1 = DVBD0_i * (lexp(0.5*T0) + 2.0*lexp(T0)) * (0.0 + VSCE_i);
            phic_star  = (1.0 + LPE1_i / Leff)*(`P_Q_NIST1998 * NDEP_i * TSI * TSI) / (2.0 * epssi * nVt) + VBSA/nVt - RC * (vgfbb);
            vg_FD = phic_star + gam * sqrt(lexp(-phic_star) + phic_star -1.0) ;

            if (vgfb1 < (vg_FD)) begin
                //PD initial Guess
                if (abs(vgfb1) <= limit) begin
                    T0 =  inv_x1 * inv_x1 * `oneSixth * `invSqrt2;
                    sp_dd         =  vgfb1 * inv_x1 * (1.0 + vgfb1 * (1.0 - (exp_ns)) * gam * T0);
                end else begin
                    if (vgfb1 < (-limit)) begin
                        SP_S_yg   = -vgfb1;
                        SP_S_ysub   = 1.25 * (SP_S_yg * inv_x1);
                        SP_S_eta  =  0.5 * (SP_S_ysub + 10.0 - sqrt((SP_S_ysub - 6.0) * (SP_S_ysub - 6.0) + 64.0));
                        SP_S_temp   = SP_S_yg - SP_S_eta;
                        SP_S_a      = SP_S_temp * SP_S_temp + gam2 * (SP_S_eta + 1.0);
                        SP_S_c      = 2.0 * SP_S_temp - gam2;
                        SP_S_tau    = -SP_S_eta + lln(SP_S_a * inv_gam2);
                        `sigma0(SP_S_a, SP_S_c, SP_S_tau, SP_S_eta, SP_S_y0)
                        SP_S_delta0 = lexp(SP_S_y0);
                        SP_S_delta1 = 1.0 / SP_S_delta0;
                        SP_S_temp   = 1.0 / (2.0 + SP_S_y0 * SP_S_y0);
                        SP_S_xi0    = SP_S_y0 * SP_S_y0 * SP_S_temp;
                        SP_S_xi1    = 4.0 * (SP_S_y0 * SP_S_temp * SP_S_temp);
                        SP_S_xi2    = (8.0 * SP_S_temp - 12.0 * SP_S_xi0) * SP_S_temp * SP_S_temp;
                        SP_S_temp   = SP_S_yg - SP_S_y0;
                        SP_S_temp1  = (exp_ns) * SP_S_delta1;
                        SP_S_pC     = 2.0 * SP_S_temp + gam2 * (SP_S_delta0 - 1.0 - SP_S_temp1 + (exp_ns) * (1.0 - SP_S_xi1));
                        SP_S_qC     = SP_S_temp * SP_S_temp - gam2 * (SP_S_delta0 - SP_S_y0 - 1.0 + SP_S_temp1 + (exp_ns) * (SP_S_y0 - 1.0 - SP_S_xi0));
                        SP_S_temp   = 2.0 - gam2 * (SP_S_delta0 + SP_S_temp1 - (exp_ns) * SP_S_xi2);
                        SP_S_temp   = SP_S_pC * SP_S_pC - 2.0 * (SP_S_qC * SP_S_temp);
                        SP_S_temp   = sqrt(SP_S_temp * SP_S_temp + 64e-8) - 8e-4;
                        sp_dd          = -SP_S_y0 - 2.0 * (SP_S_qC / (SP_S_pC + sqrt(SP_S_temp)));
                    end else begin
                        SP_xg1    = 1.0 / (1.25 + gam * 7.324648775608221e-001);
                        SP_S_A_fac= (x1 * 1.25 * SP_xg1 - 1.0) * SP_xg1;
                        SP_S_xbar = vgfb1 * inv_x1 * (1.0 + SP_S_A_fac * vgfb1);
                        SP_S_temp = lexp(-SP_S_xbar);
                        SP_S_w    = 1.0 - SP_S_temp;
                        SP_S_x1   = vgfb1 + gam2 * 0.5 - gam * sqrt(vgfb1 + gam2 * 0.25 - SP_S_w);
                        SP_S_bx   = (phisf) + 3.0;
                        SP_S_eta  = `MINF(SP_S_x1, SP_S_bx, 5.0) - 0.5 * (SP_S_bx - sqrt(SP_S_bx * SP_S_bx + 5.0));
                        SP_S_temp = vgfb1 - SP_S_eta;
                        SP_S_temp1= lexp(-SP_S_eta);
                        SP_S_temp2= 1.0 / (2.0 + SP_S_eta * SP_S_eta);
                        SP_S_xi0  = SP_S_eta * SP_S_eta * SP_S_temp2;
                        SP_S_xi1  = 4.0 * (SP_S_eta * SP_S_temp2 * SP_S_temp2);
                        SP_S_xi2  = (8.0 * SP_S_temp2 - 12.0 * SP_S_xi0) * SP_S_temp2 * SP_S_temp2;
                        SP_S_a    = max(1.0e-40, SP_S_temp * SP_S_temp - gam2 * (SP_S_temp1 + SP_S_eta - 1.0 - (exp_ns) * (SP_S_eta + 1.0 + SP_S_xi0)));
                        SP_S_b    = 1.0 - 0.5 * (gam2 * (SP_S_temp1 - (exp_ns) * SP_S_xi2));
                        SP_S_c    = 2.0 * SP_S_temp + gam2 * (1.0 - SP_S_temp1 - (exp_ns) * (1.0 + SP_S_xi1));
                        SP_S_tau  = (phisf) - SP_S_eta + lln(SP_S_a / gam2);
                        `sigma1(SP_S_a, SP_S_b, SP_S_c, SP_S_tau, SP_S_eta, SP_S_x0)
                        SP_S_delta0 = lexp(SP_S_x0);
                        SP_S_delta1 = 1.0 / SP_S_delta0;
                        SP_S_delta0 = lexp(SP_S_x0 - phisf);
                        SP_S_temp   = 1.0 / (2.0 + SP_S_x0 * SP_S_x0);
                        SP_S_xi0    = SP_S_x0 * SP_S_x0 * SP_S_temp;
                        SP_S_xi1    = 4.0 * (SP_S_x0 * SP_S_temp * SP_S_temp);
                        SP_S_xi2    = (8.0 * SP_S_temp - 12.0 * SP_S_xi0) * SP_S_temp * SP_S_temp;
                        SP_S_temp   = vgfb1 - SP_S_x0;
                        SP_S_pC     = 2.0 * SP_S_temp + gam2 * (1.0 - SP_S_delta1 + SP_S_delta0 - (exp_ns) * (1.0 + SP_S_xi1));
                        SP_S_qC     = SP_S_temp * SP_S_temp - gam2 * (SP_S_delta1 + SP_S_x0 - 1.0 + SP_S_delta0 - (exp_ns) * (SP_S_x0 + 1.0 + SP_S_xi0));
                        SP_S_temp   = 2.0 - gam2 * (SP_S_delta1 + SP_S_delta0 - (exp_ns) * SP_S_xi2);
                        SP_S_temp   = SP_S_pC * SP_S_pC - 2.0 * (SP_S_qC * SP_S_temp);
                        SP_S_temp   = sqrt(SP_S_temp * SP_S_temp + 64e-8) - 8e-4;
                        sp_dd       = SP_S_x0 + 2.0 * (SP_S_qC / (SP_S_pC + sqrt(SP_S_temp)));
                    end
                end
            end else begin
                //FD initial Guess
                zeta    = RT;
                zeta2   = zeta * zeta;
                u_crit  = phic_star - phisb0 * inv_nVt;
                usf_FD  = vgfb1 - gam * sqrt(lexp(-u_crit) + u_crit -1.0) ;
                SP_S_bx = (phisf) + 3.0;
                SP_S_Z0 =  `MINF(usf_FD, SP_S_bx, 40.0);
                a_fd = ((vgfb1-SP_S_Z0) * (vgfb1-SP_S_Z0) - zeta2 * (vgfbb-SP_S_Z0 + phic_star) * (vgfbb-SP_S_Z0+phic_star) - gam2 * (phic_star));
                c_fd = 2.0 * (vgfb1 - SP_S_Z0 ) - 2.0 * zeta2 * (vgfbb - SP_S_Z0 + phic_star) ;
                c_fd2 = c_fd * c_fd;
                d_fd = 1.0 - zeta2;
                if (a_fd < 0) begin
                    a_fd = 0.0;
                end
                tau_fd = phisf - SP_S_Z0  + lln(a_fd * inv_gam2);
                v_fd = a_fd + c_fd;
                v_fd2 = v_fd * v_fd;
                mu_fd = v_fd2 / tau_fd  + 0.5 * c_fd2 - a_fd * d_fd;
                temp1_fd = (c_fd * v_fd) / mu_fd;
                temp2_fd = ( `oneThird * c_fd2 - a_fd * d_fd);
                u_first_r = (v_fd * a_fd) / (mu_fd + temp1_fd * temp2_fd);
                u0_first_FD = SP_S_Z0  + u_first_r;
                delta0_fd = lexp(u0_first_FD - phisf);
                p_fd = 2 *(vgfb1-u0_first_FD)- 2.0 * zeta2 * (vgfbb-u0_first_FD + phic_star)+ gam2 * delta0_fd;
                q_fd = (vgfb1-u0_first_FD) * (vgfb1-u0_first_FD) - zeta2 * (vgfbb-u0_first_FD + phic_star) * (vgfbb-u0_first_FD+phic_star)- gam2 * (phic_star+delta0_fd);
                temp3_fd = 2.0 * q_fd * (2.0- 2.0 * zeta2 - gam2 * delta0_fd);
                w_fd= (2.0 * q_fd) / (p_fd + sqrt(p_fd * p_fd - temp3_fd));
                sp_dd  = u0_first_FD + w_fd;
            end

            phisf_smooth      =  2.0 * phib / n - sqrt(vs * vs + 0.000064) + 0.008;
            exp_ns_smooth     =  lexp(-phisf_smooth);

            if (abs(vgfb1) <= limit) begin
                T0 =  inv_x1 * inv_x1 * `oneSixth * `invSqrt2;
                sp_dd1         =  vgfb1 * inv_x1 * (1.0 + vgfb1 * (1.0 - (lexp(-phisf_smooth))) * gam * T0); // sp-> sp_dd
            end else begin
                if (vgfb1 < (-limit)) begin
                    SP_S_yg   = -vgfb1;
                    SP_S_ysub   = 1.25 * (SP_S_yg * inv_x1);
                    SP_S_eta  =  0.5 * (SP_S_ysub + 10.0 - sqrt((SP_S_ysub - 6.0) * (SP_S_ysub - 6.0) + 64.0));
                    SP_S_temp   = SP_S_yg - SP_S_eta;
                    SP_S_a      = SP_S_temp * SP_S_temp + gam2 * (SP_S_eta + 1.0);
                    SP_S_c      = 2.0 * SP_S_temp - gam2;
                    SP_S_tau    = -SP_S_eta + lln(SP_S_a * inv_gam2);
                    `sigma0(SP_S_a, SP_S_c, SP_S_tau, SP_S_eta, SP_S_y0)
                    SP_S_delta0 = lexp(SP_S_y0);
                    SP_S_delta1 = 1.0 / SP_S_delta0;
                    SP_S_temp   = 1.0 / (2.0 + SP_S_y0 * SP_S_y0);
                    SP_S_xi0    = SP_S_y0 * SP_S_y0 * SP_S_temp;
                    SP_S_xi1    = 4.0 * (SP_S_y0 * SP_S_temp * SP_S_temp);
                    SP_S_xi2    = (8.0 * SP_S_temp - 12.0 * SP_S_xi0) * SP_S_temp * SP_S_temp;
                    SP_S_temp   = SP_S_yg - SP_S_y0;
                    SP_S_temp1  = (exp_ns_smooth) * SP_S_delta1;
                    SP_S_pC     = 2.0 * SP_S_temp + gam2 * (SP_S_delta0 - 1.0 - SP_S_temp1 + (exp_ns_smooth) * (1.0 - SP_S_xi1));
                    SP_S_qC     = SP_S_temp * SP_S_temp - gam2 * (SP_S_delta0 - SP_S_y0 - 1.0 + SP_S_temp1 + (exp_ns_smooth) * (SP_S_y0 - 1.0 - SP_S_xi0));
                    SP_S_temp   = 2.0 - gam2 * (SP_S_delta0 + SP_S_temp1 - (exp_ns_smooth) * SP_S_xi2);
                    SP_S_temp   = SP_S_pC * SP_S_pC - 2.0 * (SP_S_qC * SP_S_temp);
                    SP_S_temp   = sqrt(SP_S_temp * SP_S_temp + 64e-8) - 8e-4;
                    sp_dd1      = -SP_S_y0 - 2.0 * (SP_S_qC / (SP_S_pC + sqrt(SP_S_temp)));
                end else begin
                    SP_xg1    = 1.0 / (1.25 + gam * 7.324648775608221e-001);
                    SP_S_A_fac= (x1 * 1.25 * SP_xg1 - 1.0) * SP_xg1;
                    SP_S_xbar = vgfb1 * inv_x1 * (1.0 + SP_S_A_fac * vgfb1);
                    SP_S_temp = lexp(-SP_S_xbar);
                    SP_S_w    = 1.0 - SP_S_temp;
                    SP_S_x1   = vgfb1 + gam2 * 0.5 - gam * sqrt(vgfb1 + gam2 * 0.25 - SP_S_w);
                    SP_S_bx   = (phisf_smooth) + 3.0;
                    SP_S_eta  = `MINF(SP_S_x1, SP_S_bx, 5.0) - 0.5 * (SP_S_bx - sqrt(SP_S_bx * SP_S_bx + 5.0));
                    SP_S_temp = vgfb1 - SP_S_eta;
                    SP_S_temp1= lexp(-SP_S_eta);
                    SP_S_temp2= 1.0 / (2.0 + SP_S_eta * SP_S_eta);
                    SP_S_xi0  = SP_S_eta * SP_S_eta * SP_S_temp2;
                    SP_S_xi1  = 4.0 * (SP_S_eta * SP_S_temp2 * SP_S_temp2);
                    SP_S_xi2  = (8.0 * SP_S_temp2 - 12.0 * SP_S_xi0) * SP_S_temp2 * SP_S_temp2;
                    SP_S_a    = max(1.0e-40, SP_S_temp * SP_S_temp - gam2 * (SP_S_temp1 + SP_S_eta - 1.0 - (exp_ns_smooth) * (SP_S_eta + 1.0 + SP_S_xi0)));
                    SP_S_b    = 1.0 - 0.5 * (gam2 * (SP_S_temp1 - (exp_ns_smooth) * SP_S_xi2));
                    SP_S_c    = 2.0 * SP_S_temp + gam2 * (1.0 - SP_S_temp1 - (exp_ns_smooth) * (1.0 + SP_S_xi1));
                    SP_S_tau  = (phisf_smooth) - SP_S_eta + lln(SP_S_a / gam2);
                    `sigma1(SP_S_a, SP_S_b, SP_S_c, SP_S_tau, SP_S_eta, SP_S_x0)
                    SP_S_delta0 = lexp(SP_S_x0);
                    SP_S_delta1 = 1.0 / SP_S_delta0;
                    SP_S_delta0 = (lexp(SP_S_x0-phisf_smooth));
                    SP_S_temp   = 1.0 / (2.0 + SP_S_x0 * SP_S_x0);
                    SP_S_xi0    = SP_S_x0 * SP_S_x0 * SP_S_temp;
                    SP_S_xi1    = 4.0 * (SP_S_x0 * SP_S_temp * SP_S_temp);
                    SP_S_xi2    = (8.0 * SP_S_temp - 12.0 * SP_S_xi0) * SP_S_temp * SP_S_temp;
                    SP_S_temp   = vgfb1 - SP_S_x0;
                    SP_S_pC     = 2.0 * SP_S_temp + gam2 * (1.0 - SP_S_delta1 + SP_S_delta0 - (exp_ns_smooth) * (1.0 + SP_S_xi1));
                    SP_S_qC     = SP_S_temp * SP_S_temp - gam2 * (SP_S_delta1 + SP_S_x0 - 1.0 + SP_S_delta0 - (exp_ns_smooth) * (SP_S_x0 + 1.0 + SP_S_xi0));
                    SP_S_temp   = 2.0 - gam2 * (SP_S_delta1 + SP_S_delta0 - (exp_ns_smooth) * SP_S_xi2);
                    SP_S_temp   = SP_S_pC * SP_S_pC - 2.0 * (SP_S_qC * SP_S_temp);
                    SP_S_temp   = sqrt(SP_S_temp * SP_S_temp + 64e-8) - 8e-4;
                    sp_dd1      = SP_S_x0 + 2.0 * (SP_S_qC / (SP_S_pC + sqrt(SP_S_temp)));
                end
            end

            xs = sp_dd;
            limit1 = 1.0e-7;
            K11 = 2.0;
            SP_S_tempc =  inv_x1 * inv_x1 * `oneSixth * `invSqrt2 ;

            T0 = -DVBD1_i * Leff / litl;
            T1 = DVBD0_i * (lexp(0.5*T0) + 2.0*lexp(T0)) * (0.0 + VSCE_i);
            PHIC =  (1.0 + LPE1_i / Leff)*(`P_Q_NIST1998 * NDEP_i * (TSI * TSI)) / (2.0 * epssi)+ VBSA;
            phic_s = PHIC-RC*(vgfbb*nVt)*CDSBS1_i+ (1.0+RC)*(phisb0);

            gmesp = 8.0 + (7.0) * tanh(10.0 * (phic_star - phisf) + 500.0);

            //First Iteration of final Poisson's expression
            if (abs(vgfb1)<= (limit1)) begin
                T0 =  inv_x1 * inv_x1 * `oneSixth * `invSqrt2;
                x7_s         =  vgfb1 * inv_x1 * (1.0 + vgfb1 * (1.0 - (exp_ns)) * gam * T0); // sp-> sp_dd
            end else begin
                T0= (0.5 * (tanh(-5.0 * (vgfb1 - K11)) +  tanh(5.0 * (vgfb1 + K11)) ));
                sp_vfb       =vgfb1 * inv_x1 * (1.0 + vgfb1 * (1.0 - (exp_ns)) * gam * SP_S_tempc) * T0;

                T0  = lexp((xs * nVt - phic_s)/nVt);
                T1  = lexp((sp_vfb * nVt - phic_s)/nVt);
                T2  = ln_one_plus_exp((xs * nVt - phic_s) / nVt) - ln_one_plus_exp((sp_vfb * nVt - phic_s)/nVt);
                T6  = lexp(-xs);
                T7  = xs * xs;
                T8  = 1.0 / (T7 + 2.0);
                T9  = lexp(-phisf);
                T10 = lexp(xs - phisf);
                if (GMCMOD == 0) begin
                    T11 = (1.0 + RC);
                end else begin
                    T11 = (1.0 + 1.0 / lexp((((sp_dd1 * nVt) / phic_s) - 1.0) * gmesp)) * (1.0 + RC);
                end
                T12 = (1.0 + T0) * T11;
                T3  = -(phisb0 / nVt + T2 / T11);
                T4  = lexp(T3);

                fx   = (vgfb1 - xs) * (vgfb1 - xs) - RT * RT * (vgfbb + T3) * (vgfbb + T3) - gam2 * (T6 - T4 + xs + T3 + T10 - T9 * (xs + 1.0 + T8 * T7));
                f_x  = (2.0 * T0 * (vgfbb + T3) * RT * RT) / T12 - 2.0 * vgfb1 + 2.0 * xs - gam2 * (T10 + T9 * (-2.0 * xs * T8 + 2.0 * xs * xs * xs * T8 * T8 - 1.0) - T6 - T0 / T12 + (T0 * T4) / T12 + 1.0);
                f_xx = 2.0 * RT * RT * T0 * (vgfbb + T3) / T12 - 2.0 * RT * RT * T0 * T0 / (T12 * T12) - gam2 * (T6 + T10 - 2.0 * T9 * T8 * (1.0 - T7 * T8 * (5.0 - 4.0 * T7 * T8)) - T0 / T12 * (1.0 - T0 / (1.0 + T0) - T4 + T0 * T4 / (1.0 + T0) * (1.0 + 1.0 / T11))) - 2.0 * RT * RT * T0 * T0 * (vgfbb + T3) / (T12 * (1.0 + T0)) + 2.0;

                x7_s=xs-(fx/f_x)*(1.0 + ((fx*f_xx)/(2.0*f_x*f_x)));

            end

            //Second Iteration of final Poisson's expression
            xs=x7_s;
            if (abs(vgfb1)<= (limit1)) begin
                T0 =  inv_x1 * inv_x1 * `oneSixth * `invSqrt2;
                x7_s         =  vgfb1 * inv_x1 * (1.0 + vgfb1 * (1.0 - (exp_ns)) * gam * T0); // sp-> sp_dd
            end else begin
                T0= (0.5 * (tanh(-5.0 * (vgfb1 - K11)) +  tanh(5.0 * (vgfb1 + K11)) ));
                sp_vfb       =vgfb1 * inv_x1 * (1.0 + vgfb1 * (1.0 - (exp_ns)) * gam * SP_S_tempc) * T0;

                T0  = lexp((xs * nVt - phic_s)/nVt);
                T1  = lexp((sp_vfb * nVt - phic_s)/nVt);
                T2  = ln_one_plus_exp((xs * nVt - phic_s) / nVt) - ln_one_plus_exp((sp_vfb * nVt - phic_s)/nVt);
                T6  = lexp(-xs);
                T7  = xs * xs;
                T8  = 1.0 / (T7 + 2.0);
                T9  = lexp(-phisf);
                T10 = lexp(xs - phisf);
                if (GMCMOD == 0) begin
                    T11 = (1.0 + RC);
                end else begin
                    T11 = (1.0 + 1.0 / lexp((((sp_dd1 * nVt) / phic_s) - 1.0) * gmesp)) * (1.0 + RC);
                end
                T12 = (1.0 + T0) * T11;
                T3  = -(phisb0 / nVt + T2 / T11);
                T4  = lexp(T3);

                fx   = (vgfb1 - xs) * (vgfb1 - xs) - RT * RT * (vgfbb + T3) * (vgfbb + T3) - gam2 * (T6 - T4 + xs + T3 + T10 - T9 * (xs + 1.0 + T8 * T7));
                f_x  = (2.0 * T0 * (vgfbb + T3) * RT * RT) / T12 - 2.0 * vgfb1 + 2.0 * xs - gam2 * (T10 + T9 * (-2.0 * xs * T8 + 2.0 * xs * xs * xs * T8 * T8 - 1.0) - T6 - T0 / T12 + (T0 * T4) / T12 + 1.0);
                f_xx = 2.0 * RT * RT * T0 * (vgfbb + T3) / T12 - 2.0 * RT * RT * T0 * T0 / (T12 * T12) - gam2 * (T6 + T10 - 2.0 * T9 * T8 * (1.0 - T7 * T8 * (5.0 - 4.0 * T7 * T8)) - T0 / T12 * (1.0 - T0 / (1.0 + T0) - T4 + T0 * T4 / (1.0 + T0) * (1.0 + 1.0 / T11))) - 2.0 * RT * RT * T0 * T0 * (vgfbb + T3) / (T12 * (1.0 + T0)) + 2.0;

                x7_s=xs-(fx/f_x)*(1.0 + ((fx*f_xx)/(2.0*f_x*f_x)));
            end

            //Third Iteration of final Poisson's expression
            xs=x7_s;
            if (abs(vgfb1)<= (limit1)) begin
                T0 =  inv_x1 * inv_x1 * `oneSixth * `invSqrt2;
                x7_s         =  vgfb1 * inv_x1 * (1.0 + vgfb1 * (1.0 - (exp_ns)) * gam * T0); // sp-> sp_dd
            end else begin
                T0= (0.5 * (tanh(-5.0 * (vgfb1 - K11)) +  tanh(5.0 * (vgfb1 + K11)) ));
                sp_vfb       =vgfb1 * inv_x1 * (1.0 + vgfb1 * (1.0 - (exp_ns)) * gam * SP_S_tempc) * T0;

                T0  = lexp((xs * nVt - phic_s)/nVt);
                T1  = lexp((sp_vfb * nVt - phic_s)/nVt);
                T2  = ln_one_plus_exp((xs * nVt - phic_s) / nVt) - ln_one_plus_exp((sp_vfb * nVt - phic_s)/nVt);
                T6  = lexp(-xs);
                T7  = xs * xs;
                T8  = 1.0 / (T7 + 2.0);
                T9  = lexp(-phisf);
                T10 = lexp(xs - phisf);
                if (GMCMOD == 0) begin
                    T11 = (1.0 + RC);
                end else begin
                    T11 = (1.0 + 1.0 / lexp((((sp_dd1 * nVt) / phic_s) - 1.0) * gmesp)) * (1.0 + RC);
                end
                T12 = (1.0 + T0) * T11;
                T3  = -(phisb0 / nVt + T2 / T11);
                T4  = lexp(T3);

                fx   = (vgfb1 - xs) * (vgfb1 - xs) - RT * RT * (vgfbb + T3) * (vgfbb + T3) - gam2 * (T6 - T4 + xs + T3 + T10 - T9 * (xs + 1.0 + T8 * T7));
                f_x  = (2.0 * T0 * (vgfbb + T3) * RT * RT) / T12 - 2.0 * vgfb1 + 2.0 * xs - gam2 * (T10 + T9 * (-2.0 * xs * T8 + 2.0 * xs * xs * xs * T8 * T8 - 1.0) - T6 - T0 / T12 + (T0 * T4) / T12 + 1.0);
                f_xx = 2.0 * RT * RT * T0 * (vgfbb + T3) / T12 - 2.0 * RT * RT * T0 * T0 / (T12 * T12) - gam2 * (T6 + T10 - 2.0 * T9 * T8 * (1.0 - T7 * T8 * (5.0 - 4.0 * T7 * T8)) - T0 / T12 * (1.0 - T0 / (1.0 + T0) - T4 + T0 * T4 / (1.0 + T0) * (1.0 + 1.0 / T11))) - 2.0 * RT * RT * T0 * T0 * (vgfbb + T3) / (T12 * (1.0 + T0)) + 2.0;

                x7_s=xs-(fx/f_x)*(1.0 + ((fx*f_xx)/(2.0*f_x*f_x)));
            end

            // Drain current and Charge calculation part starts
            Vdsat_lim    =  3.912023005 * nVt;
            if (x7_s <= 0.0) begin
                qis          =  0.0;
                xgm          =  vgfb1 - x7_s;

                Vdsat        =  Vdsat_lim;

                Dr = 1.0;
                Nsat = 1.0;

                Mnud1 = 1.0;
                Dvsat = 1.0;
                Dmob  = 1.0;
                Moc = 1.0;
                Mscbe = 1.0;
                Rdrain = RDrainGeo;
                Rsource = RSourceGeo;
            end else begin //vgfb1 >0

                tempc        =  1.0 / (2.0 + x7_s * x7_s);
                xi0s         =  x7_s * x7_s * tempc;
                delta_1s     =  lexp(x7_s);
                Es1          =  1.0 / delta_1s;
                delta_1s     =  lexp(x7_s - phisf);
                Ds           =  delta_1s - lexp(-phisf) * (x7_s + 1.0 + xi0s);
                Ps           =  (vgfb1-x7_s)*(vgfb1-x7_s)*(1.0/gam2) - Ds;
                Ps           = hypsmooth(Ps - 1.0e-3, 1.0e-5) + 1.0e-3;
                sqms         =  sqrt(Ps);

                xgs          =  gam * sqrt(Ps + Ds);
                qis          =  gam2 * Ds * nVt / (xgs + gam * sqms);
                qbs        =  sqms * gam * nVt;
                Em           =  Es1;

                Dm           =  Ds;

                //Drain saturation voltage part implementation (Ref. BSIM4,BSIM-CMG)
                EeffFactor = 1.0e-8 / (epsratio * TOXE);
                Eeffs = EeffFactor * (qbs  + eta_mu * qis);

                // Ref: BSIM4 mobility model

                T2 = lexp(UCS_a * lln(0.5 * (1.0 + (qis / qbs))));

                T3 = (UA_a + UC_a * Vbsx) * pow(Eeffs, EU_t) + UD_a / T2;
                T4 = 1.0 + T3;
                `Smooth(T4, 1.0, 0.0015, Dmobs)

                WeffWRFactor = 1.0 / (pow(Weff * 1.0e6, WR_i) * NF);

                if (RDSMOD == 1) begin
                    Rdss = 0.0;
                end else begin
                    T0   = 1.0 + PRWG_i * qis;
                    T1   = PRWB_i * (sqrtPhistVbs - sqrtPhist);
                    T2   = 1.0 / T0 + T1;
                    T3   = T2 + sqrt(T2 * T2 + 0.01);
                    Rdss = (RDSWMIN_i + RDSW_i * T3) * WeffWRFactor * NF * rdstemp;
                    if (RDSMOD == 2) begin
                        Rdss = (RSourceGeo + (RDSWMIN_i + RDSW_i * T3) * WeffWRFactor * NF + RDrainGeo) * rdstemp;
                    end
                end

                Esat = 2.0 * VSAT_a / U0_a * Dmobs;
                EsatL = Esat * Leff;
                T6 = KSATIV_i * (qis + 2.0 * nVt);

                if (Rdss > 0.0) begin
                    WVCox = Weff * VSAT_a * Cox;
                    T0 = WVCox * Rdss;
                    Ta = 2.0 * T0;
                    Tb = T6 + EsatL + 3.0 * T6 * T0;
                    Tc = T6 * (EsatL + 2.0 * T6 * T0);
                    Vdsat = (Tb - sqrt(Tb * Tb - 2.0 * Ta * Tc)) / Ta;
                end else begin
                    Vdsat = EsatL * T6 / (EsatL + T6);
                end

                if (A0 == 0.0 && AGS == 0.0) begin
                    AbulkIV = 1.0;
                end else begin
                    T1  = Leff / (Leff + sqrt(XJ_i * Xdep));
                    AbulkIV = 1.0 + (A0 * T1 - AGS * T1 * pow(qis,AGS1) * nVt) / (1.0 + KETA * Vbsx);
                    `Smooth(AbulkIV, 0.1, 0.0005, AbulkIV)
                end

                Vdsat   = hypsmooth(Vdsat - 1.0e-3, 1.0e-5) + 1.0e-3;
                Vdsat   = Vdsat / AbulkIV;
                T7      = pow((Vds / Vdsat) + 1.0e-6, 1.0 / DELTA_t);
                T8      = pow(1.0 + T7, -DELTA_t);
                Vdseff  = Vds * T8;
                vdeff   = (Vdseff +Vs) * inv_nVt;

                /* Surface potential at Drain side  DD-MODEL*/
                phidf         =  2 * phib/n + vdeff;
                exp_nd     =  lexp(-phidf);
                limit       =  1.0e-3 * x1;
                T0 = -DVBD1_i * Leff / litl;
                T1 = DVBD0_i * (lexp(0.5*T0) + 2.0*lexp(T0)) * (Vds* inv_nVt + VSCE_i* inv_nVt);
                phic_star  = (1.0 + LPE1_i / Leff)*(`P_Q_NIST1998 * NDEP_i * TSI * TSI) / (2.0 * epssi * nVt) + VBSA/nVt - RC * (vgfbb)*CDSBS1_i + (1.0+RC)*T1;

                vg_FD = phic_star + gam * sqrt(lexp(-phic_star) + phic_star -1.0 );

                if (vgfb1 < (vg_FD)) begin
                    //PD initial Guess
                    if (abs(vgfb1) <= limit) begin
                        T0 =  inv_x1 * inv_x1 * `oneSixth * `invSqrt2;
                        sp_dd         =  vgfb1 * inv_x1 * (1.0 + vgfb1 * (1.0 - (exp_nd)) * gam * T0);// sp-> sp_dd
                    end else begin
                        if (vgfb1 < (-limit)) begin
                            SP_S_yg   = -vgfb1;
                            SP_S_ysub   = 1.25 * (SP_S_yg * inv_x1);
                            SP_S_eta  =  0.5 * (SP_S_ysub + 10.0 - sqrt((SP_S_ysub - 6.0) * (SP_S_ysub - 6.0) + 64.0));
                            SP_S_temp   = SP_S_yg - SP_S_eta;
                            SP_S_a      = SP_S_temp * SP_S_temp + gam2 * (SP_S_eta + 1.0);
                            SP_S_c      = 2.0 * SP_S_temp - gam2;
                            SP_S_tau    = -SP_S_eta + lln(SP_S_a * inv_gam2);
                            `sigma0(SP_S_a, SP_S_c, SP_S_tau, SP_S_eta, SP_S_y0)
                            SP_S_delta0 = lexp(SP_S_y0);
                            SP_S_delta1 = 1.0 / SP_S_delta0;
                            SP_S_temp   = 1.0 / (2.0 + SP_S_y0 * SP_S_y0);
                            SP_S_xi0    = SP_S_y0 * SP_S_y0 * SP_S_temp;
                            SP_S_xi1    = 4.0 * (SP_S_y0 * SP_S_temp * SP_S_temp);
                            SP_S_xi2    = (8.0 * SP_S_temp - 12.0 * SP_S_xi0) * SP_S_temp * SP_S_temp;
                            SP_S_temp   = SP_S_yg - SP_S_y0;
                            SP_S_temp1  = (exp_nd) * SP_S_delta1;
                            SP_S_pC     = 2.0 * SP_S_temp + gam2 * (SP_S_delta0 - 1.0 - SP_S_temp1 + (exp_nd) * (1.0 - SP_S_xi1));
                            SP_S_qC     = SP_S_temp * SP_S_temp - gam2 * (SP_S_delta0 - SP_S_y0 - 1.0 + SP_S_temp1 + (exp_nd) * (SP_S_y0 - 1.0 - SP_S_xi0));
                            SP_S_temp   = 2.0 - gam2 * (SP_S_delta0 + SP_S_temp1 - (exp_nd) * SP_S_xi2);
                            SP_S_temp   = SP_S_pC * SP_S_pC - 2.0 * (SP_S_qC * SP_S_temp);
                            sp_dd          = -SP_S_y0 - 2.0 * (SP_S_qC / (SP_S_pC + sqrt(SP_S_temp)));
                        end else begin
                            SP_xg1    = 1.0 / (1.25 + gam * 7.324648775608221e-001);
                            SP_S_A_fac= (x1 * 1.25 * SP_xg1 - 1.0) * SP_xg1;
                            SP_S_xbar = vgfb1 * inv_x1 * (1.0 + SP_S_A_fac * vgfb1);
                            SP_S_temp = lexp(-SP_S_xbar);
                            SP_S_w    = 1.0 - SP_S_temp;
                            SP_S_x1   = vgfb1 + gam2 * 0.5 - gam * sqrt(vgfb1 + gam2 * 0.25 - SP_S_w);
                            SP_S_bx   = (phidf) + 3.0;
                            SP_S_eta  = `MINF(SP_S_x1, SP_S_bx, 5.0) - 0.5 * (SP_S_bx - sqrt(SP_S_bx * SP_S_bx + 5.0));
                            SP_S_temp = vgfb1 - SP_S_eta;
                            SP_S_temp1= lexp(-SP_S_eta);
                            SP_S_temp2= 1.0 / (2.0 + SP_S_eta * SP_S_eta);
                            SP_S_xi0  = SP_S_eta * SP_S_eta * SP_S_temp2;
                            SP_S_xi1  = 4.0 * (SP_S_eta * SP_S_temp2 * SP_S_temp2);
                            SP_S_xi2  = (8.0 * SP_S_temp2 - 12.0 * SP_S_xi0) * SP_S_temp2 * SP_S_temp2;
                            SP_S_a    = max(1.0e-40, SP_S_temp * SP_S_temp - gam2 * (SP_S_temp1 + SP_S_eta - 1.0 - (exp_nd) * (SP_S_eta + 1.0 + SP_S_xi0)));
                            SP_S_b    = 1.0 - 0.5 * (gam2 * (SP_S_temp1 - (exp_nd) * SP_S_xi2));
                            SP_S_c    = 2.0 * SP_S_temp + gam2 * (1.0 - SP_S_temp1 - (exp_nd) * (1.0 + SP_S_xi1));
                            SP_S_tau  = (phidf) - SP_S_eta + lln(SP_S_a / gam2);
                            `sigma1(SP_S_a, SP_S_b, SP_S_c, SP_S_tau, SP_S_eta, SP_S_x0)
                            SP_S_delta0 = lexp(SP_S_x0);
                            SP_S_delta1 = 1.0 / SP_S_delta0;
                            SP_S_delta0 = lexp(SP_S_x0 - phidf);
                            SP_S_temp   = 1.0 / (2.0 + SP_S_x0 * SP_S_x0);
                            SP_S_xi0    = SP_S_x0 * SP_S_x0 * SP_S_temp;
                            SP_S_xi1    = 4.0 * (SP_S_x0 * SP_S_temp * SP_S_temp);
                            SP_S_xi2    = (8.0 * SP_S_temp - 12.0 * SP_S_xi0) * SP_S_temp * SP_S_temp;
                            SP_S_temp   = vgfb1 - SP_S_x0;
                            SP_S_pC     = 2.0 * SP_S_temp + gam2 * (1.0 - SP_S_delta1 + SP_S_delta0 - (exp_nd) * (1.0 + SP_S_xi1));
                            SP_S_qC     = SP_S_temp * SP_S_temp - gam2 * (SP_S_delta1 + SP_S_x0 - 1.0 + SP_S_delta0 - (exp_nd) * (SP_S_x0 + 1.0 + SP_S_xi0));
                            SP_S_temp   = 2.0 - gam2 * (SP_S_delta1 + SP_S_delta0 - (exp_nd) * SP_S_xi2);
                            SP_S_temp   = SP_S_pC * SP_S_pC - 2.0 * (SP_S_qC * SP_S_temp);
                            sp_dd          = SP_S_x0 + 2.0 * (SP_S_qC / (SP_S_pC + sqrt(SP_S_temp)));
                        end
                    end
                end else begin
                    //FD initial Guess
                    zeta    = RT;
                    zeta2   = zeta * zeta;
                    u_crit  = phic_star - phisb0 * inv_nVt;
                    usf_FD  = vgfb1 - gam * sqrt(lexp(-u_crit) + u_crit -1.0);
                    SP_S_bx = (phidf) + 3.0;
                    SP_S_Z0 =  `MINF(usf_FD, SP_S_bx, 40.0);
                    a_fd = ((vgfb1-SP_S_Z0) * (vgfb1-SP_S_Z0) - zeta2 * (vgfbb-SP_S_Z0 + phic_star) * (vgfbb-SP_S_Z0+phic_star) - gam2 * (phic_star));
                    c_fd = 2.0 * (vgfb1 - SP_S_Z0 ) - 2.0 * zeta2 * (vgfbb - SP_S_Z0 + phic_star) ;
                    c_fd2 = c_fd * c_fd;
                    d_fd = 1.0 - zeta2;
                    if (a_fd < 0) begin
                        a_fd = 0.0;
                    end
                    tau_fd = phidf - SP_S_Z0  + lln(a_fd * inv_gam2);
                    v_fd = a_fd + c_fd;
                    v_fd2 = v_fd * v_fd;
                    mu_fd = v_fd2 / tau_fd  + 0.5 * c_fd2 - a_fd * d_fd;
                    temp1_fd = (c_fd * v_fd) / mu_fd;
                    temp2_fd = ( `oneThird * c_fd2 - a_fd * d_fd);
                    u_first_r = (v_fd * a_fd) / (mu_fd + temp1_fd * temp2_fd);
                    u0_first_FD = SP_S_Z0  + u_first_r;
                    delta0_fd = lexp(u0_first_FD - phidf);
                    p_fd = 2.0 *(vgfb1-u0_first_FD)- 2.0 * zeta2 * (vgfbb-u0_first_FD + phic_star)+ gam2 * delta0_fd;
                    q_fd = (vgfb1-u0_first_FD) * (vgfb1-u0_first_FD) - zeta2 * (vgfbb-u0_first_FD + phic_star) * (vgfbb-u0_first_FD+phic_star)- gam2 * (phic_star+delta0_fd);
                    temp3_fd = 2.0 * q_fd * (2.0- 2.0 * zeta2 - gam2 * delta0_fd);
                    w_fd= (2.0 * q_fd) / (p_fd + sqrt(p_fd * p_fd - temp3_fd));
                    sp_dd  = u0_first_FD + w_fd;
                end

                xs = sp_dd;
                limit1 = 1e-7;
                K11 = 2.0;
                SP_S_tempc =  inv_x1 * inv_x1 * `oneSixth * `invSqrt2 ;
                PHIC =  (1.0 + LPE1_i / Leff)*(`P_Q_NIST1998 * NDEP_i * (TSI * TSI)) / (2.0 * epssi) + VBSA;
                T0 = -DVBD1_i * Leff / litl;
                T1 = DVBD0_i * (lexp(0.5*T0) + 2.0*lexp(T0)) * (Vds* inv_nVt + VSCE_i* inv_nVt);
                phic_s =PHIC-RC*(vgfbb*nVt)*CDSBS1_i + (1.0+RC)*T1*nVt+ (1.0+RC)*(phisb0);

                //First Iteration of final Poisson's expression
                if (abs(vgfb1)<= (limit1)) begin
                    T0 =  inv_x1 * inv_x1 * `oneSixth * `invSqrt2;
                    x7_d         =  vgfb1 * inv_x1 * (1.0 + vgfb1 * (1.0 - (exp_nd)) * gam * T0);
                end else begin
                    T0= (0.5 * (tanh(-5.0 * (vgfb1 - K11)) +  tanh(5.0 * (vgfb1 + K11)) ));
                    sp_vfb       =vgfb1 * inv_x1 * (1.0 + vgfb1 * (1.0 - (lexp(-phidf))) * gam * SP_S_tempc) * T0;

                    T0  = lexp((xs * nVt - phic_s)/nVt);
                    T1  = lexp((sp_vfb * nVt - phic_s)/nVt);
                    T2  = ln_one_plus_exp((xs * nVt - phic_s) / nVt) - ln_one_plus_exp((sp_vfb * nVt - phic_s)/nVt);
                    T6  = lexp(-xs);
                    T7  = xs * xs;
                    T8  = 1.0 / (T7 + 2.0);
                    T9  = lexp(-phidf);
                    T10 = lexp(xs - phidf);
                    if (GMCMOD == 0) begin
                        T11 = (1.0 + RC);
                    end else begin
                        T11 = (1.0 + 1.0 / lexp((((sp_dd1 * nVt) / phic_s) - 1.0) * gmesp)) * (1.0 + RC);
                    end
                    T12 = (1.0 + T0) * T11;
                    T3  = -(phisb0 / nVt + T2 / T11);
                    T4  = lexp(T3);

                    fx   = (vgfb1 - xs) * (vgfb1 - xs) - RT * RT * (vgfbb + T3) * (vgfbb + T3) - gam2 * (T6 - T4 + xs + T3 + T10 - T9 * (xs + 1.0 + T8 * T7));
                    f_x  = (2.0 * T0 * (vgfbb + T3) * RT * RT) / T12 - 2.0 * vgfb1 + 2.0 * xs - gam2 * (T10 + T9 * (-2.0 * xs * T8 + 2.0 * xs * xs * xs * T8 * T8 - 1.0) - T6 - T0 / T12 + (T0 * T4) / T12 + 1.0);
                    f_xx = 2.0 * RT * RT * T0 * (vgfbb + T3) / T12 - 2.0 * RT * RT * T0 * T0 / (T12 * T12) - gam2 * (T6 + T10 - 2.0 * T9 * T8 * (1.0 - T7 * T8 * (5.0 - 4.0 * T7 * T8)) - T0 / T12 * (1.0 - T0 / (1.0 + T0) - T4 + T0 * T4 / (1.0 + T0) * (1.0 + 1.0 / T11))) - 2.0 * RT * RT * T0 * T0 * (vgfbb + T3) / (T12 * (1.0 + T0)) + 2.0;

                    x7_d=xs-(fx/f_x)*(1.0 + ((fx*f_xx)/(2.0*f_x*f_x)));
                end

                //Second Iteration of final Poisson's expression
                xs=x7_d;
                if (abs(vgfb1)<= (limit1)) begin
                    T0 =  inv_x1 * inv_x1 * `oneSixth * `invSqrt2;
                    x7_d         =  vgfb1 * inv_x1 * (1.0 + vgfb1 * (1.0 - (exp_nd)) * gam * T0);
                end else begin
                    T0= (0.5 * (tanh(-5.0 * (vgfb1 - K11)) +  tanh(5.0 * (vgfb1 + K11)) ));
                    sp_vfb       =vgfb1 * inv_x1 * (1.0 + vgfb1 * (1.0 - (lexp(-phidf))) * gam * SP_S_tempc) * T0;

                    T0  = lexp((xs * nVt - phic_s)/nVt);
                    T1  = lexp((sp_vfb * nVt - phic_s)/nVt);
                    T2  = ln_one_plus_exp((xs * nVt - phic_s) / nVt) - ln_one_plus_exp((sp_vfb * nVt - phic_s)/nVt);
                    T6  = lexp(-xs);
                    T7  = xs * xs;
                    T8  = 1.0 / (T7 + 2.0);
                    T9  = lexp(-phidf);
                    T10 = lexp(xs - phidf);
                    if (GMCMOD == 0) begin
                        T11 = (1.0 + RC);
                    end else begin
                        T11 = (1.0 + 1.0 / lexp((((sp_dd1 * nVt) / phic_s) - 1.0) * gmesp)) * (1.0 + RC);
                    end
                    T12 = (1.0 + T0) * T11;
                    T3  = -(phisb0 / nVt + T2 / T11);
                    T4  = lexp(T3);

                    fx   = (vgfb1 - xs) * (vgfb1 - xs) - RT * RT * (vgfbb + T3) * (vgfbb + T3) - gam2 * (T6 - T4 + xs + T3 + T10 - T9 * (xs + 1.0 + T8 * T7));
                    f_x  = (2.0 * T0 * (vgfbb + T3) * RT * RT) / T12 - 2.0 * vgfb1 + 2.0 * xs - gam2 * (T10 + T9 * (-2.0 * xs * T8 + 2.0 * xs * xs * xs * T8 * T8 - 1.0) - T6 - T0 / T12 + (T0 * T4) / T12 + 1.0);
                    f_xx = 2.0 * RT * RT * T0 * (vgfbb + T3) / T12 - 2.0 * RT * RT * T0 * T0 / (T12 * T12) - gam2 * (T6 + T10 - 2.0 * T9 * T8 * (1.0 - T7 * T8 * (5.0 - 4.0 * T7 * T8)) - T0 / T12 * (1.0 - T0 / (1.0 + T0) - T4 + T0 * T4 / (1.0 + T0) * (1.0 + 1.0 / T11))) - 2.0 * RT * RT * T0 * T0 * (vgfbb + T3) / (T12 * (1.0 + T0)) + 2.0;

                    x7_d=xs-(fx/f_x)*(1.0 + ((fx*f_xx)/(2.0*f_x*f_x)));
                end

                //Third Iteration of final Poisson's expression
                xs=x7_d;
                if (abs(vgfb1)<= (limit1)) begin
                    T0 =  inv_x1 * inv_x1 * `oneSixth * `invSqrt2;
                    x7_d         =  vgfb1 * inv_x1 * (1.0 + vgfb1 * (1.0 - (exp_nd)) * gam * T0);
                end else begin
                    T0= (0.5 * (tanh(-5.0 * (vgfb1 - K11)) +  tanh(5.0 * (vgfb1 + K11)) ));
                    sp_vfb       =vgfb1 * inv_x1 * (1.0 + vgfb1 * (1.0 - (lexp(-phidf))) * gam * SP_S_tempc) * T0;

                    T0  = lexp((xs * nVt - phic_s)/nVt);
                    T1  = lexp((sp_vfb * nVt - phic_s)/nVt);
                    T2  = ln_one_plus_exp((xs * nVt - phic_s) / nVt) - ln_one_plus_exp((sp_vfb * nVt - phic_s)/nVt);
                    T6  = lexp(-xs);
                    T7  = xs * xs;
                    T8  = 1.0 / (T7 + 2.0);
                    T9  = lexp(-phidf);
                    T10 = lexp(xs - phidf);
                    if (GMCMOD == 0) begin
                        T11 = (1.0 + RC);
                    end else begin
                        T11 = (1.0 + 1.0 / lexp((((sp_dd1 * nVt) / phic_s) - 1.0) * gmesp)) * (1.0 + RC);
                    end
                    T12 = (1.0 + T0) * T11;
                    T3  = -(phisb0 / nVt + T2 / T11);
                    T4  = lexp(T3);

                    fx   = (vgfb1 - xs) * (vgfb1 - xs) - RT * RT * (vgfbb + T3) * (vgfbb + T3) - gam2 * (T6 - T4 + xs + T3 + T10 - T9 * (xs + 1.0 + T8 * T7));
                    f_x  = (2.0 * T0 * (vgfbb + T3) * RT * RT) / T12 - 2.0 * vgfb1 + 2.0 * xs - gam2 * (T10 + T9 * (-2.0 * xs * T8 + 2.0 * xs * xs * xs * T8 * T8 - 1.0) - T6 - T0 / T12 + (T0 * T4) / T12 + 1.0);
                    f_xx = 2.0 * RT * RT * T0 * (vgfbb + T3) / T12 - 2.0 * RT * RT * T0 * T0 / (T12 * T12) - gam2 * (T6 + T10 - 2.0 * T9 * T8 * (1.0 - T7 * T8 * (5.0 - 4.0 * T7 * T8)) - T0 / T12 * (1.0 - T0 / (1.0 + T0) - T4 + T0 * T4 / (1.0 + T0) * (1.0 + 1.0 / T11))) - 2.0 * RT * RT * T0 * T0 * (vgfbb + T3) / (T12 * (1.0 + T0)) + 2.0;

                    x7_d=xs-(fx/f_x)*(1.0 + ((fx*f_xx)/(2.0*f_x*f_x)));
                end

                x_ds         =  x7_d - x7_s;

                //Approximations for extremely small x7_ds: capacitance calculation
                Udse         =  (Vds)*inv_nVt;
                k_ds         =  lexp(-Udse);
                if (x_ds < 1.0e-10) begin
                    T0  = lexp((xs * nVt - phic_s)/nVt);
                    T1  = lexp((sp_vfb * nVt - phic_s)/nVt);
                    T2  = ln_one_plus_exp((xs * nVt - phic_s) / nVt) - ln_one_plus_exp((sp_vfb * nVt - phic_s)/nVt);
                    T6  = lexp(-xs);
                    T7  = xs * xs;
                    T8  = 1.0 / (T7 + 2.0);
                    T9  = lexp(-Udse - phidf);
                    T10 = lexp(xs - Udse - phidf);
                    if (GMCMOD == 0) begin
                        T11 = (1.0 + RC);
                    end else begin
                        T11 = (1.0 + 1.0 / lexp((((sp_dd1 * nVt) / phic_s) - 1.0) * gmesp)) * (1.0 + RC);
                    end
                    T12 = (1.0 + T0) * T11;
                    T3  = -(phisb0 / nVt + T2 / T11);
                    T4  = lexp(T3);

                    pC    = -((2.0 * T0 * (vgfbb + T3) * RT * RT) / T12 - 2.0 * vgfb1 + 2.0 * xs - gam2 * (T10 + T9 * (-2.0 * xs * T8 + 2.0 * xs * xs * xs * T8 * T8 - 1.0) - T6 - T0 / T12 + (T0 * T4) / T12 + 1.0));
                    qC    =  gam2 *(1.0 - k_ds)* Ds;
                    tempc =  2.0 * RT * RT * T0 * (vgfbb + T3) / T12 - 2.0 * RT * RT * T0 * T0 / (T12 * T12) - gam2 * (T6 + T10 - 2.0 * T9 * T8 * (1.0 - T7 * T8 * (5.0 - 4.0 * T7 * T8)) - T0 / T12 * (1.0 - T0 / (1.0 + T0) - T4 + T0 * T4 / (1.0 + T0) * (1.0 + 1.0 / T11))) - 2.0 * RT * RT * T0 * T0 * (vgfbb + T3) / (T12 * (1.0 + T0)) + 2.0;
                    tempc        =  pC * pC - 2.0 * (tempc * qC);
                    if (tempc >= 0.0) begin
                        x_ds         =  2.0 * (qC / (pC + sqrt(tempc)));
                    end
                    x7_d         = x7_s + x_ds;
                end
                dps          =  x_ds * nVt;
                xi0d         =  x7_d * x7_d / (2.0 + x7_d * x7_d);
                Ed           =  lexp(-x7_d);
                Dd           =  lexp(x7_d - phidf) - lexp(-phidf) * (x7_d + 1.0 + xi0d);
                Pd           = (vgfb1 - x7_d )*(vgfb1 - x7_d )*(1.0/gam2) -  Dd;
                Pd           =  hypsmooth(Pd - 1.0e-3, 1.0e-5) + 1.0e-3;
                sqd          =  sqrt(Pd);

                //--------------------------------------
                xgd          =  gam * sqrt(Pd + Dd);
                qid          =  gam2 * Dd * nVt / (xgd + gam * sqd);

                // Mid-point surface potential
                x_m          =  0.5 * (x7_s + x7_d);
                tempc         =  abs(Ed * Es1);
                Em           =  sqrt(tempc);
                D_bar        =  0.5 * (Ds + Dd);
                Dm           =  D_bar + 0.125 * (x_ds * x_ds * (Em - 2.0 * inv_gam2));
                Pm           =  (vgfb1-x_m )*(vgfb1-x_m )*(1.0/gam2) - Dm;
                xgm          =  gam * sqrt(Dm + Pm);
                Pm           =  hypsmooth(Pm - 1.0e-3, 1.0e-5) + 1.0e-3;
                sqm          =  sqrt(Pm);

                if (PDEMOD==1) begin
                //Poly depletion effect
                    pdef =2 * Cox * Cox * nVt /(`P_Q_NIST1998 * epssi * NGATE_i);
                    d0  =  1.0 - Em + 2.0 * (xgm * (1/gam2));
                    eta_p        =  1.0 / sqrt(1.0 + pdef * xgm);
                    tempc         =  eta_p / (eta_p + 1.0);
                    x_pm         =  pdef * (tempc * tempc *xgm  *xgm)*(Dm /(Dm  + Pm)) ;
                    p_pd         =  2.0 * (xgm - x_pm) + gam2 * (1.0 - Em + Dm);
                    q_pd         =  x_pm * (x_pm - 2.0 * xgm);
                    xi_pd        =  1.0 - 0.5 * (gam2 * (Em + Dm));
                    u_pd         =  q_pd * p_pd / (p_pd * p_pd - xi_pd * q_pd);
                    x_m          =  x_m + u_pd;
                    km           =  lexp(u_pd);
                    Em           =  Em / km;
                    Dm           =  Dm * km;
                    Pm           =  ( vgfb1-x_m+ u_pd )*( vgfb1-x_m+ u_pd)*(1/gam2) -  Dm/ km ;
                    xgm          =  gam * sqrt(Dm + Pm);
                    km0          =  1.0 - Em + 2.0 * (xgm * eta_p * inv_gam2);
                    x_ds         =  x_ds * km * (d0 + D_bar) / (km0 + km * D_bar);
                    dps          =  x_ds * nVt;
                    Pm           =  hypsmooth(Pm - 1.0e-3, 1.0e-5) + 1.0e-3;
                    sqm          =  sqrt(Pm);
                end

                if (abs(dps) > 1e-35) begin
                    alpha_DD    =  (qis - qid) / dps;
                end

                qim          =  nVt * (gam2 * Dm / (xgm + gam * sqm));

                qim1         =  qim + nVt * alpha_DD;
            end

            ids_edge     =  NF * (U0_a) * (WEDGE / Leff) * Cox * qim1 * dps * (DdL * Dvsatinv / (Dr)) * Moc;
            ids          =  ids + ids_edge;
        end
    //SOIMOD=1 ends here
    end else begin

        // psip: pinch-off voltage
        phib_n = phib / n;
        `PO_psip(vgfb, gam, 0.0, phib_n, psip)

        // Normalized inversion charge at source end of channel
        `BSIM_q(psip, phib_n, vs, gam, qs)

        // Average charge-surface potential slope, Ref: Charge-based MOS Transistor Modeling by C. Enz & E. Vittoz
        `Smooth(psip, 1.0, 2.0, psipclamp)
        sqrtpsip = sqrt(psipclamp);

        // Source side surface potential
        psiavg = psip - 2.0 * qs;
        `Smooth(psiavg, 1.0, 2.0, T0)
        nq = 1.0 + gam / (sqrtpsip + sqrt(T0));

        // Drain saturation voltage
        EeffFactor = 1.0e-8 / (epsratio * TOXE);
        T0 = nVt * (vgfb - psip - 2.0 * qs * (nq - 1.0));
        `Smooth(T0, 0.0, 0.1, qbs)

        // Source side qi and qb for Vdsat- normalized to Cox
        qis = 2.0 * nq * nVt * qs;
        Eeffs = EeffFactor * (qbs + eta_mu * qis);
        // Ref: BSIM4 mobility model
        T2 = pow(0.5 * (1.0 + (qis / qbs)), UCS_a);
        T3 = (UA_a + UC_a * Vbsx) * pow(Eeffs, EU_t) + UD_a / T2;
        T4 = 1.0 + T3;
        `Smooth(T4, 1.0, 0.0015, Dmobs)
        WeffWRFactor = 1.0 / (pow(Weff * 1.0e6, WR_i) * NF);

        if (RDSMOD == 1) begin
            Rdss = 0.0;
        end else begin
            T0   = 1.0 + PRWG_i * qis;
            T1   = PRWB_i * (sqrtPhistVbs - sqrtPhist);
            T2   = 1.0 / T0 + T1;
            T3   = T2 + sqrt(T2 * T2 + 0.01);
            if (RDSMOD == 0) begin
                Rdss = (RDSWMIN_i + RDSW_i * T3) * WeffWRFactor * NF * rdstemp;
            end else begin
                Rdss = (RSourceGeo + (RDSWMIN_i + RDSW_i * T3) * WeffWRFactor * NF + RDrainGeo) * rdstemp;
            end
        end

        T0  = pow(Dmobs, 1.0 / PSAT_a);
        T11 = PSATB_i * Vbsx;
        T12 = sqrt(0.1+T11*T11);
        T1  = 0.5*(1-T11+sqrt((1-T11)*(1-T11)+T12));
        T2  = 10.0 * PSATX * qs * T1 / (10.0 * PSATX + qs * T1);
        if (PTWG_a < 0.0) begin
            LambdaC = 2.0 * ((U0_a / T0) * nVt / (VSAT_a * Leff)) * (1.0 / (1.0 - PTWG_a * T2));
        end else begin
            LambdaC = 2.0 * ((U0_a / T0) * nVt / (VSAT_a * Leff)) * (1.0 + PTWG_a * T2);
        end

        // qdsat for external Rds
        if (Rdss > 0.0) begin
          // Accurate qdsat derived from consistent I-V
            T11 = Weff * 2.0 * nq * Cox * nVt * VSAT_a;
            T12 = T11 * LambdaC * Rdss / (2.0 * nVt);
            T0  = 0.5 * LambdaC * (qs * qs + qs) / (1.0 + 0.5 * LambdaC * (1.0 + qs));
            T1  = 2.0 * LambdaC * (qs - T0);
            T2  = sqrt(1.0 + T1 * T1);

            if (T1 != 0.0) begin
                ln_T1_T2 = asinh(T1);
                T3 = T2 + (1.0 / T1) * ln_T1_T2;
            end else begin
                T3 = T2 + (1.0 / T2);
            end
            T4 = T0 * T3 + T12 * T0 * (qs + T0 + 1.0) - LambdaC * ((qs * qs + qs) - (T0 * T0 + T0));
            if (T1 != 0.0) begin
                T5 = -2.0 * LambdaC * (T1 * T2 - ln_T1_T2) / (T1 * T1);
            end else begin
                T5 = -2.0 * LambdaC * (T1 / T2);
            end
            T6 = T0 * T5 + T3 + T12 * (qs + 2.0 * T0 + 1.0) + LambdaC * (2.0 * T0 + 1.0);
            T0 = T0 - T4 / T6;
            T1 = 2.0 * LambdaC * (qs - T0);
            T2 = sqrt(1.0 + T1 * T1);

            if (T1 != 0.0) begin
                ln_T1_T2 = asinh(T1);
                T3 = T2 + (1.0 / T1) * ln_T1_T2;
            end else begin
                T3 = T2 + (1.0 / T2);
            end
            T4 = T0 * T3 + T12 * T0 * (qs + T0 + 1.0) - LambdaC * ((qs * qs + qs) - (T0 * T0 + T0));
            if (T1 != 0.0) begin
                T5 = -2.0 * LambdaC * (T1 * T2 - ln_T1_T2) / (T1 * T1);
            end else begin
                T5 = -2.0 * LambdaC * (T1 / T2);
            end
            T6    = T0 * T5 + T3 + T12 * (qs + 2.0 * T0 + 1.0) + LambdaC * (2.0 * T0 + 1.0);
            qdsat = T0 - T4 / T6;
        end else begin
            // Accurate qdsat derived from consistent I-V
            T0 = 0.5 * LambdaC * (qs * qs + qs) / (1.0 + 0.5 * LambdaC * (1.0 + qs));
            T1 = 2.0 * LambdaC * (qs - T0);
            T2 = sqrt(1.0 + T1 * T1);

            if (T1 != 0.0) begin
                ln_T1_T2 = asinh(T1);
                T3 = T2 + (1.0 / T1) * ln_T1_T2;
            end else begin
                T3 = T2 + (1.0 / T2);
            end
            T4 = T0 * T3 - LambdaC * ((qs * qs + qs) - (T0 * T0 + T0));
            if (T1 != 0.0) begin
                T5 = -2.0 * LambdaC * (T1 * T2 - ln_T1_T2) / (T1 * T1);
            end else begin
                T5 = -2.0 * LambdaC * (T1 / T2);
            end
            T6 = T0 * T5 + T3 + LambdaC * (2.0 * T0 + 1.0);
            T0 = T0 - (T4 / T6);
            T1 = 2.0 * LambdaC * (qs - T0);
            T2 = sqrt(1.0 + T1 * T1);

            if (T1 != 0.0) begin
                ln_T1_T2 = asinh(T1);
                T3 = T2 + (1.0 / T1) * ln_T1_T2;
            end else begin
                T3 = T2 + (1.0 / T2);
            end
            T4 = T0 * T3 - LambdaC * ((qs * qs + qs) - (T0 * T0 + T0));
            if (T1 != 0.0) begin
                T5 = -2.0 * LambdaC * (T1 * T2 - ln_T1_T2) / (T1 * T1);
            end else begin
                T5 = -2.0 * LambdaC * (T1 / T2);
            end
            T6    = T0 * T5 + T3 + LambdaC * (2.0 * T0 + 1.0);
            qdsat = T0 - (T4 / T6);
        // qdsat for internal Rds, Ref: BSIM4
        end
        vdsat = psip - 2.0 * phib_n - (2.0 * qdsat + lln((qdsat * 2.0 * nq * inv_gam) * ((qdsat * 2.0 * nq * inv_gam) + (gam / (nq - 1.0)))));
        Vdsat = vdsat * nVt;
        // Normalized charge qdeff at drain end of channel
        // Vdssat clamped to avoid negative values during transient simulation

        if (A0 == 0.0 && AGS == 0.0) begin
            AbulkIV = 1.0;
        end else begin
            T1  = Leff / (Leff + sqrt(XJ_i * Xdep));
            AbulkIV = 1.0 + (A0 * T1 - AGS * T1 * pow(qs,AGS1) * nVt) / (1.0 + KETA * Vbsx);
            `Smooth(AbulkIV, 0.1, 0.0005, AbulkIV)
        end
        `Smooth(Vdsat - Vs, 0.0, 1.0e-3, Vdssat)
        Vdssat    = Vdssat / AbulkIV;
        T7      = pow((Vds / Vdssat) + 1.0e-6, 1.0 / DELTA_t);
        T8      = pow(1.0 + T7, -DELTA_t);
        Vdseff  = Vds * T8;
        vdeff   = (Vdseff + Vs) * inv_nVt;
        `BSIM_q(psip, phib_n, vdeff, gam, qdeff)

        // Reevaluation of nq to include qdeff
        psiavg = psip - qs - qdeff -1.0;
        `Smooth(psiavg, 1.0, 2.0, T0)
        T2 = sqrt(T0);
        nq = 1.0 + gam / (sqrtpsip + T2);

        // Inversion and bulk charge
        DQSD2 = (qs - qdeff) * (qs - qdeff);
        T0    = 1.0 / (1.0 + qs + qdeff);
        T1    = DQSD2 * T0;
        Qb    = vgfb - psip - (nq - 1.0) * (qs + qdeff + `Oneby3 * T1);
        T2    = `Oneby3 * nq;
        T3    = T1 * T0;
        Qs    = T2 * (2.0 * qs + qdeff + 0.5 * (1.0 + 0.8 * qs + 1.2 * qdeff) * T3);
        Qd    = T2 * (qs + 2.0 * qdeff + 0.5 * (1.0 + 1.2 * qs + 0.8 * qdeff) * T3);

        // Mobility degradation, Ref: BSIM4
        // Average charges (qba and qia) - normalized to Cox
        `Smooth(nVt * Qb, 0.0, 0.1, qba)
        qia   = nVt * (Qs + Qd);

        Eeffm = EeffFactor * (qba + eta_mu * qia);
        T2    = pow(0.5 * (1.0 + (qia / qba)), UCS_a);
        T3    = (UA_a + UC_a * Vbsx) * pow(Eeffm, EU_t) + UD_a / T2;
        T4    = 1.0 + T3;
        `Smooth(T4, 1.0, 0.0015, Dmob)
        // Output conductance
        Esat  = 2.0 * VSAT_a / (U0_a / Dmob);
        EsatL = Esat * Leff;
        if (PVAG_i > 0.0) begin
            PVAGfactor = 1.0 + PVAG_i * qia / EsatL;
        end else begin
            PVAGfactor = 1.0 / (1.0 - PVAG_i * qia / EsatL);
        end

        // Output conductance due to DIBL, Ref: BSIM4
        DIBLfactor = PDIBLC_a;
        diffVds    = Vds - Vdseff;
        Vgst2Vtm   = qia + 2.0 * nVt;
        if (DIBLfactor > 0.0) begin
            T3     = Vgst2Vtm / (Vdssat + Vgst2Vtm);
            T4     = hypsmooth((1.0 + PDIBLCB_i * Vbsx), 1.0e-3);
            T5     = 1.0 / T4;
            VaDIBL = Vgst2Vtm / DIBLfactor * T3 * PVAGfactor * T5;
            Moc    = 1.0 + diffVds / VaDIBL;
        end else begin
            Moc = 1.0;
        end

        // Degradation factor due to pocket implants, Ref: BSIM4
        if (FPROUT_i <= 0.0) begin
            Fp = 1.0;
        end else begin
            T9 = FPROUT_i * sqrt(Leff) / Vgst2Vtm;
            Fp = 1.0 / (1.0 + T9);
        end

        // Channel length modulation, Ref: BSIM4
        Vasat = Vdssat + EsatL;
        if (PCLM_a > 0.0) begin
            if (PCLMG < 0.0) begin
                T1 = PCLM_a / (1.0 - PCLMG * qia / EsatL) / Fp;
            end else begin
                T1 = PCLM_a * (1.0 + PCLMG * qia / EsatL) / Fp;
            end
            MdL = 1.0 + T1 * lln(1.0 + diffVds / T1 / Vasat);
        end else begin
            if (PCLMG < 0.0) begin
                T1 = PCLM_a / (1.0 - PCLMG * qia / EsatL) / Fp;
            end else begin
                T1 = PCLM_a * (1.0 + PCLMG * qia / EsatL) / Fp;
            end
            MdL = 1.0 + T1;
        end
        Moc = Moc * MdL;

        // Calculate Va_DITS, Ref: BSIM4
        T1 = lexp(PDITSD_i * Vds);
        if (PDITS_i > 0.0) begin
            T2      = 1.0 + PDITSL * Leff;
            VaDITS  = (1.0 + T2 * T1) / PDITS_i;
            VaDITS  = VaDITS * Fp;
        end else begin
            VaDITS  = `MAX_EXPL;
        end
        T4  = diffVds / VaDITS;
        T0  = 1.0 + T4;
        Moc = Moc * T0;

        // Calculate Va_SCBE, Ref: BSIM4
        if (PSCBE2_i > 0.0) begin
            if (diffVds > PSCBE1_i * litl / `EXPL_THRESHOLD) begin
                T0     = PSCBE1_i * litl / diffVds;
                VaSCBE = Leff * lexp(T0) / PSCBE2_i;
            end else begin
                VaSCBE = `MAX_EXPL * Leff/PSCBE2_i;
            end
        end else begin
            VaSCBE = `MAX_EXPL;
        end
        Mscbe = 1.0 + (diffVds / VaSCBE);
        Moc   = Moc * Mscbe;

        // Velocity saturation
        T0 = pow(Dmob, 1.0 / PSAT_a);
        T11 = PSATB_i * Vbsx;
        T12 = sqrt(0.1+T11*T11);
        T1  = 0.5*(1-T11+sqrt((1-T11)*(1-T11)+T12));
        T2  = 10.0 * PSATX * qia * T1 / (10.0 * PSATX + qia * T1);
        if (PTWG_a < 0.0) begin
            LambdaC = 2.0 * ((U0_a / T0) * nVt / (VSAT_a * Leff)) * (1.0 / (1.0 - PTWG_a * T2));
        end else begin
            LambdaC = 2.0 * ((U0_a / T0) * nVt / (VSAT_a * Leff)) * (1.0 + PTWG_a * T2);
        end
        T1 = 2.0 * LambdaC * (qs - qdeff);
        T2 = sqrt(1.0 + T1 * T1);
        if (T1 != 0.0) begin
            Dvsat = 0.5 * (T2 + (1.0 / T1) * asinh(T1));
        end else begin
            Dvsat = 0.5 * (T2 + (1.0 / T2));
        end
        Dptwg = Dvsat;
        // S/D series resistances, Ref: BSIM4
        Rsource = 0.0;
        Rdrain  = 0.0;
        if (RDSMOD == 1) begin
            Rdsi = 0.0;
            Dr   = 1.0;
            // Rs (Source side resistance for all fingers)
            T2      = Vgs_noswap - Vfbsdr;
            T3      = sqrt(T2 * T2 + 0.01);
            Vgs_eff = 0.5 * (T2 + T3);
            T5      = 1.0 + PRWG_i * Vgs_eff;
            T6      = (1.0 / T5) + PRWB_i * Vsb_noswap;
            T4      = 0.5 * (T6 + sqrt(T6 * T6 + 0.01));
            Rsource = rdstemp * (RSourceGeo + (RSWMIN_i + RSW_i * T4) * WeffWRFactor);
            // Rd (Drain side resistance for all fingers)
            T2      = Vgd_noswap - Vfbsdr;
            T3      = sqrt(T2 * T2 + 0.01);
            Vgd_eff = 0.5 * (T2 + T3);
            T5      = 1.0 + PRWG_i * Vgd_eff;
            T6      = (1.0 / T5) + PRWB_i * Vdb_noswap;
            T4      = 0.5 * (T6 + sqrt(T6 * T6 + 0.01));
            Rdrain  = rdstemp * (RDrainGeo + (RDWMIN_i + RDW_i * T4) * WeffWRFactor);
        end else begin
            // Ref: (1) BSIM4 (2) "Operation and Modeling of the MOS Transistor" by Yannis Tsividis
            T0      = 1.0 + PRWG_i * qia;
            T1      = PRWB_i * (sqrtPhistVbs - sqrtPhist);
            T2      = 1.0 / T0 + T1;
            T3      = 0.5 * (T2 + sqrt(T2 * T2 + 0.01));
            Rdsi    = rdstemp * (RDSWMIN_i + RDSW_i * T3) * WeffWRFactor * NF;
            Rdrain  = RDrainGeo;
            Rsource = RSourceGeo;
            Dr      = 1.0 + U0_a /(Dvsat * Dmob) * Cox * Weff / Leff * qia * Rdsi;
            if (RDSMOD == 2) begin
                Rdsi    = rdstemp * (RSourceGeo + (RDSWMIN_i + RDSW_i * T3) * WeffWRFactor * NF + RDrainGeo);
                Rdrain  = 0.0;
                Rsource = 0.0;
                Dr      = 1.0 + U0_a /(Dvsat * Dmob) * Cox * Weff / Leff * qia * Rdsi;
            end
        end

        // Non-saturation effect
        T0   = A1_t + A2_t / (qia + 2.0 * n * Vtm);
        DQSD = qs - qdeff;
        T1   = T0 * DQSD * DQSD;
        T2   = T1 + 1.0 - 0.001;
        T3   = -1.0 + 0.5 * (T2 + sqrt(T2 * T2 + 0.004));
        Nsat = 0.5 * (1.0 + sqrt(1.0 + T3));
        `Smooth2(Nsat, 1.0, 0.01, Nsat)

        // MNUD model to enhance Id-Vd fitting flexibility
        T0   = (qs + qdeff);
        T1   = (qs - qdeff);
        T2   = T1 / (T0 + M0_t);
        T3   = K0_t * T2 * T2;
        Mnud = 1.0 + T3;

        // MNUD1 to enhance the fitting flexibility for the gm/Id - similar approach used in BSIM-CMG
        T9    = C0_t / (max(0, C0SI_t + C0SISAT_t * T1 * T1) * T0 + 2.0 * n * Vtm);
        Mnud1 = lexp(-T9);
        Dtot  = Dmob * Dvsat * Dr;

        // Effective mobility including mobility degradation
        ueff = U0_a / Dtot;

        // I-V
        ids  = 2.0 * NF * nq * ueff * Weff / Leff * Cox * nVt * nVt * ((qs - qdeff) * (1.0 + qs + qdeff)) * Moc / Nsat * Mnud * Mnud1;
        ids  = ids * IDS0MULT;

        Gcrg = 0.0;
        if (RGATEMOD > 1) begin
            idsovvds = ueff * Weff / Leff * Cox * qia;
            T9       = XRCRG2 * Vt;
            T0       = T9 * ueff * Weff / Leff * Cox;
            Gcrg     = XRCRG1 * NF * (T0 + idsovvds);
            if (RGATEMOD == 2) begin
                Rgeltd = 1.0 / Grgeltd;
                if (Rgeltd < minr) begin
                    Rgeltd = minr ;
                    Grgeltd = 1.0 / Rgeltd;
                end
                T11  = Grgeltd + Gcrg;
                Gcrg = Grgeltd * Gcrg / T11;
            end
        end

        // Junction currents and capacitances
        //Diode and BJT Current
        wdiod = Weff / NSEG + PDBCP;
        wdios = Weff / NSEG + PSBCP;
        WsTsi = wdios * TSI;
        WdTsi = wdiod * TSI;

        NVtm1 = Vtm * NDIODE_i;
        T0 = Vbs_jct / NVtm1;
        ExpVbsNVtm = lexp(T0);

        NVtm2 = Vtm * NDIODE_i;
        T0 = Vbd_jct / NVtm2;
        ExpVbdNVtm = lexp(T0);

        T4 = `Eg300 / Vtm * (TRatio-1);

        //Ibs1 : Diffusion current as per SOI
        if (ISDIF_i == 0.0) begin
            Ibs1 = 0.0;
        end else begin
            T7 = XDIF_i * T4 / NDIODE_i;
            T1 = lexp(T7);
            JDIFS = ISDIF_i * T1;
            T0 = WsTsi * JDIFS;
            Ibs1 = T0 * (ExpVbsNVtm - 1);
        end

        //Ibd1 : Diffusion Current as per SOI
        if (IDDIF_i == 0.0) begin
            Ibd1 = 0.0;
        end else begin
            T7 = XDIF_i * T4 / NDIODE_i;
            T1 = lexp(T7);
            JDIFD = IDDIF_i * T1;
            T0 = WdTsi * JDIFD;
            Ibd1 = T0 * (ExpVbdNVtm - 1);
        end

        // Ibs2 and Ibd2: Recombination / Trap-assisted tunneling current
        if (ISREC_i == 0.0) begin
            Ibs2 = 0.0;
        end else begin
            T7 = XREC_i * T4 / NRECF0_i;
            T2 = lexp(T7);
            JRECS = ISREC_i * T2;
            //forward bias
            NVtmf = VTM00 * NRECF0_i * (1 + NTRECF_i * (TRatio - 1));
            NVtmr = VTM00 * NRECR0_i * (1 + NTRECR_i * (TRatio - 1));

            T0 = Vbs_jct / NVtmf;
            T10 = lexp(T0);

            //reverse bias
            if (( VREC0_i - Vbs_jct) < 1e-3) begin
                T1 = 1e3;
                T0 = - Vbs_jct / NVtmr * VREC0_i * T1;
                T11 = lexp(T0);
                T11 = -T11;
            end else begin
                T1 = 1 / (VREC0_i - Vbs_jct);
                T0 = -Vbs_jct / NVtmr * VREC0_i * T1;
                T11 = lexp(T0);

                T11 = -T11;
            end

            T3 = WsTsi * JRECS;
            Ibs2 = T3 * (T10 + T11);
        end

        if (IDREC_i == 0.0) begin
            Ibd2 = 0.0;
        end else begin
            T7 = XREC_i * T4 / NRECF0_i;
            T2 = lexp(T7);
            JRECD = IDREC_i * T2;
            NVtmf = VTM00 * NRECF0_i * (1 + NTRECF_i * (TRatio - 1));
            NVtmr = VTM00 * NRECR0_i * (1 + NTRECR_i * (TRatio - 1));

            T0 = Vbd_jct / NVtmf;
            T10 = lexp(T0);

            if (( VREC0D_i - Vbd_jct) < 1e-3) begin

                T1 = 1e3;
                T0 = - Vbd_jct / NVtmr * VREC0D_i * T1;
                T11 = lexp(T0);
                T11 = -T11;
            end else begin
                T1 = 1 / (VREC0D_i - Vbd_jct);
                T0 = -Vbd_jct / NVtmr * VREC0D_i * T1;
                T11 = lexp(T0);

                T11 = -T11;
            end

            T3 = WdTsi * JRECD;
            Ibd2 = T3 * (T10 + T11);
        end

        //Ibs3 and Ibd3 - Recombination current in neutral body
        WTsi = Weff / NSEG * TSI;

        if (ISBJT_i == 0.0 && IDBJT_i == 0.0 ) begin
            Ibs3 =0.0;
            Ibd3 =0.0;
            Ic = 0.0;
        end else begin
            T7 = XBJT_i * T4 / NDIODE_i;
            T0 = lexp(T7);
            Ahlis = AHLI_i * T0; /* high level injection */
            JBJTS = ISBJT_i * T0;
            T7 = XBJT_i * T4 / NDIODE_i;
            T0 = lexp(T7);
            Ahlid = AHLID_i * T0; /* high level injection */
            JBJTD = IDBJT_i * T0;
            //High level injection on Source Side
            Ehlis = Ahlis * (ExpVbsNVtm - 1);
            if (Ehlis < 1e-5) begin
                Ehlis = 0;
                EhlisFactor = 1;
            end else begin
                EhlisFactor = 1.0 / sqrt(1 + Ehlis);
            end

            // high level injection of drain side
            Ehlid = Ahlid * (ExpVbdNVtm - 1);
            if (Ehlid < 1e-5) begin
                Ehlid = 0;
                EhlidFactor = 1;
            end else begin
                EhlidFactor = 1.0 / sqrt(1 + Ehlid);
            end

            T0 = -0.5 * Leff * Leff / LN / LN;
            ALPHABJT = lexp(T0);
            T2 = 1 - ALPHABJT;
            T0 = LBJT0_i * (1.0 / Leff + 1.0 / LN);
            lratio = pow(T0,NBJT_i);

            Ien = WTsi * JBJTS * lratio;
            T1 = T0 * Ien;
            Ibs3 = T1 * (ExpVbsNVtm -1) * EhlisFactor;

            Ien = WTsi * JBJTD * lratio;
            T1 = T0 * Ien;
            Ibd3 = T1 * (ExpVbdNVtm -1) * EhlidFactor;

            //Terms for diffusion charge
            lratiodif = 1.0 + LDIF0 * pow(T0,NDIF_i);

            Iendif = WTsi * JBJTS * lratiodif;
            Ibsdif = Iendif * (ExpVbsNVtm - 1) * EhlisFactor;

            Iendif = WTsi * JBJTD * lratiodif;
            Ibddif = Iendif * (ExpVbdNVtm - 1) * EhlidFactor;

            //BJT collector Current Ic
            Vearly = VABJT_i + AELY_i * Leff;

            if (Vearly < 1)
                Vearly = 1;
            if (BJTOFF == 1) begin
                Ic = 0.0;
            end else begin
                // second order effects
                T0 = 1 + (Vbs_jct + Vbd_jct) / Vearly;
                T1 = Ehlis + Ehlid;
                T3 = sqrt(T0 * T0 + 4 * T1);
                T2 = (T0 + T3) / 2.0;

                if (T2 < 0.1) begin
                    E2ndFactor = 10.0;
                end else begin
                    E2ndFactor = 1.0 /T2;
                end
                T0 = ALPHABJT * Ien;
                Ic = NF * T0 * (ExpVbsNVtm - ExpVbdNVtm) * E2ndFactor;
            end
        end

        //Ibs4 and Ibd4 : tunneling
        if (ISTUN_i == 0.0 && IDTUN_i == 0.0) begin
            Ibs4 = 0.0;
            Ibd4 = 0.0;
        end else begin
            T7 = XTUN_i * (TRatio - 1);
            T0 = lexp(T7);
            JTUNS = ISTUN_i * T0;
            T7 = XTUND_i * (TRatio - 1);
            T0 = lexp(T7);

            JTUND = IDTUN_i * T0;
            NVtm2 = VTM00 * NTUN_i;
            if (( VTUN0_i - Vbs_jct) < 1e-3) begin

                T1 = 1e3;
                T0 = -Vbs_jct / NVtm2 * VTUN0_i * T1;
                T1 = lexp(T0);

                T3 = WsTsi * JTUNS;
                Ibs4 = T3 * (1 - T1);
            end else begin
                T1 = 1 / (VTUN0_i - Vbs_jct);
                T0 = -Vbs_jct / NVtm2 * VTUN0_i * T1;
                T1 = lexp(T0);

                T3 = WsTsi * JTUNS;
                Ibs4 = T3 * (1 - T1);
            end

            NVtm2 = VTM00 * NTUND_i;
            if (( VTUN0D_i - Vbd_jct) < 1e-3) begin

                T1 = 1e3;
                T0 = -Vbd_jct / NVtm2 * VTUN0D_i * T1;
                T1 = lexp(T0);

                T3 = WsTsi * JTUND;
                Ibd4 = T3 * (1 - T1);
            end else begin
                T1 = 1 / (VTUN0D_i - Vbd_jct);
                T0 = -Vbd_jct / NVtm2 * VTUN0D_i * T1;
                T1 = lexp(T0);

                T3 = WsTsi * JTUND;
                Ibd4 = T3 * (1 - T1);
            end
        end

        Ibs = NF * (Ibs1 + Ibs2 + Ibs3 + Ibs4);
        Ibd = NF * (Ibd1 + Ibd2 + Ibd3 + Ibd4);

        // GIDL and GISL currents, Ref: BSIM4 and BSIM-SOI
        igisl = 0.0;
        igidl = 0.0;
        if (GIDLMOD == 0) begin
            T0 = epsratio * TOXE;
            // GIDL
            if ((AGIDL_i <= 0.0) || (BGIDL_t <= 0.0) || (CGIDL_i < 0.0)) begin
                T6 = 0.0;
            end else begin
                T1 = (-Vgd_noswap - EGIDL_i + Vfbsdr) / T0;
                T1 = hypsmooth(T1, 1.0e-2);
                T2 = BGIDL_t / (T1 + 1.0e-3);
                if (CGIDL_i != 0.0) begin
                    T3 = Vdb_noswap * Vdb_noswap * Vdb_noswap;
                    T4 = CGIDL_i + abs(T3) + 1.0e-4;
                    T5 = hypsmooth(T3 / T4, 1.0e-6) - 1.0e-6;
                end else begin
                    T5 = 1.0;
                end
                T6 = AGIDL_i * wdiod * T1 * lexp(-T2) * T5;
            end
            igidl = T6;
            // GISL
            if ((AGISL_i <= 0.0) || (BGISL_t <= 0.0) || (CGISL_i < 0.0)) begin
                T6 = 0.0;
            end else begin
                T1 = (-Vgs_noswap - EGISL_i + Vfbsdr) / T0;
                T1 = hypsmooth(T1, 1.0e-2);
                T2 = BGISL_t / (T1 + 1.0e-3);
                if (CGISL_i != 0.0) begin
                    T3 = Vsb_noswap * Vsb_noswap * Vsb_noswap;
                    T4 = CGISL_i + abs(T3) + 1.0e-4;
                    T5 = hypsmooth(T3 / T4, 1.0e-6) - 1.0e-6;
                end else begin
                    T5 = 1.0;
                end
                T6 = AGISL_i * wdios * T1 * lexp(-T2) * T5;
            end
            igisl = T6;
        end else begin
            //GIDLMOD = 1
            T0 = epsratio * TOXE;
            Vgd_noswap_1    = RGISL_i * Vg - Vd;
            Vgs_noswap_1    = RGIDL_i * Vg - Vs;
            T2      = Vgs_noswap - Vfbsdr;
            Vgs_eff = sqrt(T2 * T2 + 1.0e-4);
            //GIDL
            if ((AGIDL_i <= 0.0) || (BGIDL_t <= 0.0)) begin
                T6 = 0.0;
            end else begin
                T1 = (-Vgd_noswap_1 - EGIDL_i + Vfbsdr) / T0;
                T1 = hypsmooth(T1, 1.0e-2);
                T2 = BGIDL_t / (T1 + 1.0e-3);

                if (KGIDL_i != 0.0) begin
                    T3 = -Vdb_noswap-FGIDL_i;
                    T4 = T3 + 1.0e-4;
                    T5 = hypsmooth(KGIDL_i / T4, 1.0e-6) - 1.0e-6;
                end else begin
                    T5 = 1.0;
                end
                T6 = AGIDL_i * wdiod * T1 * lexp(-T2) * lexp(T5);
            end
            igidl = T6;

            //GISL
            if ((AGISL_i <= 0.0) || (BGISL_t <= 0.0)) begin
                T6 = 0.0;
            end else begin
                T1 = (-Vgs_noswap_1 - EGISL_i + Vfbsdr) / T0;
                T1 = hypsmooth(T1, 1.0e-2);
                T2 = BGISL_t / (T1 + 1.0e-3);

                if (KGISL_i != 0.0) begin
                    T3 = -Vsb_noswap-FGISL_i;
                    T4 = T3 + 1.0e-4;
                    T5 = hypsmooth(KGISL_i / T4, 1.0e-6) - 1.0e-6;
                end else begin
                    T5 = 1.0;
                end
                T6 = AGISL_i * wdios * T1 * lexp(-T2) * lexp(T5);
            end
            igisl = T6;
        end

        IGIDL = devsign * NF * MULT_I * igidl;
        IGISL = devsign * NF * MULT_I * igisl;

        // Impact ionization currents, Ref: BSIM4 and BSIM-SOI
        //BULK MOSFET
        if (IIIMOD == 0) begin
            if ((ALPHA0_i <= 0.0) || (BETA0_t <= 0.0)) begin
                Iii = 0.0;
            end else if (diffVds > BETA0_t / `EXPL_THRESHOLD) begin
                T1  = -BETA0_t / diffVds;
                Iii = ALPHA0_i * diffVds * ids * lexp(T1) / Mscbe;
            end else begin
                Iii = ALPHA0_i * diffVds * ids * `MIN_EXPL / Mscbe;
            end

        //SOI
        end else if (IIIMOD == 1) begin
            if ((ALPHA0_i <= 0.0) || (BETA2_i == 0.0 && BETA1_i == 0.0 && BETA0_t == 0.0)) begin
                Iii = 0.0;
            end else begin
                Vdsatii0 = VDSATII0_i * (1.0 + TII * (TRatio - 1.0)) - (LII_i / Leff);
                T0 = ESATII_i * Leff;
                T1 = SII0_i * T0 / (1.0 + T0);

                T0 = 1.0 / (1.0 + hypsmooth((SII1_i * vgsfb * nVt), IIMOD2CLAMP1));
                T3 = T0 + SII2_i;
                T2 = hypsmooth((vgsfb * nVt * T3), IIMOD2CLAMP2);
                T3 = 1.0 / (1.0 + SIID_i * Vdsx);

                VgsStep = T1 * T2 * T3;
                Vdsatii = Vdsatii0 + VgsStep;
                Vdiff = Vdsx - Vdsatii;

                T0 = BETA2_i + BETA1_i * Vdiff + BETA0_t * Vdiff * Vdiff;
                T1 = sqrt(T0 * T0 + 1.0e-10);
                Ratio = -hypmax(-ALPHA0_i * lexp(Vdiff / T1), -10.0, IIMOD2CLAMP3);
                Iii = Ratio * (ids + FBJTII_i * sigvds * Ic);
            end

            //IIIMOD = 2
            //two components have the different impact ionization rate.
        end else begin
            if ((ALPHA0_i <= 0.0) || (BETA2_i == 0.0 && BETA1_i == 0.0 && BETA0_t == 0.0)) begin
                Iii = 0.0;
            end else begin
                //Idsmosfet
                Vdsatii0 = VDSATII0_i * (1.0 + TII * (TRatio - 1.0)) - (LII_i / Leff);
                T0 = ESATII_i * Leff;
                T1 = SII0_i * T0 / (1.0 + T0);

                T0 = 1.0 / (1.0 + hypsmooth((SII1_i * vgsfb * nVt), IIMOD2CLAMP1));
                T3 = T0 + SII2_i;
                T2 = hypsmooth((vgsfb * nVt * T3), IIMOD2CLAMP2);
                T3 = 1.0 / (1.0 + SIID_i * Vdsx);

                VgsStep = T1 * T2 * T3;
                Vdsatii = Vdsatii0 + VgsStep;
                Vdiff = Vdsx - Vdsatii;

                T0 = BETA2_i + BETA1_i * Vdiff + BETA0_t * Vdiff * Vdiff;
                T1 = sqrt(T0 * T0 + 1.0e-10);
                Ratio = -hypmax(-ALPHA0_i * lexp(Vdiff / T1), -10.0, IIMOD2CLAMP3);
                Idsmosfet = Ratio * ids;
            end
            //Iiibjt

            T0 = (CBJTII_i + EBJTII_i * Leff) / Leff;
            Vbc = VBCI_i * (1.0 + TVBCI * (TRatio - 1));

            if (sigvds > 0)
                T1 = Vbc - Vbd_jct;
            else
                T1 = Vbc - Vbs_jct;

            T2 = MBJTII_i - 1.0;

            if (T1 > 0.0)
                T3 = -ABJTII_i * pow(T1,T2);
            else
                T3 = 0.0;

            T4 = lexp(T3);
            Iiibjt = T0 * sigvds * Ic * T1 * T4;

            //Total Iii
            Iii = Idsmosfet + Iiibjt;
        end

        ISUB = Iii * MULT_I * devsign;

        // Gate currents, Ref: BSIM-SOI

        AIGC_i = AIGC_i + AIGC1_i * (TRatio - 1.0);
        AIGS_i = AIGS_i + AIGS1_i * (TRatio - 1.0);
        AIGD_i = AIGD_i + AIGD1_i * (TRatio - 1.0);
        ALPHAGB1_i = ALPHAGB1_i + ALPHAGB1_T_i * (TRatio - 1.0);
        ALPHAGB2_i = ALPHAGB2_i + ALPHAGB2_T_i * (TRatio - 1.0);
        AIGBCP2_i  = AIGBCP2_i + AIGBCP2_T_i * (TRatio - 1.0);

        igb = 0.0; igcs = 0.0;
        igcd   = 0.0; igs    = 0.0; igd = 0.0;

        // Gate-to-body tunneling components
        if ((IGCMOD != 0) || (IGBMOD != 0)) begin
            Voxm1    = nVt * (vgfb - psip + qs + qdeff);
            T1      = sqrt(Voxm1 * Voxm1 + 1.0e-4);
            Voxmacc = 0.5 * (-Voxm1 + T1);
            Voxminv = 0.5 * (Voxm1 + T1);

            if (IGBMOD != 0) begin
                //Igbacc
                T1     = Voxm1 / VECB;
                Vaux_Igbacc = VECB * ln_one_plus_exp(-T1);

                if (VGB2 != 0) begin
                    T0 = 1- Voxmacc / VGB2;
                end else begin
                    T0 = 1;
                end

                if (T0 < 0.01) begin
                    T0 = 0.01;
                end

                T1 = (Leff * Weff / NSEG + AGBCPD / NF ) * AGB2 * ToxRatio;
                T2 = BGB2 * TOXE;

                T3 = T2 * (ALPHAGB2_i - BETAGB2_i * Voxmacc) / T0;
                T4 = lexp(T3);

                igbacc = T1 * Vg * Vaux_Igbacc * T4;
                igbacc = igbacc * igtemp;

                //Igbinv
                T1     = (Voxm1 - EIGBINV_i) / VEVB;
                Vaux_Igbinv = VEVB * ln_one_plus_exp(T1);

                if (VGB1 != 0) begin
                    T0 = 1- Voxminv / VGB1;
                end else begin
                    T0 = 1;
                end

                if (T0 < 0.01) begin
                    T0 = 0.01;
                end

                T1 = (Leff * Weff / NSEG + AGBCPD / NF ) * AGB1 * ToxRatio;
                T2 = BGB1 * TOXE;

                T3 = T2 * (ALPHAGB1_i - BETAGB1_i * Voxminv) / T0;
                T4 = lexp(T3);

                igbinv = T1 * Vg * Vaux_Igbinv * T4;
                igbinv = igbinv * igtemp;

                igb    = NF * (igbacc + igbinv);

                Vfb2 = vfb * nVt + EGGBCP2;
            end

            //Gate tunneling component in the AGBCP2 region
            if ((BODYMOD !=0 && $port_connected(b) != 0 && !(TNODEOUT && !$port_connected(t)) && MODAGBCP2 ==1) && AGBCP2 > 0) begin
                Vgb = devsign * V(gi, bi2);
                T0 = Vgb - Vfb2;
                T1 = sqrt(T0 * T0 + 1.0e-4);
                Vgp_eff = 0.5 * (-T0 + T1 - 1.0e-2);
                T11 = (TYPE == `ntype) ? AGBC2N : AGBC2P;
                T12 = (TYPE == `ntype) ? BGBC2N : BGBC2P;
                T2 = Vgb * Vgp_eff;
                T3 = AIGBCP2_i * CIGBCP2_i - BIGBCP2_i;
                T4 = BIGBCP2_i * CIGBCP2_i;
                T5 = (-T12) * TOXE * (AIGBCP2_i + T3 * Vgp_eff -T4 * Vgp_eff * Vgp_eff);
                T6 = lexp(T5);
                T11 = T11 * AGBCP2 * ToxRatio;
                Ig_agbcp2 = T11 * T2 * T6 * igtemp;
            end else begin
                Ig_agbcp2 = 0.0;
            end

            if (IGCMOD != 0) begin
                // Igcinv
                T1   = AIGC_i - BIGC_i * Voxminv;
                T2   = 1.0 + CIGC_i * Voxminv;
                T3   = Bechvb * T1 * T2;
                T4   = nq * nVt * (qs + qdeff) * lexp(T3);
                igc0 = NF * Aechvb * T4 * (Vg + 0.5 * Vdsx - 0.5 * (Vs + Vd)) * igtemp;
                // Gate-current partitioning
                Vdseffx = sqrt(Vdseff * Vdseff + 0.01) - 0.1;
                T1      = PIGCD_i * Vdseffx;
                T1_exp  = lexp(-T1);
                T3      = T1 + T1_exp -1.0 + 1.0e-4;
                T4      = 1.0 - (T1 + 1.0) * T1_exp + 1.0e-4;
                T5      = T1 * T1 + 2.0e-4;
                if (sigvds > 0) begin
                    igcd = igc0 * T4 / T5;
                    igcs = igc0 * T3 / T5;
                end else begin
                    igcs = igc0 * T4 / T5;
                    igcd = igc0 * T3 / T5;
                end
                // Igs
                T2      = Vgs_noswap - Vfbsdr;
                Vgs_eff = sqrt(T2 * T2 + 1.0e-4);
                if (IGCLAMP == 1) begin
                    T1 = hypsmooth((AIGS_i - BIGS_i * Vgs_eff), 1.0e-6);
                    if (CIGS_i < 0.01) begin
                        CIGS_i = 0.01;
                    end
                end else begin
                    T1 = AIGS_i - BIGS_i * Vgs_eff;
                end
                T2       = 1.0 + CIGS_i * Vgs_eff;
                T3       = BechvbEdge * T1 * T2;
                T4       = lexp(T3);
                igs_mult = igtemp * NF * AechvbEdges * DLCIG_i;
                igs      = igs_mult * Vgs_noswap * Vgs_eff * T4;
                // Igd
                T2      = Vgd_noswap - Vfbsdr;
                Vgd_eff = sqrt(T2 * T2 + 1.0e-4);
                if (IGCLAMP == 1) begin
                    T1 = hypsmooth((AIGD_i - BIGD_i * Vgd_eff), 1.0e-6);
                    if (CIGD_i < 0.01) begin
                        CIGD_i = 0.01;
                    end
                end else begin
                    T1 = AIGD_i - BIGD_i * Vgd_eff;
                end
                T2       = 1.0 + CIGD_i * Vgd_eff;
                T3       = BechvbEdge * T1 * T2;
                T4       = lexp(T3);
                igd_mult = igtemp * NF * AechvbEdged * DLCIGD_i;
                igd      = igd_mult * Vgd_noswap * Vgd_eff * T4;
            end
        end
        IGS  = devsign * MULT_I * igs;
        IGD  = devsign * MULT_I * igd;
        IGB  = devsign * MULT_I * igb;
        IGCS = devsign * MULT_I * igcs;
        IGCD = devsign * MULT_I * igcd;

        // Junction capacitances (no swapping)
        // Source-to-bulk junction
        Czbs       = CJS_t * ASeff;
        Czbssw     = CJSWS_t * PSeff;
        Czbsswg    = CJSWGS_t * Weffcj * NF;
        czbs_p1    = pow(0.1, -MJS);

        if (MJS == 1) begin
            czbs_p2    = 1.5 - ln(0.1);
        end else begin
            czbs_p2    = 1.0 / (1.0 - MJS) * (1.0 - 0.05 * MJS * (1.0 + MJS) * czbs_p1);
        end
        czbssw_p1  = pow(0.1, -MJSWS);
        if (MJSWS == 1) begin
            czbssw_p2    = 1.5 - ln(0.1);
        end else begin
            czbssw_p2  = 1.0 / (1.0 - MJSWS) * (1.0 - 0.05 * MJSWS * (1.0 + MJSWS) * czbssw_p1);
        end
        czbsswg_p1 = pow(0.1, -MJSWGS);
        if (MJSWGS == 1) begin
            czbsswg_p2    = 1.5 - ln(0.1);
        end else begin
            czbsswg_p2 = 1.0 / (1.0 - MJSWGS) * (1.0 - 0.05 * MJSWGS * (1.0 + MJSWGS) * czbsswg_p1);
        end

        `JunCap(Czbs, Vbs_jct, PBS_t, MJS, czbs_p1, czbs_p2, Qbsj1)
        `JunCap(Czbssw, Vbs_jct, PBSWS_t, MJSWS, czbssw_p1, czbssw_p2, Qbsj2)
        `JunCap(Czbsswg, Vbs_jct, PBSWGS_t, MJSWGS, czbsswg_p1, czbsswg_p2, Qbsj3)

        Qbsj4 = TT * Ibsdif * NF;
        Qbsj = Qbsj1 + Qbsj2 + Qbsj3 + Qbsj4;

        // Drain-to-bulk junction
        Czbd       = CJD_t * ADeff;
        Czbdsw     = CJSWD_t * PDeff;
        Czbdswg    = CJSWGD_t * Weffcj * NF;
        czbd_p1    = pow(0.1, -MJD);

        if (MJD == 1) begin
            czbd_p2    = 1.5 - ln(0.1);
        end else begin
            czbd_p2    = 1.0 / (1.0 - MJD) * (1.0 - 0.05 * MJD * (1.0 + MJD) * czbd_p1);
        end
        czbdsw_p1  = pow(0.1, -MJSWD);
        if (MJSWD == 1) begin
            czbdsw_p2  = 1.5 - ln(0.1);
        end else begin
            czbdsw_p2  = 1.0 / (1.0 - MJSWD) * (1.0 - 0.05 * MJSWD * (1.0 + MJSWD) * czbdsw_p1);
        end
        czbdswg_p1 = pow(0.1, -MJSWGD);
        if (MJSWGD == 1) begin
            czbdswg_p2 = 1.5 - ln(0.1);
        end else begin
            czbdswg_p2 = 1.0 / (1.0 - MJSWGD) * (1.0 - 0.05 * MJSWGD * (1.0 + MJSWGD) * czbdswg_p1);
        end

        `JunCap(Czbd, Vbd_jct, PBD_t, MJD, czbd_p1, czbd_p2, Qbdj1)
        `JunCap(Czbdsw, Vbd_jct, PBSWD_t, MJSWD, czbdsw_p1, czbdsw_p2, Qbdj2)
        `JunCap(Czbdswg, Vbd_jct, PBSWGD_t, MJSWGD, czbdswg_p1, czbdswg_p2, Qbdj3)

        Qbdj4 = TT * Ibddif * NF;
        Qbdj = Qbdj1 + Qbdj2 + Qbdj3 + Qbdj4;

        // Sub-surface leakage drain current
        if (SSLMOD != 0) begin
            T1 = pow(NDEP_i / 1.0e23, SSLEXP1);
            T2 = pow(300.0 / DevTemp, SSLEXP2);
            T3 = (devsign*SSL5 * V(bi,si)) / Vt;
            SSL0_NT  = SSL0 * lexp(-T1 * T2);
            SSL1_NT  = SSL1 * T2 * T1;
            PHIB_SSL = SSL3 * tanh(lexp(devsign * SSL4 * (V(gi, bi) - VTH - V(si,bi))));
            Issl     = sigvds * NF * Weff * SSL0_NT * lexp(T3) * lexp(-SSL1_NT * Leff) * lexp(PHIB_SSL / Vt) * (lexp(SSL2 * Vdsx / Vt) - 1.0);
            I(di, si) <+ devsign * MULT_I * Issl;
        end

        // Harshit's new flicker noise model. Ref: H. Agarwal et. al., IEEE J-EDS, vol. 3, no. 4, April 2015.
        Nt      = 4.0 * Vt * `P_Q_NIST1998;
        Esatnoi = 2.0 * VSAT_a / ueff;
        if (EM <= 0.0) begin
            DelClm = 0.0;
        end else begin
            T0     = (diffVds / litl + EM) / Esatnoi;
            DelClm = litl * lln(T0);
            if (DelClm < 0.0) begin
                DelClm = 0.0;
            end
        end
        Nstar = Vt / `P_Q_NIST1998 * (Cox + Cdep + CIT_i);
        Nl    = 2.0 * nq * Cox * Vt * qdeff * Mnud1 * Mnud / `P_Q_NIST1998;
        T0a   = `P_Q_NIST1998 * `P_Q_NIST1998 * `P_Q_NIST1998 * Vt * abs(ids) * ueff;
        T0b   = `P_Q_NIST1998 * Vt * ids * ids;
        T0c   = NOIA + NOIB * Nl + NOIC * Nl * Nl;
        T0d   = (Nl + Nstar) * (Nl + Nstar);
        T0e   = NOIA * `P_Q_NIST1998 * Vt;
        if (FNOIMOD == 1) begin
            LH1 = LH_d;
            if (Leff > LH1) begin
                T0 = (Leff - LH1);
            end else begin
                LH1 = Leff;
                T0 = LH1;
            end
            if (LINTNOI >= T0 / 2.0) begin
                $strobe("Warning: LINTNOI = %e is too large - Leff for noise is negative. Re-setting LINTNOI = 0.", LINTNOI);
                LINTNOI_i = 0.0;
            end else begin
                LINTNOI_i = LINTNOI;
            end
            LeffnoiH = Leff;
            vgfbh  = (Vg - VFB_i) / Vt;
            gam_h  = sqrt(2.0 * `P_Q_NIST1998 * epssi * HNDEP / Vt) / Cox;
            phib_h = ln(HNDEP / ni);

            // Pinch-Off potential for halo region
            `PO_psip(vgfbh, gam_h, 0.0, phib_h, psiph)

            // Normalized inversion charge at source end of halo MOSFET
            `BSIM_q(psiph, phib_h, vs, gam_h, qsh)
            `Smooth(psiph, 1.0, 2.0, psiphclamp)
            nq_h = 1.0 + gam_h / (2.0 * sqrt(psiphclamp));

            // Setting mobility of halo region equal to the mobility of the channel. In general, U0H < ueff
            U0_i_h  = ueff;
            beta_h  = U0_i_h * Cox * Weff * NF;
            beta_ch = ueff * Cox * Weff * NF;

            // Normalized drain current for halo transistor. Eq. (14) of the paper
            i1 = ids * LH1 / (2.0 * nq_h * beta_h * Vt * Vt);

            // Normalized drain current for channel transistor. Eq. (15) of the paper
            i2 = ids * (LeffnoiH - LH1) / (2.0 * nq * beta_ch * nVt * nVt);
            T0 = (1.0 + 4.0 * (qsh * qsh + qsh - i1));
            if (T0 < 1.0) begin
                qdh = 0.0;
            end else begin
                // Drain charge of halo transistor. Eq. (16) of the paper
                qdh = -0.5 + 0.5 * sqrt(T0);
            end

            // Source charge of channel transistor. Eq. (17) of the paper
            qsch   = -0.5 + 0.5 * sqrt(1.0 + 4.0 * (qdeff * qdeff + qdeff + i2));
            gds_h  = 2.0 * nq_h * beta_h * Vt * qdh;
            gds_ch = 2.0 * nq * beta_ch * Vt * qdeff;
            gm_ch  = 2.0 * beta_ch * Vt * (qsch - qdeff);
            R_ch   = gds_h * (LeffnoiH - LH1);
            R_h    = gm_ch * LH1 + gds_ch * LH1;
            t_tot  = 1.0 / (R_ch + R_h) / (R_ch + R_h);
            CF_ch  = R_ch * R_ch * t_tot;
            CF_h   = R_h * R_h * t_tot;

            // Local noise source
            if (Leff != LH1) begin
                Np2       = 2.0 * nq * Cox * Vt * qsch / `P_Q_NIST1998;
                Leffnoi   = LeffnoiH - 2.0 * LINTNOI_i-LH1;
                Leffnoisq = Leffnoi * Leffnoi;
                // Channel transistor LNS
                T1     = 1.0e10 * Cox * Leffnoisq;
                T2     = NOIA * lln((Np2 + Nstar) / (Nl + Nstar));
                T3     = NOIB * (Np2 - Nl);
                T4     = 0.5 * NOIC * (Np2 * Np2 - Nl * Nl);
                T5     = 1.0e10 * Leffnoisq * Weff * NF;
                Ssi_ch = T0a / T1 * (T2 + T3 + T4) + T0b / T5 * DelClm * T0c / T0d;
                T6     = Weff * NF * Leffnoi * 1.0e10 * Nstar * Nstar;
                Swi_ch = T0e / T6 * ids * ids;
                T7 = Swi_ch + Ssi_ch;
                if (T7 > 0.0) begin
                    FNPowerAt1Hz_ch = (Ssi_ch * Swi_ch) / T7;
                end else begin
                    FNPowerAt1Hz_ch = 0.0;
                end
            end else begin
                FNPowerAt1Hz_ch = 0.0;
            end

            // Halo transistor LNS
            T8    = NOIA2 * `P_Q_NIST1998 * Vt;
            T9    = Weff * NF * LH1 * 1.0e10 * Nstar * Nstar;
            Swi_h = T8 / T9 * ids * ids;
            T10   = Swi_h;
            if (T10 > 0.0) begin
                FNPowerAt1Hz_h = Swi_h;
            end else begin
                FNPowerAt1Hz_h = 0.0;
            end
            // Overall noise
            FNPowerAt1Hz = FNPowerAt1Hz_ch * CF_ch + FNPowerAt1Hz_h * CF_h;
            I(di, si) <+ flicker_noise(sigvds*MULT_FN*FNPowerAt1Hz, EF, "1overf");
        end else begin
            // Parameter checking
            if (LINTNOI >= Leff/2.0) begin
                $strobe("Warning: LINTNOI = %e is too large - Leff for noise is negative. Re-setting LINTNOI = 0.", LINTNOI);
                LINTNOI_i = 0.0;
            end else begin
                LINTNOI_i = LINTNOI;
            end
            if (NOIA > 0.0 || NOIB > 0.0 || NOIC > 0.0) begin
                Leffnoi   = Leff - 2.0 * LINTNOI_i;
                Leffnoisq = Leffnoi * Leffnoi;
                T0        = 1.0e10 * Cox * Leffnoisq;
                N0        = 2.0 * nq * Cox * Vt * qs * Mnud1 * Mnud / `P_Q_NIST1998;
                T1        = NOIA * lln((N0 + Nstar) / (Nl + Nstar));
                T2        = NOIB * (N0 - Nl);
                T3        = 0.5 * NOIC * (N0 * N0 - Nl * Nl);
                T4        = 1.0e10 * Leffnoisq * Weff * NF;
                Ssi       = T0a / T0 * (T1 + T2 + T3) + T0b / T4 * DelClm * T0c / T0d;
                T5        = Weff * NF * Leffnoi * 1.0e10 * Nstar * Nstar;
                Swi       = T0e / T5 * ids * ids;
                T6        = Swi + Ssi;
                if (T6 > 0.0) begin
                    FNPowerAt1Hz = (Ssi * Swi) / T6/(1.0+NOIA1*pow((qs-qdeff),NOIAX));
                end else begin
                    FNPowerAt1Hz = 0.0;
                end
            end else begin
                FNPowerAt1Hz = 0.0;
            end
            I(di, si) <+ flicker_noise(sigvds*MULT_FN*FNPowerAt1Hz, EF, "1overf");
        end

        T0         = qia / Esatnoi / Leff;
        T1         = T0 * T0;
        T3         = RNOIA * (1.0 + TNOIA * Leff * T1);
        T4         = RNOIB * (1.0 + TNOIB * Leff * T1);
        T5         = RNOIK * (1.0 + TNOIK * Leff * T1);
        ctnoi      = RNOIC * (1.0 + TNOIC * Leff * T1);
        betanoisq  = 3.0 * T3 * T3;
        betanoisq  = (betanoisq - 1.0) * lexp(-Leff / LP) + 1.0;
        betaLowId  = T5 * T5;
        thetanoisq = T4 * T4;
        cm_igid    = 0.0;
        case (TNOIMOD)
            0: begin
                QSi   = -NF * Weff * Leff * Cox * Vt * Qs;
                QDi   = -NF * Weff * Leff * Cox * Vt * Qd;
                T0    = ueff * abs(QSi + QDi);
                T1    = T0 * Rdsi + Leff * Leff;
                Gtnoi = (T0 / T1) * NTNOI;
                sidn  = Nt * Gtnoi;
                I(di, si) <+ white_noise(MULT_I * sidn, "id");
            end
            1: begin
                Vtn   = 2.0 * nq * nVt;
                T0    = ueff * Dptwg * Moc * Cox * Vtn;
                T1    = 0.5 * (qs + qdeff);
                T3    = T1 + 0.5;
                T4    = T3 * T3;
                T5    = T4 * T3;
                T6    = (qs - qdeff);
                T7    = T6 * T6;
                T8    = T7 * T6;
                T9    = (6.0 * T1 + 0.5) * T7;
                Lvsat = Leff * Dptwg;
                T10   = Lvsat / Leff;
                T12   = 1.0 + (betaLowId * (Vdseff / Vdssat) / (TNOIK2 + qia));
                T12   = ((T12 - 1.0) * lexp(-Leff / LP)) + 1.0;
                `Smooth(T12, 0.0, 1.0e-1, T12)
                mid   = T0 * NF * Weff / Lvsat * (T1 * T12 + T7 * betanoisq / (12.0 * T3));
                mig   = Lvsat * T10 * T10 * (T1 / T4 - T9 / (60.0 * T4 * T4) + T7 * T7 / (144.0 * T4 * T5)) * 15.0 / 4.0 * thetanoisq / (NF * Weff * 12.0 * T0);
                migid = T10 * (T6 / (12.0 * T3) - T8 / (144.0 * T5)) * ctnoi / 0.395;
                sqid  = sqrt(Nt * mid);
                if (mig > 0.0) begin
                    sqig = sqrt(Nt / mig);
                    if (sqid > 0.0) begin
                        cm_igid = migid * sqig / sqid;
                    end else begin
                        cm_igid = 0.0;
                    end
                end else begin
                    sqig    = 0.0;
                    cm_igid = 0.0;
                end
                I(N2)     <+ white_noise(cm_igid, "corl");
                I(NI)     <+ white_noise(sqig * sqig * (1.0 - cm_igid), "corl");
                I(NI)     <+ -sqig * V(N2);
                I(NC)     <+ ddt(mig * Cox * Weff * NF * Leff * V(NC));
                I(di, si) <+ white_noise(MULT_I * sqid * sqid * (1.0 - cm_igid), "id");
                I(di, si) <+ sqid * MULT_I * V(N2);
                I(gi, si) <+ ddt(0.5 * MULT_Q * ((1.0 + sigvds) * mig * Cox * Weff * NF * Leff * V(NC)));
                I(gi, di) <+ ddt(0.5 * MULT_Q * ((1.0 - sigvds) * mig * Cox * Weff * NF * Leff * V(NC)));
            end
        endcase
        I(N2) <+ V(N2);
        I(NR) <+ V(NR);

        // Low frequency excess noise due to FBE
        I(bi,di) <+ white_noise( 2 * MULT_I * `P_Q_NIST1998 * NOIF * abs(Ibd), "ibd");
        I(bi,si) <+ white_noise( 2 * MULT_I * `P_Q_NIST1998 * NOIF * abs(Ibs), "ibs");

        // Gate current shot noise
        if (IGCMOD != 0) begin
            I(gi, si) <+ white_noise(2.0 * MULT_I * `P_Q_NIST1998 * abs(igcs + igs), "igs");
            I(gi, di) <+ white_noise(2.0 * MULT_I * `P_Q_NIST1998 * abs(igcd + igd), "igd");
        end
        if (IGBMOD != 0) begin
            I(gi, bi) <+ white_noise(2.0 * MULT_I * `P_Q_NIST1998 * abs(igb), "igb");
        end

        // C-V model
        vgfbCV   = vgfb;

        invgamg2 = 0.0;

        if (CVMOD == 1) begin
            VFBCV_i = VFBCV_i + DELVTO;
            vg      = Vg * inv_Vt;
            vs      = Vs * inv_Vt;
            vfb     = VFBCV_i * inv_Vt;
            vgfbCV  = vg - vfb;
            phibCV    = lln(NDEPCV_i / ni);
            // Normalized body factor
            gamCV      = sqrt(2.0 * `P_Q_NIST1998 * epssi * NDEPCV_i * inv_Vt) / Cox;
            inv_gam  = 1.0 / gamCV;
            gamg2    = (2.0 * `P_Q_NIST1998 * epssi * NGATE_i) / (Cox * Cox * Vt);
            invgamg2 = (NGATE_i > 0.0) ? (1.0 / gamg2) : 0.0;
            DPD      = (NGATE_i > 0.0) ? (NDEPCV_i / NGATE_i) : 0.0;

            // psip: pinch-off voltage
            `PO_psip(vgfbCV, gamCV, DPD, phibCV, psip)

            // Normalized inversion charge at source end of channel
            `BSIM_q(psip, phibCV, vs, gamCV, qs)
            `Smooth(psip, 1.0, 2.0, psipclamp)
            sqrtpsip = sqrt(psipclamp);

            // Source side surface potential
            psiavg = psip - 2.0 * qs;
            `Smooth(psiavg, 1.0, 2.0, T0)
            nq = 1.0 + gamCV / (sqrtpsip + sqrt(T0));

            // Drain saturation voltage
            T0 = Vt * (vgfbCV - psip - 2.0 * qs * (nq - 1.0));
            `Smooth(T0, 0.0, 0.1, qbs)

            // Source side qi and qb for Vdsat (normalized to Cox)
            qis = 2.0 * nq * Vt * qs;
            Eeffs = EeffFactor * (qbs + eta_mu * qis);

            // Ref: BSIM4 mobility model
            T3 = (UA_a + UC_a * Vbsx) * pow(Eeffs, EU_t);
            T4 = 1.0 + T3;
            `Smooth(T4, 1.0, 0.0015, Dmobs)
            LambdaC_by2 = (U0_a / Dmobs) * Vt / (VSATCV_t * Lact);
            qdsat       = LambdaC_by2 * (qs * qs + qs) / (1.0 + LambdaC_by2 * (1.0 + qs));
            vdsatcv     = psip - 2.0 * phibCV - (2.0 * qdsat + lln((qdsat * 2.0 * nq * inv_gam) * ((qdsat * 2.0 * nq * inv_gam) + (gamCV / (nq - 1.0)))));
            VdsatCV     = vdsatcv * Vt;
            `Smooth(VdsatCV - Vs, 0.0, 1.0e-3, VdssatCV)
            if (A0CV == 0.0 && AGSCV == 0.0) begin
                AbulkCV = ABULK;
            end else begin
                T1    = Leff / (Leff + sqrt(XJ_i * Xdep));
                AbulkCV = 1.0 + (A0CV * T1 - AGSCV * T1 * qs * nVt) / (1.0 + KETACV * Vbsx);
                `Smooth(AbulkCV, 0.1, 0.0005, AbulkCV)
            end
            VdssatCV     = VdssatCV / AbulkCV;
            T7     = pow((Vds / VdssatCV) + 1.0e-6, 1.0 / DELTA_t);
            T8     = pow(1.0 + T7, -DELTA_t);
            Vdseff = Vds * T8;
            vdeff  = (Vdseff + Vs) * inv_Vt;
            `BSIM_q(psip, phibCV, vdeff, gamCV, qdeff)

            // Reevaluation of nq to include qdeff needed for gummel symmetry
            psiavg = psip - qs - qdeff - 1.0;
            `Smooth(psiavg, 1.0, 2.0, T0)
            T2 = sqrt(T0);
            T3 = 1.0 + DPD + gamCV / (sqrtpsip + T2);
            T4 = 0.5 + DPD * T2 * inv_gam;
            T5 = sqrt(T4 * T4 + T3 * (qs + qdeff) * invgamg2);
            nq = T3 / (T4 + T5);

            // C-V expressions including velocity saturation and CLM
            // Velocity saturation for C-V
            T0  = Vt * (vgfbCV - psip - 2.0 * qs * (nq - 1.0));
            `Smooth(T0, 0.0, 0.1, qbs)
            T1  = Vt * (vgfbCV - psip - 2.0 * qdeff * (nq - 1.0));
            `Smooth(T1, 0.0, 0.1, qbd)
            qb  = 0.5 * (qbs + qbd);
            qia = nq * Vt * (qs + qdeff);
            Eeffm = EeffFactor * (qb + eta_mu * qia);
            `PO_psip((vgfbCV + DELVFBACC * inv_Vt), gamCV, DPD, phibCV, psip)
            T3    = (UA_a + UC_a * Vbsx) * pow(Eeffm, EU_t);
            T4    = 1.0 + T3;
            `Smooth(T4, 1.0, 0.0015, Dmob)
            LambdaC = 2.0 * (U0_a / Dmob) * Vt / (VSATCV_t * Lact);
            dps     = qs - qdeff;
            T1      = 2.0 * (LambdaC * dps) * (LambdaC * dps);
            zsat    = sqrt(1.0 + T1);
            Dvsat   = 0.5 * (1.0 + zsat);
            // CLM for C-V
            Esat    = 2.0 * VSATCV_t / (U0_a / Dmob);
            EsatL   = Esat * Lact;
            Vasat   = VdssatCV + EsatL;
            diffVds = Vds - Vdseff;
        end
        if (PCLMCV_i != 0.0) begin
            MdL = 1.0 + PCLMCV_i * lln(1.0 + diffVds / PCLMCV_i / Vasat);
        end else begin
            MdL = 1.0;
        end
        //MdL = 1;
        MdL_2       = MdL * MdL;
        inv_MdL     = 1.0 / MdL;
        inv_MdL_2   = 1.0 / MdL_2;
        MdL_less_1  = MdL - 1.0;
        vgpqm = vgfbCV - psip;
        DQSD  = (qs - qdeff);
        DQSD2 = (qs - qdeff) * (qs - qdeff);
        sis   = vgpqm + 2.0 * qs;
        sid   = vgpqm + 2.0 * qdeff;
        `Smooth(sis, 0.0, 0.5, T1)
        `Smooth(sid, 0.0, 0.5, T2)
        Temps = sqrt(0.25 + T1 * invgamg2);
        Tempd = sqrt(0.25 + T2 * invgamg2);
        T1 = sis / (1.0 + 2.0 * Temps);
        T2 = sid / (1.0 + 2.0 * Tempd);
        T3 = Temps + Tempd;
        T4 = `Oneby3 * (DQSD2 / (T3 * T3 * T3));
        T5 = (AbulkCV * Dvsat * inv_MdL) / (1.0 + qs + qdeff);
        T6 = 0.8 * (T3 * T3 + Temps * Tempd) * T5;
        T7 = T6 + (2.0 * invgamg2);
        T8 = `Oneby3 * DQSD2 * T5;
        dqgeff = sid * (2.0 * Tempd - 1.0) / (2.0 * Tempd + 1.0);
        qbeff  = vgpqm - 2.0 * (nq - 1.0) * qdeff + dqgeff;
        Qb  = inv_MdL * (T1 + T2 + (T4 * T7 - nq * (qs + qdeff + T8))) + MdL_less_1 * qbeff;
        T9  = qs + qdeff;
        T10 = DQSD2 * T5 * T5;
        Qi  = nq * inv_MdL * (T9 + `Oneby3 * DQSD2 * T5) + 2.0 * nq * MdL_less_1 * qdeff;
        Qd1 = nq * inv_MdL_2 * (0.5 * T9 - (DQSD / 6.0) * (1.0 - DQSD * T5 - 0.2 * T10));
        Qd2 = nq * (MdL - inv_MdL) * qdeff;
        Qd  = Qd1 + Qd2;
        Qs  = Qi - Qd;

        // Quantum mechanical effects
        `Smooth(Vt * Qb, 0.0, 0.1, qbaCV)

        qiaCV      = Vt * (Qs + Qd);
        T0         = (qiaCV + ETAQM * qbaCV) / QM0;
        T1         = 1.0 + pow(T0, 0.7 * BDOS);
        XDCinv     = ADOS * 1.9e-9 / T1;
        Coxeffinv  = 3.9 * `P_EPS0 / (BSIMBULKTOXP * 3.9 / EPSROX + XDCinv / epsratio);
        QBi        =  -(NF * Wact * Lact + AGBCP) * (`P_EPS0 * EPSROX / BSIMBULKTOXP) * Vt * Qb;
        WLCOXVtinv = (NF * Wact * Lact + AGBCP) * Coxeffinv * Vt;
        QDi = -WLCOXVtinv * Qd;
        QSi = -WLCOXVtinv * Qs;

        //AGBCP2 Cap
        if (MODAGBCP2 == 1) begin
            VFBAGBCP2_i = VFBAGBCP2 + DELVTO;
            vg1      = Vg1 * inv_Vt;
            vs1      = Vs1 * inv_Vt;
            vfb     = VFBAGBCP2_i * inv_Vt;
            vgfbAGBCP2  = vg1 - vfb;
            phibAGBCP2  = lln(NDEPAGBCP2_d / ni);
            // Normalized body factor
            gamAGBCP2      = sqrt(2.0 * `P_Q_NIST1998 * epssi * NDEPAGBCP2_d * inv_Vt) / Cox;
            inv_gam  = 1.0 / gamAGBCP2;

            invgamg2 = 0.0;
            DPD      = 0.0;

            // psip: pinch-off voltage
            `PO_psip(vgfbAGBCP2, gamAGBCP2, DPD, phibAGBCP2, psip)

            // Normalized inversion charge at source end of channel
            `BSIM_q(psip, phibAGBCP2, vs1, gamAGBCP2, qs)
            `Smooth(psip, 1.0, 2.0, psipclamp)
            sqrtpsip = sqrt(psipclamp);

            // Source side surface potential
            psiavg = psip - 2.0 * qs;
            `Smooth(psiavg, 1.0, 2.0, T0)
            nq = 1.0 + gamAGBCP2 / (sqrtpsip + sqrt(T0));

            // Drain saturation voltage
            T0 = Vt * (vgfbAGBCP2 - psip - 2.0 * qs * (nq - 1.0));
            `Smooth(T0, 0.0, 0.1, qbs)

            // Source side qi and qb for Vdsat (normalized to Cox)
            qis = 2.0 * nq * Vt * qs;
            Eeffs = EeffFactor * (qbs + eta_mu * qis);

            // Ref: BSIM4 mobility model
            T3 = (UA_a + UC_a * Vbsx1) * pow(Eeffs, EU_t);
            T4 = 1.0 + T3;
            `Smooth(T4, 1.0, 0.0015, Dmobs)
            LambdaC_by2 = (U0_a / Dmobs) * Vt / (VSATCV_t * Lact);
            qdsat       = LambdaC_by2 * (qs * qs + qs) / (1.0 + LambdaC_by2 * (1.0 + qs));
            vdsatcv     = psip - 2.0 * phibAGBCP2 - (2.0 * qdsat + lln((qdsat * 2.0 * nq * inv_gam) * ((qdsat * 2.0 * nq * inv_gam) + (gamAGBCP2 / (nq - 1.0)))));
            VdsatCV     = vdsatcv * Vt;
            `Smooth(VdsatCV - Vs1, 0.0, 1.0e-3, VdssatCV)
            VdssatCV     = VdssatCV;
            T7     = pow((Vds / VdssatCV) + 1.0e-6, 1.0 / DELTA_t);
            T8     = pow(1.0 + T7, -DELTA_t);
            Vdseff = Vds * T8;
            vdeff  = (Vdseff + Vs1) * inv_Vt;
            `BSIM_q(psip, phibAGBCP2, vdeff, gamAGBCP2, qdeff)

            // Reevaluation of nq to include qdeff needed for gummel symmetry
            psiavg = psip - qs - qdeff - 1.0;
            `Smooth(psiavg, 1.0, 2.0, T0)
            T2 = sqrt(T0);
            T3 = 1.0 + DPD + gamAGBCP2 / (sqrtpsip + T2);
            T4 = 0.5 + DPD * T2 * inv_gam;
            T5 = sqrt(T4 * T4 + T3 * (qs + qdeff) * invgamg2);
            nq = T3 / (T4 + T5);

            MdL = 1;
            MdL_2       = MdL * MdL;
            inv_MdL     = 1.0 / MdL;
            inv_MdL_2   = 1.0 / MdL_2;
            MdL_less_1  = MdL - 1.0;
            vgpqm = vgfbAGBCP2 - psip;
            DQSD  = (qs - qdeff);
            DQSD2 = (qs - qdeff) * (qs - qdeff);
            sis   = vgpqm + 2.0 * qs;
            sid   = vgpqm + 2.0 * qdeff;
            `Smooth(sis, 0.0, 0.5, T1)
            `Smooth(sid, 0.0, 0.5, T2)
            Temps = sqrt(0.25 + T1 * invgamg2);
            Tempd = sqrt(0.25 + T2 * invgamg2);
            T1 = sis / (1.0 + 2.0 * Temps);
            T2 = sid / (1.0 + 2.0 * Tempd);
            T3 = Temps + Tempd;
            T4 = `Oneby3 * (DQSD2 / (T3 * T3 * T3));

            Dvsat = 0; //
            T5 = (Dvsat * inv_MdL) / (1.0 + qs + qdeff);
            T6 = 0.8 * (T3 * T3 + Temps * Tempd) * T5;
            T7 = T6 + (2.0 * invgamg2);
            T8 = `Oneby3 * DQSD2 * T5;
            dqgeff = sid * (2.0 * Tempd - 1.0) / (2.0 * Tempd + 1.0);
            qbeff  = vgpqm - 2.0 * (nq - 1.0) * qdeff + dqgeff;
            Qb  = inv_MdL * (T1 + T2 + (T4 * T7 - nq * (qs + qdeff + T8))) + MdL_less_1 * qbeff;
            T9  = qs + qdeff;
            T10 = DQSD2 * T5 * T5;
            Qi  = nq * inv_MdL * (T9 + `Oneby3 * DQSD2 * T5) + 2.0 * nq * MdL_less_1 * qdeff;
            Qd1 = nq * inv_MdL_2 * (0.5 * T9 - (DQSD / 6.0) * (1.0 - DQSD * T5 - 0.2 * T10));
            Qd2 = nq * (MdL - inv_MdL) * qdeff;
            Qd  = Qd1 + Qd2;

            WLCOX = AGBCP2 * (`P_EPS0 * EPSROX / BSIMBULKTOXP) * Vt;
            QBi_AGBCP2        = WLCOX * Qb;
            QDi_AGBCP2        = WLCOX * Qd;
            Qi_AGBCP2         = WLCOX * Qi;

        end else begin
            QBi_AGBCP2 = 0.0;
            QDi_AGBCP2 = 0.0;
            Qi_AGBCP2 = 0.0;

        end

        QDim        = QDi;
        QSim        = QSi;
        QBim        = QBi;
        QGim        = -(QBim + QSim + QDim);

        QDiagbcp2   = -(MODAGBCP2 * QDi_AGBCP2);
        QSiagbcp2   = -(MODAGBCP2 * Qi_AGBCP2 - MODAGBCP2 * QDi_AGBCP2);
        QBiagbcp2   = -(MODAGBCP2 * QBi_AGBCP2);
        QGiagbcp2   = -(QBiagbcp2 + QSiagbcp2 + QDiagbcp2);
        QDi        = -(-QDi + MODAGBCP2 * QDi_AGBCP2);
        QSi        = -(-QSi + MODAGBCP2 * Qi_AGBCP2 - MODAGBCP2 * QDi_AGBCP2);
        QBi        = -(-QBi + MODAGBCP2 * QBi_AGBCP2);
        QGi        = -(QBi + QSi + QDi);

        // Outer fringing capacitances
        if (!$param_given(CF)) begin
            CF_i = 2.0 * EPSROX * `P_EPS0 / `M_PI * lln(CFRCOEFF * (1.0 + 0.4e-6 / TOXE));
        end
        Cgsof = CGSO + CF_i;
        Cgdof = CGDO + CF_i;

        // Overlap capacitances
        if (COVMOD == 0) begin
            Qovs = -Wact * NF * Cgsof * Vgs_ov_noswap;
            Qovd = -Wact * NF * Cgdof * Vgd_ov_noswap;
        end else begin
            T0    = sqrt((Vgs_ov_noswap - Vfbsdr + `DELTA_1) * (Vgs_ov_noswap - Vfbsdr + `DELTA_1) + 4.0 * `DELTA_1);
            Vgsov = 0.5 * (Vgs_ov_noswap - Vfbsdr + `DELTA_1 - T0);
            T6    = Vgsov / pow(1.0 + pow((-Vgsov / CKAPPAS1), CKAPPAS2), 1.0 / CKAPPAS2);
            T1    = sqrt(1.0 - 4.0 * T6 / CKAPPAS_i);
            Qovs  = -Wact * NF * (Cgsof * Vgs_ov_noswap + CGSL_i * (Vgs_ov_noswap - Vfbsdr - Vgsov - 0.5 * CKAPPAS_i * (-1.0 + T1)));
            T0    = sqrt((Vgd_ov_noswap - Vfbsdr + `DELTA_1) * (Vgd_ov_noswap - Vfbsdr + `DELTA_1) + 4.0 * `DELTA_1);
            Vgdov = 0.5 * (Vgd_ov_noswap - Vfbsdr + `DELTA_1 - T0);
            T6    = Vgdov / pow(1.0 + pow((-Vgdov / CKAPPAD1), CKAPPAD2), 1.0 / CKAPPAD2);
            T2    = sqrt(1.0 - 4.0 * T6 / CKAPPAD_i);
            Qovd  = -Wact * NF * (Cgdof * Vgd_ov_noswap + CGDL_i * (Vgd_ov_noswap - Vfbsdr - Vgdov - 0.5 * CKAPPAD_i * (-1.0 + T2)));
        end
        Qovb = -devsign * NF * Lact * CGBO * V(gm, bi);
        Qovg = -(Qovs + Qovd + Qovb);

        //Backgate Charges --- related to new introduced substrate terminal
        LeffCVb = Lnew - 2.0 * dLCV - DLCB;
        LeffCVbg = LeffCVb + 2.0 * DLBG;
        if (NSUB_i > 0) begin
            T0 = lln(NDEP_i / NSUB_i);
            vfbb = -devsign * Vtm * T0;
        end else begin
            T0 = lln(-NDEP_i * NSUB_i / ni / ni);
            vfbb = -devsign * Vtm * T0;
        end

        Vesfb = Ves - vfbb;
        Cbox = 3.453133e-11 / TBOX;
        CboxWL = KB1_i * FBODY * Cbox * (Wact / NSEG * NF * LeffCVbg + AEBCP);
        Qe1 = CboxWL * (Vesfb - Vbs);
        Qsub = Qe1;

        //Sidewall Fringing Capacitance
        T0 = CSDESW * lln(CFRCOEFF * (1.0 + TSI / TBOX));
        T1 = PS - W;
        if (T1 > 0.0)
            csesw = T0 * T1;
        else
            csesw = 0.0;

        T1 = PD - W;
        if (T1 > 0.0)
            cdesw = T0 * T1;
        else
            cdesw = 0.0;

        // Extrinsic Bottom S/D to Substrate Charge
        csbox = Cbox * AS;
        csmin = CSDMIN * AS;
        cdbox = Cbox * AD;
        cdmin = CSDMIN * AD;

        //T10 is vse without type conversion
        //T11 is vde without type conversion
        T10 = -devsign * ves;
        T11 = -devsign * ved;

        if (CSDMIN != 0) begin
            T1 = -0.5 * (cdbox - cdmin) / ACEDB;
            T2 = lln(cosh(-ACEDB * T11 + BCEDB));
            T3 = 0.5 * (cdbox + cdmin) * T11;
            qde = T1 * T2 + T3;

            T1 = -0.5 * (csbox - csmin) / ACESB;
            T2 = lln(cosh(-ACESB * T10 + BCESB));
            T3 = 0.5 * (csbox + csmin) * T10;
            qse = T1 * T2 + T3;
        end else begin
            qse = csbox * T10;
            qde = cdbox * T11;
        end

        qse = qse + csesw * T10;
        qde = qde + cdesw * T11;

         // Edge FET model
        if (EDGEFET == 1) begin
            phib_edge     = lln(NDEPEDGE_i / ni);
            Phist         = max(0.4 + Vt * phib_edge + PHIN_i, 0.4);

            T1DEP         = sqrt(2.0 * epssi / (`P_Q_NIST1998 * NDEPEDGE_i));
            NFACTOREDGE_t = NFACTOREDGE_i * hypsmooth((1.0 + TNFACTOREDGE_i * (TRatio - 1.0)), 1e-3);
            ETA0EDGE_t    = ETA0EDGE_i * (1.0 + TETA0EDGE_i * (TRatio - 1.0));
            `Smooth(Phist - Vbsx, 0.05, 0.1, PhistVbs)
            sqrtPhistVbs  = sqrt(PhistVbs);
            Xdep          = T1DEP * sqrtPhistVbs;
            Cdep          = epssi / Xdep;
            cdsc          = CITEDGE_i + NFACTOREDGE_t + CDSCDEDGE_a * Vdsx - CDSCBEDGE_i * Vbsx;
            T1            = 1.0 + cdsc/Cox;
            `Smooth(T1, 1.0, 0.05, n)
            nVt       = n * Vt;
            inv_nVt   = 1.0 / nVt;
            vg        = Vg * inv_nVt;
            vs        = Vs * inv_nVt;
            vfb       = VFB_i * inv_nVt;
            dvth_dibl = -(ETA0EDGE_t + ETABEDGE_i * Vbsx) * Vdsx;
            dvth_temp = (KT1EDGE_i + KT1LEDGE_i / Leff + KT2EDGE_i * Vbsx) * (pow(TRatio, KT1EXPEDGE_i) - 1.0);
            litl_edge = litl * (1.0 + DVT2EDGE * Vbsx);
            if (litl_edge > 0) begin
                T0       = DVT1EDGE * Leff / litl_edge;
                if (T0 < 40.0) begin
                    theta_sce_edge = 0.5 * DVT0EDGE / (cosh(T0) - 1.0);
                end else begin
                    theta_sce_edge = DVT0EDGE * lexp(-T0);
                end
            end else begin
                theta_sce_edge = 0.0;
            end
            dvth_sce  = theta_sce_edge * (Vbi_edge - Phist);
            Vth_shift = dvth_dibl - dvth_temp + dvth_sce + DVTEDGE + vth0_stress_EDGE - (K2EDGE_i) * Vbsx + vth0_well_edge ;
            vgfb      = vg - vfb - Vth_shift * inv_nVt;
            // Normalized body factor
            DGAMMAEDGE_i = DGAMMAEDGE * (1.0 + DGAMMAEDGEL * pow(Leff, -DGAMMAEDGELEXP));
            gam_edge          = sqrt(2.0 * `P_Q_NIST1998 * epssi * NDEPEDGE_i * inv_nVt) / Cox;
            gam_edge          = gam_edge * (1.0 + DGAMMAEDGE_i);

            // psip: pinch-off voltage
            phib_n_edge  = phib_edge / n;
            `PO_psip(vgfb, gam_edge, 0.0, phib_n_edge, psip)
            `BSIM_q(psip, phib_n_edge, vs, gam_edge, qs_edge)

            // Approximate pinch-off voltage
            vdsatedge = 2.0 * nVt * qs_edge + 2.0 * nVt;
            Vdsatedge = vdsatedge;
            Vdsatedge = Vdsatedge + Vs;

            // Vdssat clamped to avoid negative values during transient simulation
            `Smooth(Vdsatedge - Vs, 0.0, 1.0e-3, Vdssate)
            T7     = pow((Vds / Vdssate) + 1.0e-6, 1.0 / DELTA_t);
            T8     = pow(1.0 + T7, -DELTA_t);
            Vdseff = Vds * T8;
            vdeff  = (Vdseff + Vs) * inv_nVt;
            `BSIM_q(psip, phib_n_edge, vdeff, gam_edge, qdeff_edge)

            // Nq calculation for Edge FET
            `Smooth(psip, 1.0, 2.0, psipclamp)
            sqrtpsip = sqrt(psipclamp);
            psiavg   = psip - qs_edge - qdeff_edge -1.0;
            `Smooth(psiavg, 1.0, 2.0, T0)
            T2       = sqrt(T0);
            nq_edge  = 1.0 + gam_edge / (sqrtpsip + T2);
            ids_edge = 2.0 * NF * nq_edge * ueff * WEDGE / Leff * Cox * nVt * nVt * ((qs_edge - qdeff_edge) * (1.0 + qs_edge + qdeff_edge)) * Moc;
            ids      = ids_edge + ids;

            // Flicker rnoise calculation for Edge FET
            noia_edge      = NOIA * NEDGE;
            noib_edge      = NOIB * NEDGE;
            noic_edge      = NOIC * NEDGE;
            Leffnoi_edge   = Leff-2.0 * LINTNOI_i;
            Leffnoisq_edge = Leffnoi_edge*Leffnoi_edge;
            Nstar = Vt / `P_Q_NIST1998 * (Cox + Cdep + CITEDGE_i);
            Nl    = 2.0 * nq_edge * Cox * Vt * qdeff_edge / `P_Q_NIST1998;
            T0a   = `P_Q_NIST1998 * `P_Q_NIST1998 * `P_Q_NIST1998 * Vt * abs(ids_edge) * ueff;
            T0b   = `P_Q_NIST1998 * Vt * ids_edge * ids_edge;
            T0c   = noia_edge + noib_edge * Nl + noic_edge * Nl * Nl;
            T0d   = (Nl + Nstar) * (Nl + Nstar);
            T0e   = noia_edge * `P_Q_NIST1998 * Vt;
            N0    = 2.0 * nq_edge * Cox * Vt * qs_edge / `P_Q_NIST1998;
            T1    = noia_edge * lln((N0 + Nstar) / (Nl + Nstar));
            T2    = noib_edge * (N0 - Nl);
            T3    = 0.5 * noic_edge * (N0 * N0 - Nl * Nl);
            T4    = 1.0e10 * Leffnoisq_edge * WEDGE * NF;
            Ssi   = T0a / T0 * (T1 + T2 + T3) + T0b / T4 * DelClm * T0c / T0d;
            T5    = WEDGE * NF * Leffnoi_edge * 1.0e10 * Nstar * Nstar;
            Swi   = T0e / T5 * ids_edge * ids_edge;
            T6    = Swi + Ssi;
            if (T6 > 0.0) begin
                T7 = (Ssi * Swi) / T6;
                T8 = 1.0 + NOIA1_EDGE * pow((qs_edge - qdeff_edge), NOIAX_EDGE);
                FNPowerAtedge = T7/T8;
            end else begin
                FNPowerAtedge = 0.0;
            end
            I(di, si) <+ flicker_noise(sigvds*MULT_FN*FNPowerAtedge, EF, "1overf_edgefet");
        end
        // End of Edge FET parasitic device drain current model

        // Charge expressions including fringing and overlap capacitances
        QB = devsign * MULT_Q * (QBi + Qovb + Qbsj + Qbdj);
        if (sigvds > 0) begin
            QSI = devsign * MULT_Q * QSi;
            QSIM = devsign * MULT_Q * QSim;
            QSIAGBCP2 = devsign * MULT_Q * QSiagbcp2;
            QDI = devsign * MULT_Q * QDi;
            QDIM = devsign * MULT_Q * QDim;
            QDIAGBCP2 = devsign * MULT_Q * QDiagbcp2;
            QS  = devsign * MULT_Q * (QSi + Qovs - Qbsj);
            QD  = devsign * MULT_Q * (QDi + Qovd - Qbdj);
        end else begin
            QSI = devsign * MULT_Q * QDi;
            QSIM = devsign * MULT_Q * QDim;
            QSIAGBCP2 = devsign * MULT_Q * QDiagbcp2;
            QDI = devsign * MULT_Q * QSi;
            QDIM = devsign * MULT_Q * QSim;
            QDIAGBCP2 = devsign * MULT_Q * QSiagbcp2;
            QS  = devsign * MULT_Q * (QDi + Qovs - Qbsj);
            QD  = devsign * MULT_Q * (QSi + Qovd - Qbdj);
        end
        QG = devsign * MULT_Q * (QGi + Qovg);

        // Output
        // Intrinsic charges
        QBI = devsign * MULT_Q * QBi;
        QGI = devsign * MULT_Q * QGi;
        QGIM = devsign * MULT_Q * QGim;
        QGIAGBCP2 = devsign * MULT_Q * QGiagbcp2;

    end
    // QSI and QDI are defined above
    // Intrinsic capacitances
    CGSI = -ddx(QGI, V(si));
    CGDI = -ddx(QGI, V(di));
    CGBI = -ddx(QGI, V(bi));
    CGGI = ddx(QGI, V(gi));
    CSSI = ddx(QSI, V(si));
    CSDI = -ddx(QSI, V(di));
    CSBI = -ddx(QSI, V(bi));
    CSGI = -ddx(QSI, V(gi));
    CDSI = -ddx(QDI, V(si));
    CDDI = ddx(QDI, V(di));
    CDBI = -ddx(QDI, V(bi));
    CDGI = -ddx(QDI, V(gi));
    CBSI = -ddx(QBI, V(si));
    CBDI = -ddx(QBI, V(di));
    CBBI = ddx(QBI, V(bi));
    CBGI = -ddx(QBI, V(gi));

    // Total capacitances
    CGS = -ddx(QG, V(si));
    CGD = -ddx(QG, V(di));
    CGB = -ddx(QG, V(bi));
    CGG = CGGI + ddx(devsign * MULT_Q * Qovg, V(gm));
    CSS = ddx(QS, V(si));
    CSD = -ddx(QS, V(di));
    CSB = CSBI - ddx((QS - QSI), V(bi));
    CSG = CSGI - ddx((QS - QSI), V(gm));
    CDS = -ddx(QD, V(si));
    CDD = ddx(QD, V(di));
    CDB = CDBI - ddx((QD - QDI), V(bi));
    CDG = CDGI - ddx((QD - QDI), V(gm));
    CBS = -ddx(QB, V(si));
    CBD = -ddx(QB, V(di));
    CBB = CBBI + ddx(QB, V(bi)) + ddx((devsign * MULT_Q * Qovb), V(bi));
    CBG = -ddx(QB, V(gi)) - ddx((devsign * MULT_Q * Qovb), V(gm));

    // Total extrinsic capacitance
    CGSEXT = -devsign * ddx(MULT_Q * Qovg, V(si));  // Gate-to-source overlap + outer fringing
    CGDEXT = -devsign * ddx(MULT_Q * Qovg, V(di));  // Gate-to-drain overlap + outer fringing
    CGBOV  = -devsign * ddx(MULT_Q * Qovg, V(bi));  // Gate-to-body overlap

    // Total S/D junction capacitances
    CAPBS  = -devsign * ddx(MULT_Q * Qbsj, V(si));
    CAPBD  = -devsign * (ddx(MULT_Q * Qbdj, V(di)));

    // W & L
    WEFF   = Weff;  // Effective width for I-V
    LEFF   = Leff;  // Effective length for I-V
    WEFFCV = Wact;  // Effective width for C-V
    LEFFCV = Lact;  // Effective length for C-V
    IBS   = -devsign * MULT_I * Ibs;                          // Source junction current
    IBD   = -devsign * MULT_I * (Ibd);              // Drain junction current
    // Currents and derivatives
    if (sigvds > 0) begin
        IDS   = devsign * MULT_I * ids;                       // Intrinsic drain-to-source current
        IDEFF = IDS - (IGD + IGCD) + ISUB + IGIDL + IBD;   // Total drain current
        ISEFF = -IDS - (IGS + IGCS) + IGISL + IBS;         // Total source current
    end else begin
        IDS   = -devsign * MULT_I * ids;                      // Intrinsic drain-to-source current
        IDEFF = IDS - (IGD + IGCD) + IGIDL + IBD;          // Total drain current
        ISEFF = -IDS - (IGS + IGCS) + ISUB + IGISL + IBS;  // Total source current
    end
    IGEFF = IGB + IGS + IGCS + IGD + IGCD;           // Total gate tunneling current
    VDS   = V(di, si);                               // Drain-to-source voltage
    VGS   = V(gi, si);
    VBS   = -V(si, bi);                              // Source-to-body voltage
    VDSAT = Vdssat;                                  // Drain-to-source saturation voltage
    GM    = ddx(IDS, V(gi));                         // Transconductance
    GMBS  = ddx(IDS, V(bi));                         // Body transconductance
    if (sigvds > 0) begin
        GDS   = ddx(IDS, V(di));                     // Output conductance
    end else begin
        GDS   = ddx(-IDS, V(si));
    end

    // Loading variables
    I(gi, bi)  <+ ddt(QGIM);
    I(gi, bi2) <+ ddt(QGIAGBCP2);
    I(si, bi)  <+ ddt(QSIM);
    I(si, bi2) <+ ddt(QSIAGBCP2);
    I(di, bi)  <+ ddt(QDIM);
    I(di, bi2) <+ ddt(QDIAGBCP2);
    I(gm, si)  <+ ddt(-devsign * MULT_Q * Qovs);
    I(gm, di)  <+ ddt(-devsign * MULT_Q * Qovd);
    I(gm, bi)  <+ ddt(-devsign * MULT_Q * Qovb);

    I(gi, bi2) <+ devsign * MULT_I * Ig_agbcp2;
    I(e, bi) <+ devsign * ddt(MULT_Q * Qsub);

    I(di,e)  <+ ddt(MULT_Q * qde);
    I(si,e)  <+ ddt(MULT_Q * qse);

    // Drain-to-source current
    I(di, si) <+ devsign * MULT_I * sigvds * ids;

    if (IGBMOD != 0) begin
        I(gi, bi) <+ IGB;
    end
    if (IGCMOD != 0) begin
        I(gi, si) <+ (IGS + IGCS);
        I(gi, di) <+ (IGD + IGCD);
    end
    if (sigvds > 0) begin
        I(di, bi) <+ ISUB + IGIDL;
        I(si, bi) <+ IGISL;
    end else begin
        I(di, bi) <+ IGIDL;
        I(si, bi) <+ ISUB + IGISL;
    end

    if (RGATEMOD == 0) begin
        V(g, gm) <+ 0.0;
    end else begin: rgate
        real Ggate, Gnoise;
        if (RGATEMOD == 2) begin
            Ggate  = Gcrg;
            Gnoise = Gcrg * Gcrg / Grgeltd;
        end else begin
            Ggate  = Grgeltd;
            Gnoise = Grgeltd;
        end
        I(g, gm) <+ V(g, gm) * MULT_I * Ggate;
        I(g, gm) <+ white_noise(Nt * MULT_I * Gnoise, "rg");
    end

    // External S/D resistances
    if (RDSMOD !=2 && RDrainGeo > 0) begin
        gdpr = 1.0 / Rdrain;   // Note: gdpr considers all fingers
        I(d, di) <+ V(d, di) * MULT_I * gdpr;
    end else begin
        V(d, di) <+ 0.0;
    end

    if (RDSMOD !=2 && RDrainGeo > 0) begin
        I(d, di) <+ white_noise(Nt * MULT_I * gdpr, "rd");
    end

    if (RDSMOD !=2 && RSourceGeo > 0) begin
        gspr = 1.0 / Rsource;   // Note: gspr considers all fingers
        I(s, si) <+ V(s, si) * MULT_I * gspr;
    end else begin
        V(s, si) <+ 0.0;
    end

    if (RDSMOD !=2 && RSourceGeo > 0) begin
        I(s, si) <+ white_noise(Nt * MULT_I * gspr, "rs");
    end

    if (RGATEMOD == 3) begin
        I(gm, gi) <+ V(gm, gi) * MULT_I * Gcrg;
    end else begin
        V(gm, gi) <+ 0.0;
    end

    //Self-heating network
    if ((SHMOD != 0) && (RTH0 > 0.0)) begin
        Pdiss = devsign * sigvds * ids * V(di, si);
        if (RDSMOD !=2 && RDrainGeo >0) begin
            Pdiss = Pdiss + V(d, di) * V(d, di) / Rdrain;
        end
        if (RDSMOD !=2 && RSourceGeo >0) begin
            Pdiss = Pdiss + V(s, si) * V(s, si) / Rsource;
        end
        if (TNODEOUT && !$port_connected(t)) begin
            if ($port_connected(b)) begin // last terminal is 'b'
                I(b) <+ delTemp1 * gth + ddt(delTemp1 * cth) - Pdiss;
            end else begin  // 4-terminal mode ('t' is internal)
                Pwr(t) <+ delTemp1 * gth + ddt(delTemp1 * cth) - Pdiss;
            end
        end else begin
            Pwr(t) <+ delTemp1 * gth + ddt(delTemp1 * cth) - Pdiss;
        end
    end else begin
        if (TNODEOUT && !$port_connected(t)) begin
            if ($port_connected(b)) begin // last terminal is 'b'
                V(b) <+ 0.0;//
            end else begin // 4-terminal mode ('t' is internal)
                Temp(t) <+ 0.0;
            end
        end else begin
            Temp(t) <+ 0.0;
        end
    end

    //Body Contact resistance
    RBODYEXT = NRB * RBSH;
    if (((BODYMOD == 0) && (!(TNODEOUT && !$port_connected(t)))) || ($port_connected(b) == 0)) begin
        V(b, bi) <+ 0;
        V(b, bi2) <+ 0;
    end else begin
        if (TNODEOUT && !$port_connected(t)) begin
            V(bi, bi2) <+ 0.0;
        end else begin
            //Linear Body Resistor
            if (BODYMOD == 1) begin
                RBODYINT = FRBODY * RBODY
                    * RHALO / (2.0 * RBODY + RHALO * LEFF)
                    * WEFF / NSEG / NF;
                if (RBODYINT < 1e-3) begin
                    if (RBODYEXT <= 1e-3)
                        T0 = 1.0 / 1e-3;
                    else
                        T0 = 1.0 / RBODYEXT;
                    gbody = T0;
                end else begin
                    gbody = 1.0 / (RBODYINT + RBODYEXT);
                end
            //Non-linear Body resistor
            end else begin
                UB_t = UB_i * pow(TRatio,UBTE_i);
                QB1 = -(QBi + Qbsj + Qbdj) + Qsub;
                Qbody = `P_Q_NIST1998 * NEFF_i * TSI * WEFF *LEFF - QB1;
                T0 = UB_t * Qbody;
                T1 = WEFF * WEFF;
                gbodyINT = NF * T0/T1;
                RBODYINT = 1 / gbodyINT;
                if (RBODYINT < 1e-3) begin
                    if (RBODYEXT <= 1e-3)
                        T0 = 1.0 / 1e-3;
                    else
                        T0 = 1.0 / RBODYEXT;
                    gbody = T0;
                end else begin
                    gbody = 1.0 / (RBODYINT + RBODYEXT);
                end
            end
            if (NBC == 2) begin
                gbody = 2.0 * gbody;
            end
            I(b, bi) <+ V(b, bi) * MULT_I * gbody;
            if (MODAGBCP2 == 1) begin
                if (RBODYAGBCP2 < 1e-3) begin
                    T0 = 1.0 / 1e-3;
                    gbodyagbcp2 = T0;
                end else begin
                    gbodyagbcp2 = 1.0 / RBODYAGBCP2;
                end
                I(b, bi2) <+ V(b, bi2) * MULT_I * gbodyagbcp2;
            end
        end
    end

    // Diode currents and capacitances
    I(bi, si) <+ devsign * MULT_I * Ibs + V(bi, si) * MULT_I * gmin;
    I(bi, di) <+ devsign * MULT_I * Ibd + V(bi, di) * MULT_I * gmin;
    I(bi, si) <+ devsign * ddt(MULT_Q * Qbsj);
    I(bi, di) <+ devsign * ddt(MULT_Q * Qbdj);
    if ( (BODYMOD !=0) && ($port_connected (b) == 1) && (!((TNODEOUT == 1) && ($port_connected(t) == 0))) && (MODAGBCP2 == 1) ) begin
        I(bi2, si) <+ V(bi2, si) * MULT_I * gmin;
        I(bi2, di) <+ V(bi2, di) * MULT_I * gmin;
    end

end
endmodule
