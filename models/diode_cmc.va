//======================================================================================
//======================================================================================
// Filename: diode_cmc.va
//======================================================================================
//
//
//                        Silicon Integration Initiative (Si2)
//                      Compact Model Coalition In-Code Statement
//
//    Software is distributed as is, completely without warranty or service support.  NXP
//    Semiconductors, Hiroshima University, and Silicon Integration Initiative, Inc. (Si2),
//    along with their employees are not liable for the condition or performance of the software.
//
//    NXP Semiconductors, Hiroshima University, and Si2 own the copyright and grant users
//    a perpetual, irrevocable, worldwide, non-exclusive, royalty-free license with respect to the
//    software as set forth below.
//
//    NXP Semiconductors, Hiroshima University, and Si2 hereby disclaim all implied
//    warranties.
//
//    NXP Semiconductors, Hiroshima University, and Si2 grant the users the right to modify,
//    copy, and redistribute the software and documentation, both within the user's organization
//    and externally, subject to the following restrictions
//
//      1. The users agree not to charge for the NXP Semiconductors, Hiroshima University,
//      and Si2 -developed code itself but may charge for additions, extensions, or support.
//
//      2. In any product based on the software, the users agree to acknowledge NXP
//      Semiconductors, Hiroshima University, and Si2 that developed the software.  This
//      acknowledgment shall appear in the product documentation.
//
//      3. Redistributions to others of source code and documentation must retain the copyright
//      notice, disclaimer, and list of conditions.
//
//      4. Redistributions to others in binary form must reproduce the copyright notice,
//      disclaimer, and list of conditions in the documentation and/or other materials provided
//      with the distribution.
//
//                                                     CMC In-Code Statement Revision 1.1 6/9/2016
//
//
//
// The diode_cmc is based on Juncap2 200.3.3 (test) from NXP Semiconductors.
//
// Portions commented as diode_cmc code: additional models since 2009.
//
// Portions commented as diode_cmc recovery and high-injection equations code: recovery model by Hiroshima University.
//
// All other parts are taken from Juncap2 200.3.3. Copyright 2008 NXP Semiconductors, All Rights Reserved.
//======================================================================================
//======================================================================================
//
//

`include "constants.vams"
`include "disciplines.vams"

`include "discipline.h"

// ---- begin `include "DIODE_CMC_SIMKIT_macrodefs.include" ----
//======================================================================================
//======================================================================================
// Filename: DIODE_CMC_SIMKIT_macrodefs.include
//======================================================================================
//
//
//                        Silicon Integration Initiative (Si2)
//                      Compact Model Coalition In-Code Statement
//
//    Software is distributed as is, completely without warranty or service support.  NXP
//    Semiconductors, Hiroshima University, and Silicon Integration Initiative, Inc. (Si2),
//    along with their employees are not liable for the condition or performance of the software.
//
//    NXP Semiconductors, Hiroshima University, and Si2 own the copyright and grant users
//    a perpetual, irrevocable, worldwide, non-exclusive, royalty-free license with respect to the
//    software as set forth below.
//
//    NXP Semiconductors, Hiroshima University, and Si2 hereby disclaim all implied
//    warranties.
//
//    NXP Semiconductors, Hiroshima University, and Si2 grant the users the right to modify,
//    copy, and redistribute the software and documentation, both within the user's organization
//    and externally, subject to the following restrictions
//
//      1. The users agree not to charge for the NXP Semiconductors, Hiroshima University,
//      and Si2 -developed code itself but may charge for additions, extensions, or support.
//
//      2. In any product based on the software, the users agree to acknowledge NXP
//      Semiconductors, Hiroshima University, and Si2 that developed the software.  This
//      acknowledgment shall appear in the product documentation.
//
//      3. Redistributions to others of source code and documentation must retain the copyright
//      notice, disclaimer, and list of conditions.
//
//      4. Redistributions to others in binary form must reproduce the copyright notice,
//      disclaimer, and list of conditions in the documentation and/or other materials provided
//      with the distribution.
//
//                                                     CMC In-Code Statement Revision 1.1 6/9/2016
//
//
//
// The diode_cmc is based on Juncap2 200.3.3 (test) from NXP Semiconductors.
//
// Portions commented as diode_cmc code: additional models since 2009.
//
// All other parts are taken from Juncap2 200.3.3. Copyright 2008 NXP Semiconductors, All Rights Reserved.
//======================================================================================
//
//

//////////////////////////////////////////////////////////////
//
//  General macros and constants for compact va-models
//
//////////////////////////////////////////////////////////////

`define VERS  "0.0"
`define VREV  "0.0"
`define VERSreal  0.0
`define VREVreal  0.0

`define CLIP_LOW(val,min)      ((val)>(min)?(val):(min))
`define CLIP_HIGH(val,max)     ((val)<(max)?(val):(max))
`define CLIP_BOTH(val,min,max) ((val)>(min)?((val)<(max)?(val):(max)):(min))

// Note 1: In this va-code, the `P-macro is defined such that its argument
// is ignored during compilation; in this source code it acts as
// a comment
// Note 2: In this va-code, the "from" keyword in the parameter
// list is not used. Silent clipping is used instead. One could enable
// the Verilog-A range checking by redefining the `from-macro below.
//`define P(txt)
`define AT_MODEL
`define AT_INSTANCE
`define AT_NOISE
`define from(lower,upper)
//    `define from(lower,upper) from[lower:upper]

// Some functions
`define MAX(x,y)              ((x)>(y)?(x):(y))
`define MIN(x,y)              ((x)<(y)?(x):(y))

// Mathematical constants
`define PI                    3.1415926535897931
`define SQRTPI                1.77245385090551603

// Physical constants
`define KELVINCONVERSION      273.15
`define KBOL                  1.3806505E-23
`define QELE                  1.6021918E-19
`define HBAR                  1.05457168E-34
`define MELE                  9.1093826E-31
`define EPSO                  8.8541878176E-12
`define EPSRSI                11.8

// Other constants
`define oneThird              3.3333333333333333e-01
`define twoThirds             6.6666666666666667e-01

// Constants needed in safe exponential function (called "expl")
`define se                    4.6051701859880916e+02
`define se05                  2.3025850929940458e+02
`define ke                    1.0e-200
`define ke05                  1.0e-100
`define keinv                 1.0e200
`define ke05inv               1.0e100

/////////////////////////////////////////////////////////////////////////////
//
//  Macro definitions.
//
//  Note that because variables in macros are not locally scoped,
//  the intermediate variables used in the macros below must be
//  explicitly declared in the main code.
//
/////////////////////////////////////////////////////////////////////////////

//  P3       3rd order polynomial expansion of exp()
`define P3(u) (1.0 + (u) * (1.0 + 0.5 * ((u) * (1.0 + (u) * `oneThird))))

//  expl     exp() with 3rd order polynomial extrapolation
//           for very low values (exp_low), very high
//           values (exp_high), or both (expl), to avoid overflows
//           and underflows and retain C-3 continuity
`define expl(x, res) \
    if (abs(x) < `se05) begin \
        res       = exp(x); \
    end else begin \
        if ((x) < -`se05) begin \
            res       = `ke05 / `P3(-`se05 - (x)); \
        end else begin \
            res       =  `ke05inv * `P3((x) - `se05); \
        end \
    end

`define expl_low(x, res) \
    if ((x) > -`se05) begin \
        res       =  exp(x); \
    end else begin \
        res       = `ke05 / `P3(-`se05 - (x)); \
    end

`define expl_high(x, res) \
    if ((x) < `se05) begin \
        res       = exp(x); \
    end else begin \
        res       =  `ke05inv * `P3((x) - `se05); \
    end

`define swap(a, b) \
    temp = a; \
    a    = b; \
    b    = temp;
// ---- end `include "DIODE_CMC_SIMKIT_macrodefs.include" ----

// ---- begin `include "DIODE_CMC_macrodefs.include" ----
//======================================================================================
//======================================================================================
// Filename: DIODE_CMC_macrodefs.include
//======================================================================================
//======================================================================================
//
//
//                        Silicon Integration Initiative (Si2)
//                      Compact Model Coalition In-Code Statement
//
//    Software is distributed as is, completely without warranty or service support.  NXP
//    Semiconductors, Hiroshima University, and Silicon Integration Initiative, Inc. (Si2),
//    along with their employees are not liable for the condition or performance of the software.
//
//    NXP Semiconductors, Hiroshima University, and Si2 own the copyright and grant users
//    a perpetual, irrevocable, worldwide, non-exclusive, royalty-free license with respect to the
//    software as set forth below.
//
//    NXP Semiconductors, Hiroshima University, and Si2 hereby disclaim all implied
//    warranties.
//
//    NXP Semiconductors, Hiroshima University, and Si2 grant the users the right to modify,
//    copy, and redistribute the software and documentation, both within the user's organization
//    and externally, subject to the following restrictions
//
//      1. The users agree not to charge for the NXP Semiconductors, Hiroshima University,
//      and Si2 -developed code itself but may charge for additions, extensions, or support.
//
//      2. In any product based on the software, the users agree to acknowledge NXP
//      Semiconductors, Hiroshima University, and Si2 that developed the software.  This
//      acknowledgment shall appear in the product documentation.
//
//      3. Redistributions to others of source code and documentation must retain the copyright
//      notice, disclaimer, and list of conditions.
//
//      4. Redistributions to others in binary form must reproduce the copyright notice,
//      disclaimer, and list of conditions in the documentation and/or other materials provided
//      with the distribution.
//
//                                                     CMC In-Code Statement Revision 1.1 6/9/2016
//
//
//
// The diode_cmc is based on Juncap2 200.3.3 (test) from NXP Semiconductors.
//
// Portions commented as diode_cmc code: additional models since 2009.
//
// Portions commented as diode_cmc recovery and high-injection equations code: recovery model by Hiroshima University.
//
// All other parts are taken from Juncap2 200.3.3. Copyright 2008 NXP Semiconductors, All Rights Reserved.
//======================================================================================
//======================================================================================
//
//

///////////////////////////////////////////
//
// Macros and constants used in diode_cmc
//
///////////////////////////////////////////

// Other constants
`define MINTEMP          -250
`define vbilow            0.050
`define a                 2
`define epsch             0.1
`define dvbi              0.050
`define epsav             1E-6
`define vbrmax            1E6
`define vmaxlarge         1E8
`define aerfc             0.29214664
`define twothirds         0.666666666666667

// Clipping values
`define levelnumber        200
`define AB_cliplow         0
`define LS_cliplow         0
`define LG_cliplow         0
`define MULT_cliplow       0
`define TRJ_cliplow        `MINTEMP
`define IMAX_cliplow       1E-12
`define CJORBOT_cliplow    1E-12
`define CJORSTI_cliplow    1E-18
`define CJORGAT_cliplow    1E-18
`define VBIR_cliplow       `vbilow
`define P_cliplow          0.05
`define P_cliphigh         0.95
`define IDSATR_cliplow     0
`define CSRH_cliplow       0
`define XJUN_cliplow       1E-9
`define CTAT_cliplow       0
`define MEFFTAT_cliplow    0.01
`define CBBT_cliplow       0
`define VBR_cliplow        0.1
`define PBR_cliplow        0.1
`define VJUNREF_cliplow    0.5
`define FJUNQ_cliplow      0.0

// Diode_cmc code
`define RS_cliplow         0.0
`define KF_cliplow         0.0
`define AF_cliplow         0.1
`define TT_cliplow         0
`define STVBR_cliplow      0
`define NFA_cliplow        0.1
`define VOLT_cliplow       0.0
`define XTI_cliplow        0.1
`define SCALE_cliplow      0
`define SHRINK_cliplow     0
`define SHRINK_cliphigh    100
// End of Diode_cmc code

/////////////////////////////////////////////////////////////////////////////
//
//  Macro definitions.
//
//  Note that because at present locally scoped variables
//  can only be in named blocks, the intermediate variables
//  used in the macros below must be explicitly declared
//  as variables.
//
/////////////////////////////////////////////////////////////////////////////

// Variable declarations of variables that need to be *local* in juncap-express initialization

`define LocalGlobalVars \
    /* declaration of variables needed in macro "calcerfcexpmtat" */ \
    real ysq, terfc, erfcpos; \
    \
    /* declaration of variables needed in hypfunction 5 */ \
    real h1, h2, h2d, h3, h4, h5; \
    \
    /* declaration of variables calculated outside macro "juncapfunction", voltage-dependent part */ \
    real vj, z, zinv, two_psistar, vjlim, vjsrh, vbbt, vav; \
    \
    /* declaration of variables used within macro "juncapfunction" */ \
    real tmp, id; \
    real isrh, vbi_minus_vjsrh, wsrhstep, dwsrh, wsrh, wdep, asrh; \
    real itat, btat, twoatatoverthreebtat, umaxbeforelimiting, umax, sqrtumax, umaxpoweronepointfive; \
    real wgamma, wtat, ktat, ltat, mtat, xerfc, erfctimesexpmtat, gammamax; \
    real ibbt, Fmaxr; \
    real fbreakdown; \

// Instance parameter dependent initialization

`define JuncapInitInstance \
    /*  Diode_cmc code */ \
    if (idsatbot * AB_i > 0) begin \
        vmaxbot = phitd * ln(IMAX_i / (idsatbot * AB_i) + 1) * NFABOT_i; \
    end else begin \
        vmaxbot = `vmaxlarge; \
    end \
    if (idsatsti * LS_i > 0) begin \
        vmaxsti = phitd * ln(IMAX_i / (idsatsti * LS_i) + 1) * NFASTI_i;  \
    end else begin \
        vmaxsti = `vmaxlarge; \
    end \
    if (idsatgat * LG_i > 0) begin \
        vmaxgat = phitd * ln(IMAX_i / (idsatgat * LG_i) + 1) * NFAGAT_i; \
    end else begin \
        vmaxgat = `vmaxlarge; \
    end \
    VMAX = min(min(vmaxbot, vmaxsti), vmaxgat); \
    /* End of Diode_cmc code */ \
    `expl(VMAX * phitdinv, exp_VMAX_over_phitd) \
    \
    /* determination of minimum value of the relevant built-in voltages */ \
    /* and determination of limiting value of conditioned voltage for BBT calculation */ \
    vbibot2 = vbibot; \
    vbisti2 = vbisti; \
    vbigat2 = vbigat; \
    pbot2 = PBOT_i; \
    psti2 = PSTI_i; \
    pgat2 = PGAT_i; \
    vbibot2r = VBIRBOT_i; \
    vbisti2r = VBIRSTI_i; \
    vbigat2r = VBIRGAT_i; \
    if (AB_i == 0) begin \
        vbibot2  = vbisti + vbigat; \
        pbot2    = 0.9 * min(PSTI_i, PGAT_i); \
        vbibot2r = VBIRSTI_i + VBIRGAT_i; \
    end \
    if (LS_i == 0) begin \
        vbisti2  = vbibot + vbigat; \
        psti2    = 0.9 * min(PBOT_i, PGAT_i); \
        vbisti2r = VBIRBOT_i + VBIRGAT_i; \
    end \
    if (LG_i == 0) begin \
        vbigat2  = vbibot + vbisti; \
        pgat2    = 0.9 * min(PBOT_i, PSTI_i); \
        vbigat2r = VBIRBOT_i + VBIRSTI_i; \
    end \
    vbimin  = min(min(vbibot2, vbisti2), vbigat2); \
    vch     = vbimin * `epsch; \
    pmax    = max(max(pbot2, psti2), pgat2); \
    vfmin   = vbimin * (1 - (pow(`a, (-1.0 / (pmax))))); \
    vbbtlim = min(min(vbibot2r, vbisti2r), vbigat2r) - `dvbi;

//  Diode_cmc code
//  Resistance definition
//  If resistance < minr, node collapse will happen,
//  AND rnode = 0
`define Junresistor \
    conducts=0.0; \
    if (AB_i * resbot > 0) begin \
        conducts = AB_i / resbot ; \
    end \
    if (LS_i * ressti > 0) begin \
        conducts = LS_i / ressti+ conducts; \
    end \
    if (LG_i * resgat > 0) begin \
        conducts = LG_i / resgat+ conducts; \
    end \
    if (conducts > 0.0) begin \
        restotal = 1.0/conducts + rescom; \
    end else begin \
        restotal = rescom; \
    end
//    if (((AB_i > 0 && resbot/AB_i < minr) || (LS_i >0 && ressti/LS_i < minr) || (LG_i >0 && resgat/LG_i < minr)) && rescom < minr) begin \
//        rnode = 0 ; \
//    end
// End of Diode_cmc code

// Special power-functions

`define mypower(x,power,result) \
    if (power == 0.5) begin \
        result = sqrt(x); \
    end else begin \
        result = pow(x, power); \
    end

`define mypower2(x,power,result) \
    if (power == -1) begin \
        result = 1 / (x); \
    end else begin \
        result = pow(x, power); \
    end

`define mypower3(x,power,result) \
    if (power == 4) begin \
        result = (x) * (x) * (x) * (x); \
    end else begin \
        result = pow(x, power); \
    end

// Smoothing functions

`define hypfunction2(x,x0,eps,hyp2) \
    hyp2 = 0.5 * ((x) + (x0) - sqrt(((x) - (x0)) * ((x) - (x0)) + 4 * (eps) * (eps)));

`define hypfunction5(x,x0,eps,hyp5) \
    h1   = 4.0 * (eps) * (eps); \
    h2   = (eps) / (x0); \
    h2d  = (x) + (eps) * h2; \
    h3   = (x0) + h2d; \
    h4   = (x0) - h2d; \
    h5   = sqrt(h4 * h4 + h1); \
    hyp5 = 2.0 * ((x) * (x0) / (h3 + h5));

// A special function used to calculate TAT-currents,
// including an approximation of the erfc-function

`define calcerfcexpmtat(y,m,result) \
    ysq = y * y; \
    if (y > 0) begin \
        terfc = 1 / (1 + perfc * y); \
    end else begin \
        terfc = 1 / (1 - perfc * y); \
    end \
    `expl_low(-ysq + m, tmp) \
    erfcpos = (`aerfc * terfc + berfc * (terfc * terfc) + cerfc * (terfc * terfc * terfc)) * tmp; \
    if (y > 0) begin \
        result = erfcpos; \
    end else begin \
        `expl_low(m, tmp) \
        result = 2 * tmp - erfcpos; \
    end

//Diode_cmc code
//Juncap parameter check
`define Juncapparametercheck \
    if (AB_i > ABMAX_i && ABMAX_i > 1e-18) begin \
        $strobe("WARNING: Diode area is larger than maximum allowed value \n"); \
    end \
    if (AB_i < ABMIN_i ) begin \
        $strobe("WARNING: Diode area is less than minimum allowed value \n"); \
    end \
    if (LS_i > LSMAX_i && LSMAX_i > 1e-12) begin \
        $strobe("WARNING: Diode STI-edge perimeter is larger than maximum allowed value \n"); \
    end \
    if (LS_i < LSMIN_i ) begin \
        $strobe("WARNING: Diode STI-edge perimeter is less than minimum allowed value \n"); \
    end \
    if (LG_i > LGMAX_i && LGMAX_i > 1e-12) begin \
        $strobe("WARNING: Diode gate-edge perimeter is larger than maximum allowed value \n"); \
    end \
    if (LG_i < LGMIN_i ) begin \
        $strobe("WARNING: Diode gate-edge perimeter is less than minimum allowed value \n"); \
    end \
    if (tkd > (TEMPMAX_i + `KELVINCONVERSION)) begin \
        $strobe("WARNING: Junction temperature is higher than maximum allowed value \n"); \
    end \
    if (tkd < (TEMPMIN_i + `KELVINCONVERSION)) begin \
        $strobe("WARNING: Junction temperature is lower than minimum allowed value \n"); \
    end

`define Juncapcheckop(Vtotal) \
    if (Vtotal > VFMAX_i && VFMAX_i > 1e-12) begin \
        $strobe("WARNING: Diode forward bias voltage is larger than maximum allowed value \n"); \
    end \
    if (Vtotal < (-1.0 * VRMAX_i) && VRMAX_i > 1e-12) begin \
        $strobe("WARNING: Diode reverse bias voltage is less than maximum allowed value \n"); \
    end

//End of Diode_cmc code

// This is the main function of the JUNCAP2-model. It returns the current and charge
// for a single diode

`define juncapfunction(VAK,idmult,qpref,qpref2,vbiinv,one_minus_P,idsat,CSRH,CTAT,vbi,wdepnulr,VBIRinv,P,ftd,btatpart,atat,one_over_one_minus_P,CBBT,VBIR,wdepnulrinv,fbbt,VBR,VBRinv,PBR,fstop,slope,Ijprime,Qjprime,Ijnon,swbv) \
    `mypower((1 - vj * vbiinv), one_minus_P, tmp) \
    Qjprime = qpref * (1 - tmp) + qpref2 * (VAK - vj); \
    id    = idsat * idmult; \
    if ((CSRH == 0) && (CTAT == 0)) begin \
        vbi_minus_vjsrh = 0; \
        wsrh = 0; \
        wdep = 0; \
        asrh = 0; \
        isrh = 0; \
    end else begin \
        vbi_minus_vjsrh = vbi-vjsrh; \
        wsrhstep = 1 - sqrt(1 - two_psistar / vbi_minus_vjsrh); \
        if (P == 0.5) begin \
            dwsrh = 0; \
        end else begin \
            dwsrh = ((wsrhstep * wsrhstep * ln(wsrhstep) / (1 - wsrhstep)) + wsrhstep) * (1 - 2 * P); \
        end \
        wsrh  = wsrhstep + dwsrh; \
        `mypower(vbi_minus_vjsrh * VBIRinv, P, tmp) \
        wdep  = wdepnulr * tmp; \
        asrh  = ftd * ((zinv - 1) * wdep); \
        isrh  = CSRH * (asrh * wsrh); \
    end \
    if (CTAT == 0) begin \
        itat = 0; \
    end else begin \
        btat  = btatpart * ((wdep * one_minus_P) / vbi_minus_vjsrh); \
        twoatatoverthreebtat = (`twothirds * atat) / btat; \
        umaxbeforelimiting = twoatatoverthreebtat * twoatatoverthreebtat; \
        umax  = sqrt(umaxbeforelimiting * umaxbeforelimiting / (umaxbeforelimiting * umaxbeforelimiting + 1)); \
        sqrtumax = sqrt(abs(umax)); \
        umaxpoweronepointfive = umax * sqrtumax; \
        `mypower2((1 + btat * umaxpoweronepointfive), (-P * one_over_one_minus_P), wgamma) \
        wtat  = wsrh * wgamma / (wsrh + wgamma); \
        ktat  = sqrt(0.375 * (btat / sqrtumax)); \
        ltat  = 2 * (twoatatoverthreebtat * sqrtumax) - umax; \
        mtat  = atat * twoatatoverthreebtat * sqrtumax - atat * umax + 0.5 * (btat * umaxpoweronepointfive); \
        xerfc = (ltat - 1) * ktat; \
        `calcerfcexpmtat(xerfc, mtat, erfctimesexpmtat) \
        gammamax = `SQRTPI * 0.5 * (atat * erfctimesexpmtat  / ktat); \
        itat  = CTAT * (asrh * gammamax * wtat); \
    end \
    if (CBBT == 0) begin \
        ibbt = 0; \
    end else begin \
        `mypower(((VBIR - vbbt) * VBIRinv), P, tmp) \
        Fmaxr = one_over_one_minus_P * ((VBIR - vbbt) * wdepnulrinv / tmp); \
        `expl(-fbbt / Fmaxr, tmp) \
        ibbt  = CBBT * (VAK * Fmaxr * Fmaxr * tmp); \
    end \
    if ((VBR > `vbrmax)||(swbv == 0)) begin \
        fbreakdown = 1; \
    end else begin \
        if (vav > -alphaav * VBR) begin \
            `mypower3(abs(vav * VBRinv), PBR, tmp) \
            fbreakdown = 1 / (1 - tmp); \
        end else begin \
            fbreakdown = fstop + (vav + alphaav * VBR) * slope; \
        end \
    end \
    Ijprime = (id + isrh + itat + ibbt) * fbreakdown; \
    Ijnon = (isrh + itat + ibbt) * fbreakdown;

//Diode_cmc recovery and high-injection equations code

//--- smoothUpper ---//
`define Fn_SU( y , x , xmax , delta ) begin \
    TMF1 = ( xmax ) - ( x ) - ( delta ) ; \
    TMF2 = 4.0 * ( xmax ) * ( delta) ; \
    TMF2 = TMF2 > 0.0 ?  TMF2 : - ( TMF2 ) ; \
    TMF2 = sqrt ( TMF1 * TMF1 + TMF2 ) ; \
    y = ( xmax ) - 0.5 * ( TMF1 + TMF2 ) ; \
end
`define Fn_SU_dx( y , x , xmax , delta , dx ) begin \
    TMF1 = ( xmax ) - ( x ) - ( delta ) ; \
    TMF2 = 4.0 * ( xmax ) * ( delta) ; \
    TMF2 = TMF2 > 0.0 ?  TMF2 : - ( TMF2 ) ; \
    TMF2 = sqrt ( TMF1 * TMF1 + TMF2 ) ; \
    dx = 0.5 * ( 1.0 + TMF1 / TMF2 ) ; \
    y = ( xmax ) - 0.5 * ( TMF1 + TMF2 ) ; \
end

//--- smoothLower ---//
`define Fn_SL( y , x , xmin , delta ) begin \
    TMF1 = ( x ) - ( xmin ) - ( delta ) ; \
    TMF2 = 4.0 * ( xmin ) * ( delta ) ; \
    TMF2 = TMF2 > 0.0 ?  TMF2 : - ( TMF2 ) ; \
    TMF2 = sqrt ( TMF1 * TMF1 + TMF2 ) ; \
    y = ( xmin ) + 0.5 * ( TMF1 + TMF2 ) ; \
end
`define Fn_SL_dx( y , x , xmin , delta , dx ) begin \
    TMF1 = ( x ) - ( xmin ) - ( delta ) ; \
    TMF2 = 4.0 * ( xmin ) * ( delta ) ; \
    TMF2 = TMF2 > 0.0 ?  TMF2 : - ( TMF2 ) ; \
    TMF2 = sqrt ( TMF1 * TMF1 + TMF2 ) ; \
    dx = 0.5 * ( 1.0 + TMF1 / TMF2 ) ; \
    y = ( xmin ) + 0.5 * ( TMF1 + TMF2 ) ; \
end

//--- smoothZero ---//
`define Fn_SZ( y , x , delta ) begin \
    TMF2 = sqrt ( ( x ) *  ( x ) + 4.0 * ( delta ) * ( delta) ) ; \
    y = 0.5 * ( ( x ) + TMF2 ) ; \
    if ( y < 0.0 ) begin y=0.0; end \
end

`define C_Nin0       (1.45e+16)                 // Intrinsic carrier density at 300K (m^-3)
`define C_MUEP       (500)                      // Hole mobility (cm^2/V/sec)
`define C_MUEN       (1450)                     // Electron mob. (cm^2/V/sec)
`define C_CONC       (1.0e6)                    // [cm-3] -> [m-3]
`define C_cm2m_p2    (1.0e-4)                   // [cm2] -> [m2]
`define C_NJDLT      (1.0e-2)                   // Delta for smoothing of nj
`define C_PUNCH      (1.0e-7)                   // Delta for punch-through effect of depletion (m)

`define C_MUETMP     (1.5)                      // temperature dependence of phonon scattering (-)

`define QC_scale     (1.0e-12)                  // current scaling
`define QV_scale     (1.0)                      // voltage scaling
`define Q_scale      (1.0e-23/q_pex0)           // charge scaling

`define WC_scale     (1.0e-13)                  // current scaling
`define WV_scale     (1.0)                      // voltage scaling
`define W_scale      (1.0/W_depA0)              // width scaling
//End of Diode_cmc recovery and high-injection equations code

`define nja( voltage, njl, nh, ndi, nja1, nja0, vha ) begin \
    /* Minority Carrier Density: */ \
    pnn0 = Nin * Nin / ndi; \
    /* High-Injection Threshold Voltages: */ \
    vha = (njl / phitdinv) * ln( ndi / pnn0 ); \
    /* High-Injection Coefficient for the P+/N- Junction: */ \
    if (njl < nh) begin \
        nja10 = njdv * (voltage - vha) + njl; \
        nja0 = njl- njdv * vha; \
        /* nj_A0 = njdv * (VAK - vha) + (njh + NJL)/2; //improved code but results will change */ \
        `Fn_SU( nja11, nja10, nh, `C_NJDLT ) \
        `Fn_SL( nja1,  nja11, njl, `C_NJDLT ) \
        `Fn_SU( nja0,  nja0, nh, `C_NJDLT ) \
        `Fn_SL( nja0,  nja0, njl, `C_NJDLT ) \
    end else begin  \
        nja0 = njl; \
        nja1 = njl; \
    end \
end

`define nja_dx( voltage, njl, nh, ndi, nja1, nja0, vha, dnja1_dv ) begin \
    /* Minority Carrier Density: */ \
    pnn0 = Nin * Nin / ndi; \
    /* High-Injection Threshold Voltages: */ \
    vha = (njl / phitdinv) * ln( ndi / pnn0 ); \
    /* High-Injection Coefficient for the P+/N- Junction: */ \
    if (njl < nh) begin \
        nja10 = njdv * (voltage - vha) + njl; \
        nja0 = njl- njdv * vha; \
        /* nj_A0 = njdv * (VAK - vha) + (njh + NJL)/2; //improved code but results will change */ \
        `Fn_SU_dx( nja11, nja10, nh, `C_NJDLT, dFn_SU ) \
        `Fn_SL_dx( nja1,  nja11, njl, `C_NJDLT, dFn_SL ) \
        `Fn_SU( nja0,  nja0, nh, `C_NJDLT ) \
        `Fn_SL( nja0,  nja0, njl, `C_NJDLT ) \
        dnja1_dv = njdv * dFn_SU * dFn_SL; \
        \
    end else begin  \
        nja0 = njl; \
        nja1 = njl; \
        dnja1_dv = 0.0; \
    end \
end

// The following code is written as a macro because the naming of the instance parameters is
// different for JUNCAP2 stand-alone and JUNCAP2-in-PSP: AB, LS, LG for JUNCAP2 stand-alone,
// ABSOURCE, LSSOURCE, LGSOURCE for source junction in PSP and ABDRAIN, LSDRAIN, LGDRAIN for
// drain junction in PSP
`define juncapcommon(V) \
    if ( !( ((AB_i) == 0) && ((LS_i) == 0) && ((LG_i) == 0) ) ) begin \
        `hypfunction5(V, vfmin, vch, vj) \
        /* Diode_cmc code */ \
        if (V < VMAX) begin \
            `expl(0.5 * (V * phitdinv), zinv) \
            /*  BOT scaling */  \
            `nja(V, NFABOT_i, njh, NDIBOT_i, nj1, nj0, vha1) \
            `expl((phitdinv * ( V / nj1 + vha1 * (nj1-nj0) / (nj0*njh))), idmultbot) \
            /*  STI scaling */  \
            `nja(V, NFASTI_i, njh, NDISTI_i, nj1, nj0, vha1) \
            `expl((phitdinv * ( V / nj1 + vha1 * (nj1-nj0) / (nj0*njh))), idmultsti) \
            /*  GAT scaling */  \
            `nja(V, NFAGAT_i, njh, NDIGAT_i, nj1, nj0, vha1) \
            `expl((phitdinv * ( V / nj1 + vha1 * (nj1-nj0) / (nj0*njh))), idmultgat) \
        end else begin \
            zinv = sqrt((1 + (V - VMAX) * phitdinv) * exp_VMAX_over_phitd); \
            /*  BOT scaling */  \
            `nja_dx(VMAX, NFABOT_i, njh, NDIBOT_i, nj1, nj0, vha1, dnj1_dV) \
            `expl((phitdinv * ( VMAX / nj1 + vha1 * (nj1-nj0) / (nj0*njh))), exp_VMAX_over_phitd_bot) \
            dVMAX_over_phitd_dV = phitdinv * ( (nj1 - VMAX * dnj1_dV) / (nj1*nj1) + vha1 * dnj1_dV / (nj0*njh) ); \
            idmultbot = (1 + (V - VMAX) * dVMAX_over_phitd_dV) * exp_VMAX_over_phitd_bot; \
            /*  STI scaling */  \
            `nja_dx(VMAX, NFASTI_i, njh, NDISTI_i, nj1, nj0, vha1, dnj1_dV) \
            `expl((phitdinv * ( VMAX / nj1 + vha1 * (nj1-nj0) / (nj0*njh))), exp_VMAX_over_phitd_sti) \
            dVMAX_over_phitd_dV = phitdinv * ( (nj1 - VMAX * dnj1_dV) / (nj1*nj1) + vha1 * dnj1_dV / (nj0*njh) ); \
            idmultsti = (1 + (V - VMAX) * dVMAX_over_phitd_dV) * exp_VMAX_over_phitd_sti; \
            /*  GAT scaling */  \
            `nja_dx(VMAX, NFAGAT_i, njh, NDIGAT_i, nj1, nj0, vha1, dnj1_dV) \
            `expl((phitdinv * ( VMAX / nj1 + vha1 * (nj1-nj0) / (nj0*njh))), exp_VMAX_over_phitd_gat) \
            dVMAX_over_phitd_dV = phitdinv * ( (nj1 - VMAX * dnj1_dV) / (nj1*nj1) + vha1 * dnj1_dV / (nj0*njh) ); \
            idmultgat = (1 + (V - VMAX) * dVMAX_over_phitd_dV) * exp_VMAX_over_phitd_gat; \
        end \
        idmultbot = idmultbot - 1.0 ; \
        idmultsti = idmultsti - 1.0 ; \
        idmultgat = idmultgat - 1.0 ; \
        /* End of Diode_cmc code */ \
        z      = 1 / zinv; \
        if (V > 0) begin \
            two_psistar = 2.0 * (phitd * ln(2.0 + z + sqrt((z + 1.0) * (z + 3.0)))); \
        end else begin \
            two_psistar = -V + 2.0 * (phitd * ln(2 * zinv + 1 + sqrt((1 + zinv) * (1 + 3 * zinv)))); \
        end \
        vjlim = vbimin - two_psistar; \
        `hypfunction2(V, vjlim, phitd, vjsrh) \
        `hypfunction2(V, vbbtlim, phitr, vbbt) \
        `hypfunction2(V, 0, `epsav, vav) \
    end else begin \
        idmultbot   = 0; \
        idmultsti   = 0; \
        idmultgat   = 0; \
        two_psistar = 0; \
        vj    = 0; \
        zinv  = 0; \
        vjsrh = 0; \
        vbbt  = 0; \
        vav   = 0; \
    end \
    if ((AB_i) == 0) begin \
        ijunbot = 0; \
        ijnonbot = 0; \
        qjunbot = 0; \
    end else begin \
        `juncapfunction(V, idmultbot, qprefbot, qpref2bot, vbiinvbot, one_minus_PBOT, idsatbot, CSRHBOT_i, CTATBOT_i, vbibot, wdepnulrbot, VBIRBOTinv, PBOT_i, ftdbot, btatpartbot, atatbot, one_over_one_minus_PBOT, CBBTBOT_i, VBIRBOT_i, wdepnulrinvbot, fbbtbot, VBRBOT_i, VBRinvbot, PBRBOT_i, fstopbot, slopebot, ijunbot, qjunbot, ijnonbot, swbv) \
    end \
    if ((LS_i) == 0) begin \
        ijunsti = 0; \
        ijnonsti = 0; \
        qjunsti = 0; \
    end else begin \
        `juncapfunction(V, idmultsti, qprefsti, qpref2sti, vbiinvsti, one_minus_PSTI, idsatsti, CSRHSTI_i, CTATSTI_i, vbisti, wdepnulrsti, VBIRSTIinv, PSTI_i, ftdsti, btatpartsti, atatsti, one_over_one_minus_PSTI, CBBTSTI_i, VBIRSTI_i, wdepnulrinvsti, fbbtsti, VBRSTI_i, VBRinvsti, PBRSTI_i, fstopsti, slopesti, ijunsti, qjunsti, ijnonsti, swbv) \
    end \
    if ((LG_i) == 0) begin \
        ijungat = 0; \
        ijnongat = 0; \
        qjungat = 0; \
    end else begin \
        `juncapfunction(V, idmultgat, qprefgat, qpref2gat, vbiinvgat, one_minus_PGAT, idsatgat, CSRHGAT_i, CTATGAT_i, vbigat, wdepnulrgat, VBIRGATinv, PGAT_i, ftdgat, btatpartgat, atatgat, one_over_one_minus_PGAT, CBBTGAT_i, VBIRGAT_i, wdepnulrinvgat, fbbtgat, VBRGAT_i, VBRinvgat, PBRGAT_i, fstopgat, slopegat, ijungat, qjungat, ijnongat, swbv) \
    end

//============================================================================================================
//  JUNCAP-express
//
//  The macros below are used in the express-version of JUNCAP2
//============================================================================================================

`define relerr 0.001
`define abserr 1.0e-6

`define P1(x) ((x) + 1)

`define expll(x, xlow, expxlow, xhigh, expxhigh) \
    ((x) < (xlow)) ? (expxlow) / `P1((xlow) - (x)) : (((x) > (xhigh)) ? (expxhigh) * `P1((x) - (xhigh)) : exp(x))

// The last warning message in this macro could be put out by simulator on every time/voltage step if JUNCAP
// Express is turned on. User can comment it out to avoid excessive messages.

`define ExpressCodeValidation \
    if (SWJUNEXP_i > 0.9) begin \
        if ((abs(NFABOT_i -NFAGAT_i) > `abserr && AB_i > 0 && LG_i >0) || (abs(NFABOT_i - NFASTI_i) > `abserr && AB_i >0 && LS_i >0) ||(abs(NFAGAT_i - NFASTI_i) > `abserr && LG_i >0 && LS_i >0) ) begin \
            $strobe("WARNING: The ideality factors are not the same. JUNCAP Express will not be used \n"); \
            $strobe("WARNING: The full diode_cmc is executed. \n"); \
            SWJUNEXP_i = 0; \
        end else begin \
            if (AB_i >0) begin \
                MFOR1=NFABOT_i; \
            end \
            if (LG_i >0) begin \
                MFOR1=NFAGAT_i; \
            end \
            if (LS_i >0) begin \
                MFOR1=NFASTI_i; \
            end \
            $strobe("WARNING: JUNCAP Express will not simulate breakdown behavior of diode. \n"); \
        end \
    end

// The "JuncapExpressInit"-macro below is split into four parts, as some verilog-A compilers cannot handle
// macros beyond a certain size. Moreover, it is useful to limit the list of input and output variables.
// note that the Part 1 in juncap2 is broken into two parts for the exact same reason.

// Part 1
`define JuncapExpressInit1 \
    FRACNA = 0.4; \
    FRACNB = 0.65; \
    FRACI = 0.8; \
    /* Sample voltages */ \
    V1 = -FRACNA * VJUNREF_i; \
    V2 = -FRACNB * VJUNREF_i; \
    V3 = -FRACI * VJUNREF_i; \
    V4 = 0.1; \
    V5 = 0.2; \
    /* evaluate full JUNCAP-model at five voltages */ \
    `juncapcommon(V1) \
    I1 = AB_i * ijunbot + LS_i * ijunsti + LG_i * ijungat; \
    `juncapcommon(V2) \
    I2 = AB_i * ijunbot + LS_i * ijunsti + LG_i * ijungat;

//Diode_cmc code
`define JuncapExpressInit12 \
    `juncapcommon(V3) \
    I3 = AB_i * ijunbot + LS_i * ijunsti + LG_i * ijungat;
//End of Diode_cmc code

// Part 2
`define JuncapExpressInit2 \
    /* forward currents */ \
    `juncapcommon(V4) \
    I4 = AB_i * ijunbot + LS_i * ijunsti + LG_i * ijungat; \
    `juncapcommon(V5) \
    I5 = AB_i * ijunbot + LS_i * ijunsti + LG_i * ijungat;

// Part 3
`define JuncapExpressInit3 \
    /* compute internal parameters from these five (I,V)-values */ \
    ISATFOR1   = isattotal; \
    I4_cor     = I4 - ISATFOR1 * (exp(V4 * phitdinv * MFOR1) - 1.0); \
    I5_cor     = I5 - ISATFOR1 * (exp(V5 * phitdinv * MFOR1) - 1.0); \
    if ( !( ((AB_i) == 0) && ((LS_i) == 0) && ((LG_i) == 0) ) ) begin \
        if ((I4 > 0) && (I5 > 0)) begin \
            if ((((I4_cor / I4) > `relerr) || ((I5_cor / I5) > `relerr)) && (I4_cor > 0) && (I5_cor > 0)) begin \
                alphaje   = I4_cor / I5_cor; \
                MFOR2    = phitd * ln(alphaje) / (V4 - V5); \
                ISATFOR2 =  I4_cor / (exp(V4 * phitdinv * MFOR2) - 1); \
            end \
        end \
        I1_cor    = I1 - ISATFOR1 * (exp(V1 * phitdinv * MFOR1) - 1.0) - ISATFOR2 * (exp(V1 * phitdinv * MFOR2) - 1.0); \
        I2_cor    = I2 - ISATFOR1 * (exp(V2 * phitdinv * MFOR1) - 1.0) - ISATFOR2 * (exp(V2 * phitdinv * MFOR2) - 1.0); \
        I3_cor    = I3 - ISATFOR1 * (exp(V3 * phitdinv * MFOR1) - 1.0) - ISATFOR2 * (exp(V3 * phitdinv * MFOR2) - 1.0); \
        if ((I1 < 0) && (I2 < 0) && (I3 < 0)) begin \
            if ((((I1_cor / I1) > `relerr) || ((I2_cor / I2) > `relerr) || ((I3_cor / I3) > `relerr)) \
                && (I1_cor < 0) && (I2_cor < 0) && (I3_cor < 0)) begin \
                alphaje   = I1_cor / I2_cor; \
                m0_rev    = -phitd * ln(alphaje) / (V1 - V2); /* zeroth order approximation */ \
                tt0       = V2 / (V2 - V1); \
                tt1       = phitd * (alphaje - 1) * (pow(alphaje, tt0) - 1); \
                tt0       = V1 / (V1 - V2); \
                tt2       = pow(alphaje, tt0) * (V2 - V1) + alphaje * V1 - V2; \
                mcor_rev  = tt1 / tt2; /* first order Newton correction */ \
                MREV     = m0_rev + mcor_rev; \
                if (abs(V3 * phitdinv * MREV) < 1e-6) begin \
                    /* Taylor approximation needed */ \
                    /* Note: ISATREV and MREV have different meaning in this situation!! */ \
                    m0flag = 1.0; \
                    ISATREV = I3_cor * (1 / V3 + 0.5 * phitdinv * MREV); \
                    MREV = -0.5 * I3_cor * MREV * phitdinv / V3; \
                end else begin \
                    m0flag = 0.0; \
                    ISATREV  = -I3_cor / (exp(-V3 * phitdinv * MREV) - 1); \
                end \
            end \
        end \
    end

// Part 4
`define JuncapExpressInit4 \
    /* charge model initialization */ \
    zfrac  = FJUNQ_i * (AB_i * cjobot + LS_i * cjosti + LG_i * cjogat); \
    if ((AB_i * cjobot) <= zfrac) begin \
        zflagbot = 0.0; \
    end \
    if ((LS_i * cjosti) <= zfrac) begin \
        zflagsti = 0.0; \
    end \
    if ((LG_i * cjogat) <= zfrac) begin \
        zflaggat = 0.0; \
    end

// Part 5
`define JuncapExpressInit5 \
    /* calculate limits beyond which exponentials are linearly extrapolated */ \
    if ( !( ((AB_i) == 0) && ((LS_i) == 0) && ((LG_i) == 0) ) ) begin \
        xhighf1    = ln(0.5 * IMAX_i / (ISATFOR1 + 1e-21)); \
        xhighf2    = ln(0.5 * IMAX_i / (ISATFOR2 + 1e-21)); \
        xhighr     = ln(0.5 * IMAX_i / (abs(ISATREV) + 1e-21)); \
    end \
    xhighf1    = min(xhighf1, `se05); \
    expxhf1    = exp(xhighf1); \
    xhighf2    = min(xhighf2, `se05); \
    expxhf2    = exp(xhighf2); \
    xhighr     = min(xhighr, `se05); \
    expxhr     = exp(xhighr);

`define JuncapExpressCurrent(V) \
    tm0 = V * phitdinv * MFOR1; \
    tm1 = `expll(tm0, -`se05, `ke05, xhighf1, expxhf1); \
    ijunfor1 = ISATFOR1 * (tm1 - 1.0); \
    tm0 = V * phitdinv * MFOR2; \
    tm1 = `expll(tm0, -`se05, `ke05, xhighf2, expxhf2); \
    ijunfor2 = ISATFOR2 * (tm1 - 1.0); \
    ijunrev = 0.0; \
    if (m0flag > 0) begin \
        ijunrev = V * (ISATREV + V * MREV); \
    end else begin \
        tm0 = -V * phitdinv * MREV; \
        tm1 = `expll(tm0, -`se05, `ke05, xhighr, expxhr); \
        ijunrev  = -ISATREV * (tm1 - 1.0); \
    end \
    ijun =  ijunfor1 + ijunfor2 + ijunrev; \
    ijnon = ijunfor2 + ijunrev;

`define JuncapExpressCharge(V) \
    `hypfunction5(V, vfmin, vch, vjv) \
    if (zflagbot > 0.5) begin \
        `mypower((1 - vjv * vbiinvbot), one_minus_PBOT, tmpv) \
        qjunbot = qprefbot * (1 - tmpv) + qpref2bot * (V - vjv); \
    end else begin \
        qjunbot = 0; \
    end \
    if (zflagsti > 0.5) begin \
        `mypower((1 - vjv * vbiinvsti), one_minus_PSTI, tmpv) \
        qjunsti = qprefsti * (1 - tmpv) + qpref2sti * (V - vjv); \
    end else begin \
        qjunsti = 0; \
    end \
    if (zflaggat > 0.5) begin \
        `mypower((1 - vjv * vbiinvgat), one_minus_PGAT, tmpv) \
        qjungat = qprefgat * (1 - tmpv) + qpref2gat * (V - vjv); \
    end else begin \
        qjungat = 0; \
    end

//  Parameter definition macros: "des" description argument is intended to
//  be a short description, the "inf" information argument is intended to be
//  a detailed description (e.g. for display as part of on-line help).
//
//  MPR      model    parameter real
//  MPI      model    parameter integer
//  IPR      instance parameter real
//  IPI      instance parameter integer
//  OPP      operating point parameter, includes units and description for printing
//  OPM      operating point parameter, scales with $mfactor
//  OPD      operating point parameter, scales with 1/$mfactor
//
//  Instance parameters have the attribute *type="instance"* and note that
//  compilers treat these as both instance and model parameters, with a
//  specified instance value taking precedence over a specified model card value.
//
//  There are some issues with passing range directives with some compilers,
//  so for each parameter declaration there are multiple versions:
//  cc       closed lower bound, closed upper bound
//  co       closed lower bound, open   upper bound
//  cz       closed lower bound of zero (no upper bound)
//  oc       open   lower bound, closed upper bound
//  oo       open   lower bound, open   upper bound
//  oz       open   lower bound of zero (no upper bound)
//  nb       no bounds
//  sw       switch (integer only, values  0=false  and >0=true)
//  ty       switch (integer only, values -1=n-type and +1=p-type)
//

`define ALIAS(alias,paramName) aliasparam alias = paramName;
`define OPP(nam,uni,des)               (*units=uni,                             desc=des*)           real    nam;
`define OPM(nam,uni,des)               (*units=uni, multiplicity="multiply",    desc=des*)           real    nam;
`define OPD(nam,uni,des)               (*units=uni, multiplicity="divide",      desc=des*)           real    nam;
`define MPRcc(nam,def,uni,lwr,upr,des) (*units=uni                            , desc=des*) parameter real    nam=def from[lwr:upr];
`define MPRco(nam,def,uni,lwr,upr,des) (*units=uni                            , desc=des*) parameter real    nam=def from[lwr:upr);
`define MPRcz(nam,def,uni,        des) (*units=uni                            , desc=des*) parameter real    nam=def from[  0:inf);
`define MPRoc(nam,def,uni,lwr,upr,des) (*units=uni                            , desc=des*) parameter real    nam=def from(lwr:upr];
`define MPRoo(nam,def,uni,lwr,upr,des) (*units=uni                            , desc=des*) parameter real    nam=def from(lwr:upr);
`define MPRoz(nam,def,uni,        des) (*units=uni                            , desc=des*) parameter real    nam=def from(  0:inf);
`define MPRnb(nam,def,uni,        des) (*units=uni                            , desc=des*) parameter real    nam=def;
`define MPIcc(nam,def,uni,lwr,upr,des) (*units=uni                            , desc=des*) parameter integer nam=def from[lwr:upr];
`define MPIco(nam,def,uni,lwr,upr,des) (*units=uni                            , desc=des*) parameter integer nam=def from[lwr:upr);
`define MPIcz(nam,def,uni,        des) (*units=uni                            , desc=des*) parameter integer nam=def from[  0:inf);
`define MPIoc(nam,def,uni,lwr,upr,des) (*units=uni                            , desc=des*) parameter integer nam=def from(lwr:upr];
`define MPIoo(nam,def,uni,lwr,upr,des) (*units=uni                            , desc=des*) parameter integer nam=def from(lwr:upr);
`define MPIoz(nam,def,uni,        des) (*units=uni                            , desc=des*) parameter integer nam=def from(  0:inf);
`define MPInb(nam,def,uni,        des) (*units=uni                            , desc=des*) parameter integer nam=def;
`define MPIsw(nam,def,uni,        des) (*units=uni                            , desc=des*) parameter integer nam=def from[  0:inf);
`define MPIty(nam,def,uni,        des) (*units=uni                            , desc=des*) parameter integer nam=def from[ -1:  1] exclude 0;
`define IPRcc(nam,def,uni,lwr,upr,des) (*units=uni, type="instance",            desc=des*) parameter real    nam=def from[lwr:upr];
`define IPRco(nam,def,uni,lwr,upr,des) (*units=uni, type="instance",            desc=des*) parameter real    nam=def from[lwr:upr);
`define IPRcz(nam,def,uni,        des) (*units=uni, type="instance",            desc=des*) parameter real    nam=def from[  0:inf);
`define IPRoc(nam,def,uni,lwr,upr,des) (*units=uni, type="instance",            desc=des*) parameter real    nam=def from(lwr:upr];
`define IPRoo(nam,def,uni,lwr,upr,des) (*units=uni, type="instance",            desc=des*) parameter real    nam=def from(lwr:upr);
`define IPRoz(nam,def,uni,        des) (*units=uni, type="instance",            desc=des*) parameter real    nam=def from(  0:inf);
`define IPRnb(nam,def,uni,        des) (*units=uni, type="instance",            desc=des*) parameter real    nam=def;
`define IPIcc(nam,def,uni,lwr,upr,des) (*units=uni, type="instance",            desc=des*) parameter integer nam=def from[lwr:upr];
`define IPIco(nam,def,uni,lwr,upr,des) (*units=uni, type="instance",            desc=des*) parameter integer nam=def from[lwr:upr);
`define IPIcz(nam,def,uni,        des) (*units=uni, type="instance",            desc=des*) parameter integer nam=def from[  0:inf);
`define IPIoc(nam,def,uni,lwr,upr,des) (*units=uni, type="instance",            desc=des*) parameter integer nam=def from(lwr:upr];
`define IPIoo(nam,def,uni,lwr,upr,des) (*units=uni, type="instance",            desc=des*) parameter integer nam=def from(lwr:upr);
`define IPIoz(nam,def,uni,        des) (*units=uni, type="instance",            desc=des*) parameter integer nam=def from(  0:inf);
`define IPInb(nam,def,uni,        des) (*units=uni, type="instance",            desc=des*) parameter integer nam=def;
`define IPIsw(nam,def,uni,        des) (*units=uni, type="instance",            desc=des*) parameter integer nam=def from[  0:inf);
`define BPRnb(nam,def,uni,        des) (* units=uni, type = "instance", desc=des *) parameter real nam=def;

// ---- end `include "DIODE_CMC_macrodefs.include" ----

`define JUNCAP_StandAlone

// Note: some verilog-A compilers have problems handling the ddx-operator,
// which occurs in definition of OP-output variables. If the line below is
// commented out, all OP-output variables using the ddx-operator are skipped.
`define OPderiv

/////////////////////////////////////////////////////////////////////////////
//
//  Start of Diode_cmc model code
//
/////////////////////////////////////////////////////////////////////////////

module DIODE_CMC(a,k);

//
//  Node definitions
//
inout a,k;
electrical a,k;
electrical aik;  //internal node -- Diode_cmc code
electrical charge_a, charge_k, depl_a;  //internal node -- Diode_cmc recovery and high-injection equations code

///////////////////////////////
//  Diode_cmc model parameters
///////////////////////////////

`MPRnb(level          ,2002       ,""                                              ,"Model level must be 2002")
`MPRnb(version        ,3          ,""                                              ,"Model version")
`MPRnb(subversion     ,0          ,""                                              ,"Model subversion")
`MPRnb(revision       ,0          ,""                                              ,"Model revision")

// ---- begin `include "DIODE_CMC_parlist.include" ----
//======================================================================================
//======================================================================================
// Filename: DIODE_CMC_parlist.include
//======================================================================================
//
//
//                        Silicon Integration Initiative (Si2)
//                      Compact Model Coalition In-Code Statement
//
//    Software is distributed as is, completely without warranty or service support.  NXP
//    Semiconductors, Hiroshima University, and Silicon Integration Initiative, Inc. (Si2),
//    along with their employees are not liable for the condition or performance of the software.
//
//    NXP Semiconductors, Hiroshima University, and Si2 own the copyright and grant users
//    a perpetual, irrevocable, worldwide, non-exclusive, royalty-free license with respect to the
//    software as set forth below.
//
//    NXP Semiconductors, Hiroshima University, and Si2 hereby disclaim all implied
//    warranties.
//
//    NXP Semiconductors, Hiroshima University, and Si2 grant the users the right to modify,
//    copy, and redistribute the software and documentation, both within the user's organization
//    and externally, subject to the following restrictions
//
//      1. The users agree not to charge for the NXP Semiconductors, Hiroshima University,
//      and Si2 -developed code itself but may charge for additions, extensions, or support.
//
//      2. In any product based on the software, the users agree to acknowledge NXP
//      Semiconductors, Hiroshima University, and Si2 that developed the software.  This
//      acknowledgment shall appear in the product documentation.
//
//      3. Redistributions to others of source code and documentation must retain the copyright
//      notice, disclaimer, and list of conditions.
//
//      4. Redistributions to others in binary form must reproduce the copyright notice,
//      disclaimer, and list of conditions in the documentation and/or other materials provided
//      with the distribution.
//
//                                                     CMC In-Code Statement Revision 1.1 6/9/2016
//
//
//
// The diode_cmc is based on Juncap2 200.3.3 (test) from NXP Semiconductors.
//
// Portions commented as diode_cmc code: additional models since 2009.
//
// Portions commented as diode_cmc recovery and high-injection equations code: recovery model by Hiroshima University.
//
// All other parts are taken from Juncap2 200.3.3. Copyright 2008 NXP Semiconductors, All Rights Reserved.
//======================================================================================
//
//

//////////////////////////////////////////
//
// DIODE_CMC - Reduced parameterlist
//
//////////////////////////////////////////
`MPRcz( minr, $simparam("minr",1e-3), "Ohm", "minimum resistance")
`MPRco(imax           ,1000.0     ,"A"        ,`IMAX_cliplow     ,inf              ,"Maximum current up to which forward current behaves exponentially")
`MPRco(trj            ,21.0       ,"C"        ,`TRJ_cliplow      ,inf              ,"Reference temperature")
`MPRcc(frev           ,1.0e3      ,""         ,1E3               ,1E10             ,"Coefficient for reverse breakdown current limitation")

`MPRco(cjorbot        ,1.0e-3     ,"Fm^-2"    ,`CJORBOT_cliplow  ,inf              ,"Zero-bias capacitance per unit-of-area of bottom component")
`MPRco(cjorsti        ,1.0e-9     ,"Fm^-1"    ,`CJORSTI_cliplow  ,inf              ,"Zero-bias capacitance per unit-of-length of STI-edge component")
`MPRco(cjorgat        ,1.0e-9     ,"Fm^-1"    ,`CJORGAT_cliplow  ,inf              ,"Zero-bias capacitance per unit-of-length of gate-edge component")
`MPRco(vbirbot        ,1.0        ,"V"        ,`VBIR_cliplow     ,inf              ,"Built-in voltage at the reference temperature of bottom component")
`MPRco(vbirsti        ,1.0        ,"V"        ,`VBIR_cliplow     ,inf              ,"Built-in voltage at the reference temperature of STI-edge component")
`MPRco(vbirgat        ,1.0        ,"V"        ,`VBIR_cliplow     ,inf              ,"Built-in voltage at the reference temperature of gate-edge component")
`MPRcc(pbot           ,0.5        ,""         ,`P_cliplow        ,`P_cliphigh      ,"Grading coefficient of bottom component")
`MPRcc(psti           ,0.5        ,""         ,`P_cliplow        ,`P_cliphigh      ,"Grading coefficient of STI-edge component")
`MPRcc(pgat           ,0.5        ,""         ,`P_cliplow        ,`P_cliphigh      ,"Grading coefficient of gate-edge component")
`MPRnb(phigbot        ,1.16       ,"V"                                             ,"Zero-temperature bandgap voltage of bottom component")
`MPRnb(phigsti        ,1.16       ,"V"                                             ,"Zero-temperature bandgap voltage of STI-edge component")
`MPRnb(phiggat        ,1.16       ,"V"                                             ,"Zero-temperature bandgap voltage of gate-edge component")
`MPRco(idsatrbot      ,1.0e-12    ,"Am^-2"    ,`IDSATR_cliplow   ,inf              ,"Saturation current density at the reference temperature of bottom component")
`MPRco(idsatrsti      ,1.0e-18    ,"Am^-1"    ,`IDSATR_cliplow   ,inf              ,"Saturation current density at the reference temperature of STI-edge component")
`MPRco(idsatrgat      ,1.0e-18    ,"Am^-1"    ,`IDSATR_cliplow   ,inf              ,"Saturation current density at the reference temperature of gate-edge component")
`MPRco(csrhbot        ,1.0e2      ,"Am^-3"    ,`CSRH_cliplow     ,inf              ,"Shockley-Read-Hall prefactor of bottom component")
`MPRco(csrhsti        ,1.0e-4     ,"Am^-2"    ,`CSRH_cliplow     ,inf              ,"Shockley-Read-Hall prefactor of STI-edge component")
`MPRco(csrhgat        ,1.0e-4     ,"Am^-2"    ,`CSRH_cliplow     ,inf              ,"Shockley-Read-Hall prefactor of gate-edge component")
`MPRco(xjunsti        ,1.0e-7     ,"m"        ,`XJUN_cliplow     ,inf              ,"Junction depth of STI-edge component")
`MPRco(xjungat        ,1.0e-7     ,"m"        ,`XJUN_cliplow     ,inf              ,"Junction depth of gate-edge component")
`MPRco(ctatbot        ,1.0e2      ,"Am^-3"    ,`CTAT_cliplow     ,inf              ,"Trap-assisted tunneling prefactor of bottom component")
`MPRco(ctatsti        ,1.0e-4     ,"Am^-2"    ,`CTAT_cliplow     ,inf              ,"Trap-assisted tunneling prefactor of STI-edge component")
`MPRco(ctatgat        ,1.0e-4     ,"Am^-2"    ,`CTAT_cliplow     ,inf              ,"Trap-assisted tunneling prefactor of gate-edge component")
`MPRco(mefftatbot     ,0.25       ,""         ,`MEFFTAT_cliplow  ,inf              ,"Effective mass (in units of m0) for trap-assisted tunneling of bottom component")
`MPRco(mefftatsti     ,0.25       ,""         ,`MEFFTAT_cliplow  ,inf              ,"Effective mass (in units of m0) for trap-assisted tunneling of STI-edge component")
`MPRco(mefftatgat     ,0.25       ,""         ,`MEFFTAT_cliplow  ,inf              ,"Effective mass (in units of m0) for trap-assisted tunneling of gate-edge component")
`MPRco(cbbtbot        ,1.0e-12    ,"AV^-3"    ,`CBBT_cliplow     ,inf              ,"Band-to-band tunneling prefactor of bottom component")
`MPRco(cbbtsti        ,1.0e-18    ,"AV^-3m"   ,`CBBT_cliplow     ,inf              ,"Band-to-band tunneling prefactor of STI-edge component")
`MPRco(cbbtgat        ,1.0e-18    ,"AV^-3m"   ,`CBBT_cliplow     ,inf              ,"Band-to-band tunneling prefactor of gate-edge component")
`MPRnb(fbbtrbot       ,1.0e9      ,"Vm^-1"                                         ,"Normalization field at the reference temperature for band-to-band tunneling of bottom component")
`MPRnb(fbbtrsti       ,1.0e9      ,"Vm^-1"                                         ,"Normalization field at the reference temperature for band-to-band tunneling of STI-edge component")
`MPRnb(fbbtrgat       ,1.0e9      ,"Vm^-1"                                         ,"Normalization field at the reference temperature for band-to-band tunneling of gate-edge component")
`MPRnb(stfbbtbot      ,-1.0e-3    ,"K^-1"                                          ,"Temperature scaling parameter for band-to-band tunneling of bottom component")
`MPRnb(stfbbtsti      ,-1.0e-3    ,"K^-1"                                          ,"Temperature scaling parameter for band-to-band tunneling of STI-edge component")
`MPRnb(stfbbtgat      ,-1.0e-3    ,"K^-1"                                          ,"Temperature scaling parameter for band-to-band tunneling of gate-edge component")
`MPRco(vbrbot         ,10.0       ,"V"        ,`VBR_cliplow      ,inf              ,"Breakdown voltage of bottom component")
`MPRco(vbrsti         ,10.0       ,"V"        ,`VBR_cliplow      ,inf              ,"Breakdown voltage of STI-edge component")
`MPRco(vbrgat         ,10.0       ,"V"        ,`VBR_cliplow      ,inf              ,"Breakdown voltage of gate-edge component")
`MPRco(pbrbot         ,4.0        ,"V"        ,`PBR_cliplow      ,inf              ,"Breakdown onset tuning parameter of bottom component")
`MPRco(pbrsti         ,4.0        ,"V"        ,`PBR_cliplow      ,inf              ,"Breakdown onset tuning parameter of STI-edge component")
`MPRco(pbrgat         ,4.0        ,"V"        ,`PBR_cliplow      ,inf              ,"Breakdown onset tuning parameter of gate-edge component")

//Diode_cmc code
`MPRco(rsbot          ,0.0        ,"VA^-1m^2" ,`RS_cliplow       ,inf              ,"Series resistance per unit-of-area of bottom component")
`MPRco(rssti          ,0.0        ,"VA^-1m^2" ,`RS_cliplow       ,inf              ,"Series resistance per unit-of-length of STI-edge component")
`MPRco(rsgat          ,0.0        ,"VA^-1m^2" ,`RS_cliplow       ,inf              ,"Series resistance per unit-of-length of gate-edge component")
`MPRco(rscom          ,0.0        ,"VA^-1m^2" ,`RS_cliplow       ,inf              ,"Common series resistance, no scaling")
`MPRco(strs           ,0.0        ,""         ,`RS_cliplow       ,inf              ,"Temperature scaling parameter for series resistance")
`MPRco(kf             ,0.0        ,""         ,`KF_cliplow       ,inf              ,"kf parameter for flicker noise")
`MPRco(af             ,1.0        ,""         ,`AF_cliplow       ,inf              ,"af parameter for flicker noise")
`MPRco(tt             ,0.0        ,"s"        ,`TT_cliplow       ,inf              ,"Transit time")
`MPRnb(stvbrbot1      ,0.0        ,"1/K"                                           ,"Temp. co of breakdown voltage bottom component")
`MPRnb(stvbrbot2      ,0.0        ,"1/K^2"                                         ,"Temp. co of breakdown voltage bottom component")
`MPRnb(stvbrsti1      ,0.0        ,"1/K"                                           ,"Temp. co of breakdown voltage STI-edge component")
`MPRnb(stvbrsti2      ,0.0        ,"1/K^2"                                         ,"Temp. co of breakdown voltage STI-edge component")
`MPRnb(stvbrgat1      ,0.0        ,"1/K"                                           ,"Temp. co of breakdown voltage gate-edge component")
`MPRnb(stvbrgat2      ,0.0        ,"1/K^2"                                         ,"Temp. co of breakdown voltage gate-edge component")
`MPRco(nfabot         ,1.0        ,""         ,`NFA_cliplow      ,inf              ,"ideality factor bottom component")
`MPRco(nfasti         ,1.0        ,""         ,`NFA_cliplow      ,inf              ,"ideality factor STI-edge component")
`MPRco(nfagat         ,1.0        ,""         ,`NFA_cliplow      ,inf              ,"ideality factor gate-edge component")
`MPRco(abmin          ,0.0        ,"m^2"      ,`AB_cliplow       ,inf              ,"minimum allowed junction area")
`MPRco(abmax          ,1.0        ,"m^2"      ,`AB_cliplow       ,inf              ,"maximum allowed junction area")
`MPRco(lsmin          ,0.0        ,"m"        ,`LS_cliplow       ,inf              ,"minimum allowed junction STI-edge")
`MPRco(lsmax          ,1.0        ,"m"        ,`LS_cliplow       ,inf              ,"maximum allowed junction STI-edge")
`MPRco(lgmin          ,0.0        ,"m"        ,`LG_cliplow       ,inf              ,"minimum allowed junction gate-edge")
`MPRco(lgmax          ,1.0        ,"m"        ,`LG_cliplow       ,inf              ,"maximum allowed junction gate-edge")
`MPRco(tempmin        ,-55        ,"C"        ,`TRJ_cliplow      ,inf              ,"minimum allowed junction temp")
`MPRco(tempmax        ,155        ,"C"        ,`TRJ_cliplow      ,inf              ,"maximum allowed junction temp")
`MPRco(vfmax          ,0.0        ,"V"        ,`VOLT_cliplow     ,inf              ,"maximum allowed forward junction bias")
`MPRco(vrmax          ,0.0        ,"V"        ,`VOLT_cliplow     ,inf              ,"maximum allowed reverse junction bias")
`MPRco(xti            ,3.0        ,""         ,`XTI_cliplow      ,inf              ,"Temp. co of saturation current")
`MPRcc(scale          ,1.0        ,""         ,`SCALE_cliplow    ,1.0              ,"Scale parameter")
`MPRcc(shrink         ,0.0        ,""         ,`SHRINK_cliplow   ,`SHRINK_cliphigh ,"Shrink parameter")
`MPRco(expceil        ,1e20       ,""         ,1.0               ,inf              ,"Safety valve against carrier conc explosion")
`MPRcc(swbv           ,1.0        ,""         ,0.0               ,1.0              ,"Flag to enable the breakdown of diode_cmc; 1=breakdown effect enabled, 0=breakdown effect disabled")
aliasparam  bv_enable= swbv;
//End of Diode_cmc code

// JUNCAP2-express parameters
`MPRcc(swjunexp       ,0.0        ,""         ,0.0               ,1.0              ,"Flag for JUNCAP-express; 0=full model, 1=express model")
`MPRco(vjunref        ,2.5        ,""         ,`VJUNREF_cliplow  ,inf              ,"Typical maximum junction voltage; usually about 2*VSUP")
`MPRco(fjunq          ,0.03       ,""         ,`FJUNQ_cliplow    ,inf              ,"Fraction below which junction capacitance components are considered negligible")

//Diode_cmc recovery and high-injection equations code
`MPRcc(corecovery     ,0.0        ,""         ,0.0               ,1.0              ,"Flag for recovery equations; 0=original, 1=Hiroshima")
`MPRcc(njh            ,1.0        ,""         ,0.5               ,5                ,"High-injection emission coefficient")
`MPRcc(njdv           ,0.1        ,"1/V"      ,0                 ,1e6              ,"Transition slope of emission coefficient")
`MPRcc(ndibot         ,1e16       ,"cm^-3"    ,1                 ,1e23             ,"Doping concentration of drift region")
`MPRcc(ndigat         ,1e16       ,"cm^-3"    ,1                 ,1e23             ,"Doping concentration of drift region")
`MPRcc(ndisti         ,1e16       ,"cm^-3"    ,1                 ,1e23             ,"Doping concentration of drift region")
`MPRcc(inj1           ,1.0        ,""         ,0                 ,3                ,"Factor for recovery charge density")
`MPRcc(inj2           ,10.0       ,"V^-2"     ,0                 ,50               ,"Voltage dependence of recovery charge density (high injection)")
`MPRcc(nqs            ,5e-9       ,"s"        ,0                 ,1e-3             ,"Carrier delay time")
`MPRcc(tau            ,2e-7       ,"s"        ,1.0e-12           ,1e-3             ,"Carrier lifetime")
`MPRcc(wi             ,5e-6       ,"m"        ,0                 ,1.0              ,"Length of drift region")
`MPRcc(depnqs         ,0.0        ,"s"        ,0                 ,1e-3             ,"Depletion delay time")
`MPRco(tnom           ,21         ,"C"        ,`TRJ_cliplow      ,inf              ,"Alias reference temperature")
`MPRcc(taut           ,0.0        ,""         ,0                 ,1.0e2            ,"Temp. co of carrier lifetime")
`MPRcc(injt           ,0.0        ,""         ,0                 ,20               ,"Temp. co of carrier density in high-injection condition")
//End of Diode_cmc recovery and high-injection equations code
// ---- end `include "DIODE_CMC_parlist.include" ----

//  Instance parameters
`IPRco(ab             ,1E-12      ,"m^2"      ,`AB_cliplow       ,inf              ,"Junction area")
`IPRco(ls             ,1e-6       ,"m"        ,`LS_cliplow       ,inf              ,"STI-edge part of junction perimeter")
`IPRco(lg             ,0          ,"m"        ,`LG_cliplow       ,inf              ,"Gate-edge part of junction perimeter")
`BPRnb(dta            ,0.0        ,"C"                                             ,"Temperature offset with respect to ambient temperature")

// Diode_cmc code
aliasparam   area         = ab;
aliasparam   perim        = ls;
aliasparam   pj           = ls;
aliasparam   pt           = xti;
aliasparam   dtemp        = dta;
aliasparam   trise        = dta;
// End of Diode_cmc code

//////////////////////////
//
//  Variables
//
//////////////////////////

real EPSSI;

// ---- begin `include "DIODE_CMC_varlist1.include" ----
//======================================================================================
//======================================================================================
// Filename: DIODE_CMC_varlist1.include
//======================================================================================
//
//
//                        Silicon Integration Initiative (Si2)
//                      Compact Model Coalition In-Code Statement
//
//    Software is distributed as is, completely without warranty or service support.  NXP
//    Semiconductors, Hiroshima University, and Silicon Integration Initiative, Inc. (Si2),
//    along with their employees are not liable for the condition or performance of the software.
//
//    NXP Semiconductors, Hiroshima University, and Si2 own the copyright and grant users
//    a perpetual, irrevocable, worldwide, non-exclusive, royalty-free license with respect to the
//    software as set forth below.
//
//    NXP Semiconductors, Hiroshima University, and Si2 hereby disclaim all implied
//    warranties.
//
//    NXP Semiconductors, Hiroshima University, and Si2 grant the users the right to modify,
//    copy, and redistribute the software and documentation, both within the user's organization
//    and externally, subject to the following restrictions
//
//      1. The users agree not to charge for the NXP Semiconductors, Hiroshima University,
//      and Si2 -developed code itself but may charge for additions, extensions, or support.
//
//      2. In any product based on the software, the users agree to acknowledge NXP
//      Semiconductors, Hiroshima University, and Si2 that developed the software.  This
//      acknowledgment shall appear in the product documentation.
//
//      3. Redistributions to others of source code and documentation must retain the copyright
//      notice, disclaimer, and list of conditions.
//
//      4. Redistributions to others in binary form must reproduce the copyright notice,
//      disclaimer, and list of conditions in the documentation and/or other materials provided
//      with the distribution.
//
//                                                     CMC In-Code Statement Revision 1.1 6/9/2016
//
//
//
// The diode_cmc is based on Juncap2 200.3.3 (test) from NXP Semiconductors.
//
// Portions commented as diode_cmc code: additional models since 2009.
//
// All other parts are taken from Juncap2 200.3.3. Copyright 2008 NXP Semiconductors, All Rights Reserved.
//======================================================================================
//
//

// declaration of clipped parameters
real TRJ_i, IMAX_i;
real CJORBOT_i, CJORSTI_i, CJORGAT_i, VBIRBOT_i, VBIRSTI_i, VBIRGAT_i;
real PBOT_i, PSTI_i, PGAT_i, PHIGBOT_i, PHIGSTI_i, PHIGGAT_i;
real IDSATRBOT_i, IDSATRSTI_i, IDSATRGAT_i, XJUNSTI_i, XJUNGAT_i;
real CSRHBOT_i, CSRHSTI_i, CSRHGAT_i, CTATBOT_i, CTATSTI_i, CTATGAT_i;
real MEFFTATBOT_i, MEFFTATSTI_i, MEFFTATGAT_i;
real CBBTBOT_i, CBBTSTI_i, CBBTGAT_i, FBBTRBOT_i, FBBTRSTI_i, FBBTRGAT_i;
real STFBBTBOT_i, STFBBTSTI_i, STFBBTGAT_i;
real VBRBOT_i, VBRSTI_i, VBRGAT_i, PBRBOT_i, PBRSTI_i, PBRGAT_i;
real FREV_i;

real SWJUNEXP_i, VJUNREF_i, FJUNQ_i;

//Diode_cmc code
real RSBOT_i, RSSTI_i, RSGAT_i, STRS_i, RSCOM_i;
real KF_i, AF_i;
real TT_i;
real STVBRBOT1_i, STVBRBOT2_i, STVBRSTI1_i, STVBRSTI2_i, STVBRGAT1_i, STVBRGAT2_i;
real NFABOT_i, NFAGAT_i, NFASTI_i;
real ABMIN_i, ABMAX_i, LGMAX_i, LGMIN_i, LSMAX_i, LSMIN_i, TEMPMIN_i, TEMPMAX_i;
real VFMAX_i, VRMAX_i;
real XTI_i;
real SCALE_i, SHRINK_i;
//End of Diode_cmc code

// declaration of variables calculated outside macro "juncapfunction", voltage-independent part
real tkr, tkd, auxt, KBOL_over_QELE, phitr, phitrinv, phitd, phitdinv;
real perfc, berfc, cerfc;
real deltaphigr, deltaphigd, pmax;

real phigrbot, phigrsti, phigrgat, phigdbot, phigdsti, phigdgat;
real ftdbot, ftdsti, ftdgat, idsatbot, idsatsti, idsatgat;
real ubibot, ubisti, ubigat, vbibot, vbisti, vbigat;
real vbibot2, vbisti2, vbigat2, pbot2, psti2, pgat2, vbibot2r, vbisti2r, vbigat2r;
real vbiinvbot, vbiinvsti, vbiinvgat;
real one_minus_PBOT, one_minus_PSTI, one_minus_PGAT;
real one_over_one_minus_PBOT, one_over_one_minus_PSTI, one_over_one_minus_PGAT;
real cjobot, cjosti, cjogat;
real qprefbot, qprefsti, qprefgat, qpref2bot, qpref2sti, qpref2gat;
real wdepnulrbot, wdepnulrsti, wdepnulrgat, wdepnulrinvbot, wdepnulrinvsti, wdepnulrinvgat;
real VBIRBOTinv, VBIRSTIinv, VBIRGATinv;
real deltaEbot, deltaEsti, deltaEgat, atatbot, atatsti, atatgat;
real btatpartbot, btatpartsti, btatpartgat;
real fbbtbot, fbbtsti, fbbtgat;
real alphaav;
real fstopbot, fstopsti, fstopgat, VBRinvbot, VBRinvsti, VBRinvgat;
real slopebot, slopesti, slopegat;

//Diode_cmc code
real vmaxbot, vmaxsti, vmaxgat;
real restotal, rescom, resbot, ressti, resgat;
real ftdbot2, ftdsti2, ftdgat2;
real shrinkL;
//End of Diode_cmc code

// JUNCAP-Express variables
real I1, I2, I3, I4, I5;
real I1_cor, I2_cor, I3_cor, I4_cor, I5_cor;
real V1, V2, V3, V4, V5;
real alphaje, m0_rev, mcor_rev;
real tt0, tt1, tt2, tm0, tm1;
real tmpv, vjv;
real FRACNA, FRACNB, FRACI;
real zfrac;
real ijunfor1, ijunfor2, ijunrev;

`LocalGlobalVars
// ---- end `include "DIODE_CMC_varlist1.include" ----
// ---- begin `include "DIODE_CMC_varlist2.include" ----
//======================================================================================
//======================================================================================
// Filename: DIODE_CMC_varlist2.include
//======================================================================================
//
//
//                        Silicon Integration Initiative (Si2)
//                      Compact Model Coalition In-Code Statement
//
//    Software is distributed as is, completely without warranty or service support.  NXP
//    Semiconductors, Hiroshima University, and Silicon Integration Initiative, Inc. (Si2),
//    along with their employees are not liable for the condition or performance of the software.
//
//    NXP Semiconductors, Hiroshima University, and Si2 own the copyright and grant users
//    a perpetual, irrevocable, worldwide, non-exclusive, royalty-free license with respect to the
//    software as set forth below.
//
//    NXP Semiconductors, Hiroshima University, and Si2 hereby disclaim all implied
//    warranties.
//
//    NXP Semiconductors, Hiroshima University, and Si2 grant the users the right to modify,
//    copy, and redistribute the software and documentation, both within the user's organization
//    and externally, subject to the following restrictions
//
//      1. The users agree not to charge for the NXP Semiconductors, Hiroshima University,
//      and Si2 -developed code itself but may charge for additions, extensions, or support.
//
//      2. In any product based on the software, the users agree to acknowledge NXP
//      Semiconductors, Hiroshima University, and Si2 that developed the software.  This
//      acknowledgment shall appear in the product documentation.
//
//      3. Redistributions to others of source code and documentation must retain the copyright
//      notice, disclaimer, and list of conditions.
//
//      4. Redistributions to others in binary form must reproduce the copyright notice,
//      disclaimer, and list of conditions in the documentation and/or other materials provided
//      with the distribution.
//
//                                                     CMC In-Code Statement Revision 1.1 6/9/2016
//
//
//
// The diode_cmc is based on Juncap2 200.3.3 (test) from NXP Semiconductors.
//
// Portions commented as diode_cmc code: additional models since 2009.
//
// Portions commented as diode_cmc recovery and high-injection equations code: recovery model by Hiroshima University.
//
// All other parts are taken from Juncap2 200.3.3. Copyright 2008 NXP Semiconductors, All Rights Reserved.
//======================================================================================
//
//
//================================================================
// Variables that are different for source and drain side junction
// and have a scope larger than a single macro-call
//================================================================

real AB_i, LS_i, LG_i;
real zflagbot, zflagsti, zflaggat;
real VMAX, exp_VMAX_over_phitd, vbimin, vch, vfmin, vbbtlim;
real ijunbot, qjunbot, ijunsti, qjunsti, ijungat, qjungat, ijun, qjun, jnoise;

//Diode_cmc code
real VAK; //voltage across the junction
real DQAbot, DQAsti, DQAgat; // intermediate variable for ddx() workaround
real exp_VMAX_over_phitd_bot, exp_VMAX_over_phitd_sti, exp_VMAX_over_phitd_gat;

real VRS; //voltage across the resistor
real conducts; // total series conductance and resistance
real jfnoise; //flicker noise
real jtnoise; //thermal noise
real Vtotal; //voltage across the whole diode
real isattotal; //Total saturation current
real ijnon, ijnonbot, ijnonsti, ijnongat; //non-ideal currents for noise calculation
//End of Diode_cmc code

// JUNCAP-express variables
real xhighf1, expxhf1, xhighf2, expxhf2, xhighr, expxhr;

// JUNCAP2-express intermediate parameters
real ISATFOR1, MFOR1, ISATFOR2, MFOR2, ISATREV, MREV, m0flag;

//Diode_cmc recovery and high-injection equations code

// for unit conversion
real NDI_i;
real NDIBOT_i;
real NDIGAT_i;
real NDISTI_i;
real MUEN_i, MUEP_i;
real NJL;

// temporary variables
real TMF1, TMF2;
real T1, T2;

// bias-dependent variables for the recovery model
real Nin, Pn0;
real Dn, Dp, Da, La, tau_HL;

real Vjunc_A, W_depA;
real Q_n0, Q_nexA_nqs, Q_nexK_nqs, Qrr;
//, Q_depA;
real q_pexA, q_pexK, q_pex0, Q_qs_A, Q_qs_K, Q_nqs_A, Q_nqs_K;
real Inqs0_A, Inqs0_K, q_pexA_nqs, q_pexK_nqs;
real W_qs_A, W_depA0, W_nqs_A, IWnqs0_A, W_depA_nqs;

real V_HA, V_HK;
real nj_K0, nj0, nj_K1, nj_K;
real exp_A, exp_K, p_nA, p_nK;
real exp_A2, exp_K2;
real nj1, nja10, nja11, vha1, pnn0;
real dFn_SU, dFn_SL, dnj1_dV, dVMAX_over_phitd_dV;

// fixed parameters
real PB;      //Built-in potential at P/N junction (minor) [V]
real JUNCDLT; //Smoothness of depletion width around zero bias (minor) [V]

//End of Diode_cmc recovery and high-injection equations code
/* The following line is Diode_cmc code */
real idmultbot, idmultsti, idmultgat;
// ---- end `include "DIODE_CMC_varlist2.include" ----

/////////////////////////////////////////////////////////////////////////////
//
// Variables for operating point info
//
/////////////////////////////////////////////////////////////////////////////
`OPP(vak                          ,"V"                                             ,"Voltage between anode and cathode excluding the series resistor" )

`ifdef OPderiv
    `OPM(cj                           ,"F"                                             ,"Total source junction capacitance" )
    `OPM(cjbot                        ,"F"                                             ,"Junction capacitance (bottom component)" )
    `OPM(cjgat                        ,"F"                                             ,"Junction capacitance (gate-edge component)" )
    `OPM(cjsti                        ,"F"                                             ,"Junction capacitance (STI-edge component)" )
`endif // OPderiv

`OPM(ij                           ,"A"                                             ,"Total source junction current" )
`OPM(ijbot                        ,"A"                                             ,"Junction current (bottom component)" )
`OPM(ijgat                        ,"A"                                             ,"Junction current (gate-edge component)" )
`OPM(ijsti                        ,"A"                                             ,"Junction current (STI-edge component)" )
`OPM(si                           ,"A^2/Hz"                                        ,"Total junction current noise spectral density" )

// Diode_cmc code

`OPP(vrs                          ,"V"                                             ,"Voltage across series resistor" )
`OPM(sf                           ,"A^2/Hz"                                        ,"Total junction flicker noise spectral density" )
`OPM(sr                           ,"A^2/Hz"                                        ,"Total series resistor thermal noise spectral density" )
`OPD(rseries                      ,"V/A"                                           ,"Series resistor" )

// End of Diode_cmc code

// Diode_cmc recovery and high-injection equations code
`OPM(qrr                          ,"C"                                             ,"Recovery charge" )
// End of Diode_cmc recovery and high-injection equations code

/////////////////////////////////////////////////////////////////////////////
//
//  Analog block with all calculations and contribs
//
/////////////////////////////////////////////////////////////////////////////

analog begin

    begin : initialize_Model

        EPSSI      =  `EPSO * `EPSRSI;
// ---- begin `include "DIODE_CMC_InitModel.include" ----
//======================================================================================
//======================================================================================
// Filename: DIODE_CMC_InitModel.include
//======================================================================================
//
//
//                        Silicon Integration Initiative (Si2)
//                      Compact Model Coalition In-Code Statement
//
//    Software is distributed as is, completely without warranty or service support.  NXP
//    Semiconductors, Hiroshima University, and Silicon Integration Initiative, Inc. (Si2),
//    along with their employees are not liable for the condition or performance of the software.
//
//    NXP Semiconductors, Hiroshima University, and Si2 own the copyright and grant users
//    a perpetual, irrevocable, worldwide, non-exclusive, royalty-free license with respect to the
//    software as set forth below.
//
//    NXP Semiconductors, Hiroshima University, and Si2 hereby disclaim all implied
//    warranties.
//
//    NXP Semiconductors, Hiroshima University, and Si2 grant the users the right to modify,
//    copy, and redistribute the software and documentation, both within the user's organization
//    and externally, subject to the following restrictions
//
//      1. The users agree not to charge for the NXP Semiconductors, Hiroshima University,
//      and Si2 -developed code itself but may charge for additions, extensions, or support.
//
//      2. In any product based on the software, the users agree to acknowledge NXP
//      Semiconductors, Hiroshima University, and Si2 that developed the software.  This
//      acknowledgment shall appear in the product documentation.
//
//      3. Redistributions to others of source code and documentation must retain the copyright
//      notice, disclaimer, and list of conditions.
//
//      4. Redistributions to others in binary form must reproduce the copyright notice,
//      disclaimer, and list of conditions in the documentation and/or other materials provided
//      with the distribution.
//
//                                                     CMC In-Code Statement Revision 1.1 6/9/2016
//
//
//
// The diode_cmc is based on Juncap2 200.3.3 (test) from NXP Semiconductors.
//
// Portions commented as diode_cmc code: additional models since 2009.
//
// Portions commented as diode_cmc recovery and high-injection equations code: recovery model by Hiroshima University.
//
// All other parts are taken from Juncap2 200.3.3. Copyright 2008 NXP Semiconductors, All Rights Reserved.
//======================================================================================
//
//

//////////////////////////////////////////////////////////////
//
// Calculation of internal parameters which are independent
// on instance parameters
//
//////////////////////////////////////////////////////////////

TRJ_i        = `CLIP_LOW( trj        , `TRJ_cliplow);
//Diode_cmc recovery and high-injection equations code
if ( (!$param_given(trj)) && ($param_given(tnom)) ) begin
    TRJ_i     = `CLIP_LOW( tnom       , `TRJ_cliplow);
end
//End of Diode_cmc recovery and high-injection equations code
IMAX_i       = `CLIP_LOW( imax       , `IMAX_cliplow);

CJORBOT_i    = `CLIP_LOW( cjorbot    , `CJORBOT_cliplow);
CJORSTI_i    = `CLIP_LOW( cjorsti    , `CJORSTI_cliplow);
CJORGAT_i    = `CLIP_LOW( cjorgat    , `CJORGAT_cliplow);
VBIRBOT_i    = `CLIP_LOW( vbirbot    , `VBIR_cliplow);
VBIRSTI_i    = `CLIP_LOW( vbirsti    , `VBIR_cliplow);
VBIRGAT_i    = `CLIP_LOW( vbirgat    , `VBIR_cliplow);
PBOT_i       = `CLIP_BOTH(pbot       , `P_cliplow,`P_cliphigh);
PSTI_i       = `CLIP_BOTH(psti       , `P_cliplow,`P_cliphigh);
PGAT_i       = `CLIP_BOTH(pgat       , `P_cliplow,`P_cliphigh);
PHIGBOT_i    =  phigbot;
PHIGSTI_i    =  phigsti;
PHIGGAT_i    =  phiggat;
IDSATRBOT_i  = `CLIP_LOW( idsatrbot  , `IDSATR_cliplow);
IDSATRSTI_i  = `CLIP_LOW( idsatrsti  , `IDSATR_cliplow);
IDSATRGAT_i  = `CLIP_LOW( idsatrgat  , `IDSATR_cliplow);
CSRHBOT_i    = `CLIP_LOW( csrhbot    , `CSRH_cliplow);
CSRHSTI_i    = `CLIP_LOW( csrhsti    , `CSRH_cliplow);
CSRHGAT_i    = `CLIP_LOW( csrhgat    , `CSRH_cliplow);
XJUNSTI_i    = `CLIP_LOW( xjunsti    , `XJUN_cliplow);
XJUNGAT_i    = `CLIP_LOW( xjungat    , `XJUN_cliplow);
CTATBOT_i    = `CLIP_LOW( ctatbot    , `CTAT_cliplow);
CTATSTI_i    = `CLIP_LOW( ctatsti    , `CTAT_cliplow);
CTATGAT_i    = `CLIP_LOW( ctatgat    , `CTAT_cliplow);
MEFFTATBOT_i = `CLIP_LOW( mefftatbot , `MEFFTAT_cliplow);
MEFFTATSTI_i = `CLIP_LOW( mefftatsti , `MEFFTAT_cliplow);
MEFFTATGAT_i = `CLIP_LOW( mefftatgat , `MEFFTAT_cliplow);
CBBTBOT_i    = `CLIP_LOW( cbbtbot    , `CBBT_cliplow);
CBBTSTI_i    = `CLIP_LOW( cbbtsti    , `CBBT_cliplow);
CBBTGAT_i    = `CLIP_LOW( cbbtgat    , `CBBT_cliplow);
FBBTRBOT_i   =  fbbtrbot;
FBBTRSTI_i   =  fbbtrsti;
FBBTRGAT_i   =  fbbtrgat;
STFBBTBOT_i  =  stfbbtbot;
STFBBTSTI_i  =  stfbbtsti;
STFBBTGAT_i  =  stfbbtgat;
VBRBOT_i     = `CLIP_LOW( vbrbot     , `VBR_cliplow);
VBRSTI_i     = `CLIP_LOW( vbrsti     , `VBR_cliplow);
VBRGAT_i     = `CLIP_LOW( vbrgat     , `VBR_cliplow);
PBRBOT_i     = `CLIP_LOW( pbrbot     , `PBR_cliplow);
PBRSTI_i     = `CLIP_LOW( pbrsti     , `PBR_cliplow);
PBRGAT_i     = `CLIP_LOW( pbrgat     , `PBR_cliplow);
FREV_i       =  frev;

// Diode_cmc code
RSBOT_i      = `CLIP_LOW( rsbot      , `RS_cliplow);
RSSTI_i      = `CLIP_LOW( rssti      , `RS_cliplow);
RSGAT_i      = `CLIP_LOW( rsgat      , `RS_cliplow);
RSCOM_i      = `CLIP_LOW( rscom      , `RS_cliplow);
STRS_i       = `CLIP_LOW( strs       , `RS_cliplow);
AF_i         = `CLIP_LOW( af         , `AF_cliplow);
KF_i         = `CLIP_LOW( kf         , `KF_cliplow);
TT_i         = `CLIP_LOW( tt         , `TT_cliplow);
STVBRBOT1_i  = stvbrbot1;
STVBRBOT2_i  = stvbrbot2;
STVBRSTI1_i  = stvbrsti1;
STVBRSTI2_i  = stvbrsti2;
STVBRGAT1_i  = stvbrgat1;
STVBRGAT2_i  = stvbrgat2;
NFABOT_i     = `CLIP_LOW( nfabot     , `NFA_cliplow);
NFASTI_i     = `CLIP_LOW( nfasti     , `NFA_cliplow);
NFAGAT_i     = `CLIP_LOW( nfagat     , `NFA_cliplow);
ABMIN_i      = `CLIP_LOW( abmin      , `AB_cliplow);
ABMAX_i      = `CLIP_LOW( abmax      , `AB_cliplow);
LSMIN_i      = `CLIP_LOW( lsmin      , `LS_cliplow);
LSMAX_i      = `CLIP_LOW( lsmax      , `LS_cliplow);
LGMIN_i      = `CLIP_LOW( lgmin      , `LG_cliplow);
LGMAX_i      = `CLIP_LOW( lgmax      , `LG_cliplow);
TEMPMIN_i    = `CLIP_LOW( tempmin    , `TRJ_cliplow);
TEMPMAX_i    = `CLIP_LOW( tempmax    , `TRJ_cliplow);
VFMAX_i      = `CLIP_LOW( vfmax      , `VOLT_cliplow);
VRMAX_i      = `CLIP_LOW( vrmax      , `VOLT_cliplow);
XTI_i        = `CLIP_LOW( xti        , `XTI_cliplow);
SCALE_i      = `CLIP_LOW( scale      , `SCALE_cliplow);
SHRINK_i     = `CLIP_LOW( shrink     , `SHRINK_cliplow);
//End of Diode_cmc code

SWJUNEXP_i   = 0.0;
if (swjunexp > 0.5) begin
    SWJUNEXP_i = 1.0;
end else begin
    SWJUNEXP_i = 0.0;
end

VJUNREF_i    = `CLIP_LOW( vjunref   , `VJUNREF_cliplow);
FJUNQ_i      = `CLIP_LOW( fjunq     , `FJUNQ_cliplow);

tkr            = `KELVINCONVERSION + TRJ_i;
tkd            = max($temperature + dta, `KELVINCONVERSION + `MINTEMP);
auxt           = tkd / tkr;
KBOL_over_QELE = `KBOL / `QELE;
phitr          = KBOL_over_QELE * tkr;
phitrinv       = 1.0 / phitr;
phitd          = KBOL_over_QELE * tkd;
phitdinv       = 1.0 / phitd;

// bandgap voltages at reference temperature
deltaphigr      = -(7.02e-4 * tkr * tkr) / (1108.0 + tkr);
phigrbot      = PHIGBOT_i + deltaphigr;
phigrsti      = PHIGSTI_i + deltaphigr;
phigrgat      = PHIGGAT_i + deltaphigr;

// bandgap voltages at device temperature
deltaphigd      = -(7.02e-4 * tkd * tkd) / (1108.0 + tkd);
phigdbot      = PHIGBOT_i + deltaphigd;
phigdsti      = PHIGSTI_i + deltaphigd;
phigdgat      = PHIGGAT_i + deltaphigd;

// factors ftd for ideal-current model
ftdbot        = (pow(auxt, XTI_i/2.0)) * exp(0.5 * ((phigrbot * phitrinv) - (phigdbot * phitdinv)));
ftdsti        = (pow(auxt, XTI_i/2.0)) * exp(0.5 * ((phigrsti * phitrinv) - (phigdsti * phitdinv)));
ftdgat        = (pow(auxt, XTI_i/2.0)) * exp(0.5 * ((phigrgat * phitrinv) - (phigdgat * phitdinv)));

// factors ftd for ideal-current with ideality factor != 1

ftdbot2        = (pow(auxt, XTI_i/2.0/NFABOT_i)) * exp(0.5 * ((phigrbot * phitrinv) - (phigdbot * phitdinv))/NFABOT_i);
ftdsti2        = (pow(auxt, XTI_i/2.0/NFASTI_i)) * exp(0.5 * ((phigrsti * phitrinv) - (phigdsti * phitdinv))/NFASTI_i);
ftdgat2        = (pow(auxt, XTI_i/2.0/NFAGAT_i)) * exp(0.5 * ((phigrgat * phitrinv) - (phigdgat * phitdinv))/NFAGAT_i);

// temperature-scaled saturation current for ideal-current model
idsatbot      = IDSATRBOT_i * ftdbot2 * ftdbot2;
idsatsti      = IDSATRSTI_i * ftdsti2 * ftdsti2;
idsatgat      = IDSATRGAT_i * ftdgat2 * ftdgat2;

// built-in voltages before limiting
ubibot        = VBIRBOT_i * auxt - 2 * phitd * ln(ftdbot);
ubisti        = VBIRSTI_i * auxt - 2 * phitd * ln(ftdsti);
ubigat        = VBIRGAT_i * auxt - 2 * phitd * ln(ftdgat);

// built-in voltages limited to phitd
vbibot        = ubibot + phitd * ln(1 + exp((`vbilow - ubibot) * phitdinv));
vbisti        = ubisti + phitd * ln(1 + exp((`vbilow - ubisti) * phitdinv));
vbigat        = ubigat + phitd * ln(1 + exp((`vbilow - ubigat) * phitdinv));

// inverse values of built-in voltages
vbiinvbot     = 1.0 / vbibot;
vbiinvsti     = 1.0 / vbisti;
vbiinvgat     = 1.0 / vbigat;

// one minus the grading coefficient
one_minus_PBOT = 1 - PBOT_i;
one_minus_PSTI = 1 - PSTI_i;
one_minus_PGAT = 1 - PGAT_i;

// one over "one minus the grading coefficient"
one_over_one_minus_PBOT = 1 / one_minus_PBOT;
one_over_one_minus_PSTI = 1 / one_minus_PSTI;
one_over_one_minus_PGAT = 1 / one_minus_PGAT;

// temperature-scaled zero-bias capacitance
cjobot        = CJORBOT_i * pow((VBIRBOT_i * vbiinvbot), PBOT_i);
cjosti        = CJORSTI_i * pow((VBIRSTI_i * vbiinvsti), PSTI_i);
cjogat        = CJORGAT_i * pow((VBIRGAT_i * vbiinvgat), PGAT_i);

// prefactor in physical part of charge model
qprefbot      = cjobot * vbibot * one_over_one_minus_PBOT;
qprefsti      = cjosti * vbisti * one_over_one_minus_PSTI;
qprefgat      = cjogat * vbigat * one_over_one_minus_PGAT;

// prefactor in mathematical extension of charge model
qpref2bot     = `a * cjobot;
qpref2sti     = `a * cjosti;
qpref2gat     = `a * cjogat;

// zero-bias depletion widths at reference temperature, needed in SRH and TAT model
wdepnulrbot   = EPSSI / CJORBOT_i;
wdepnulrsti   = XJUNSTI_i * EPSSI / CJORSTI_i;
wdepnulrgat   = XJUNGAT_i * EPSSI / CJORGAT_i;

// inverse values of "wdepnulr", used in BBT model
wdepnulrinvbot = 1 / wdepnulrbot;
wdepnulrinvsti = 1 / wdepnulrsti;
wdepnulrinvgat = 1 / wdepnulrgat;

// inverse values of built-in voltages at reference temperature, needed in SRH and BBT model
VBIRBOTinv    = 1 / VBIRBOT_i;
VBIRSTIinv    = 1 / VBIRSTI_i;
VBIRGATinv    = 1 / VBIRGAT_i;

// some constants needed in erfc-approximation, needed in TAT model
perfc         = (`SQRTPI * `aerfc);
berfc         = ((-5 * (`aerfc) + 6 - pow((perfc), -2)) / 3);
cerfc         = (1.0 - (`aerfc) - (berfc));

// half the bandgap energy, limited to values > phitd, needed in TAT model
deltaEbot     = max(0.5 * phigdbot, phitd);
deltaEsti     = max(0.5 * phigdsti, phitd);
deltaEgat     = max(0.5 * phigdgat, phitd);

// values of atat, needed in TAT model
atatbot       = deltaEbot * phitdinv;
atatsti       = deltaEsti * phitdinv;
atatgat       = deltaEgat * phitdinv;

// values of btatpart, needed in TAT model
btatpartbot   = sqrt(32 * MEFFTATBOT_i * `MELE * `QELE * (deltaEbot * deltaEbot * deltaEbot)) / (3 * `HBAR);
btatpartsti   = sqrt(32 * MEFFTATSTI_i * `MELE * `QELE * (deltaEsti * deltaEsti * deltaEsti)) / (3 * `HBAR);
btatpartgat   = sqrt(32 * MEFFTATGAT_i * `MELE * `QELE * (deltaEgat * deltaEgat * deltaEgat)) / (3 * `HBAR);

// temperature-scaled values of FBBT, needed in BBT model
fbbtbot       = FBBTRBOT_i * (1 + STFBBTBOT_i * (tkd - tkr));
fbbtsti       = FBBTRSTI_i * (1 + STFBBTSTI_i * (tkd - tkr));
fbbtgat       = FBBTRGAT_i * (1 + STFBBTGAT_i * (tkd - tkr));
fbbtbot       = `CLIP_LOW(fbbtbot, 0);
fbbtsti       = `CLIP_LOW(fbbtsti, 0);
fbbtgat       = `CLIP_LOW(fbbtgat, 0);

// parameter for current after breakdown, needed in avalanche/breakdown model
alphaav       = (FREV_i - 1) / FREV_i;

// values of fstop, needed in avalanche/breakdown model
fstopbot      = 1 / (1 - pow(alphaav, PBRBOT_i));
fstopsti      = 1 / (1 - pow(alphaav, PBRSTI_i));
fstopgat      = 1 / (1 - pow(alphaav, PBRGAT_i));

//Diode_cmc code
//  Breakdown and inverse values of breakdown voltages with temperature scaling, needed in avalanche/breakdown model
// Note that it violates the naming convention of this code. Usually we should not recalculate the <modelparameter>_i
// inside the code. However, fixing this will cause a lot more inconsistency between diode_cmc and juncap2

VBRBOT_i     = VBRBOT_i *( 1 + (tkd-tkr) * (STVBRBOT1_i + (tkd-tkr)*STVBRBOT2_i));
VBRSTI_i     = VBRSTI_i *( 1 + (tkd-tkr) * (STVBRSTI1_i + (tkd-tkr)*STVBRSTI2_i));
VBRGAT_i     = VBRGAT_i *( 1 + (tkd-tkr) * (STVBRGAT1_i + (tkd-tkr)*STVBRGAT2_i));

if (VBRBOT_i <= 0.1) begin
    VBRBOT_i   =  0.1;
    VBRinvbot  = 10.0;
end else begin
    VBRinvbot  = 1.0 / VBRBOT_i ;
end

if (VBRSTI_i <= 0.1) begin
    VBRSTI_i   =  0.1;
    VBRinvsti  = 10.0;
end else begin
    VBRinvsti  = 1.0 / VBRSTI_i ;
end

if (VBRGAT_i <= 0.1) begin
    VBRGAT_i   =  0.1;
    VBRinvgat  = 10.0;
end else begin
    VBRinvgat  = 1.0 / VBRGAT_i ;
end

shrinkL   = 1.0 - 0.01 * SHRINK_i;
//End of Diode_cmc code

// slopes for linear extrapolation close to and beyond breakdown, needed in avalanche/breakdown model
slopebot      = -(fstopbot * fstopbot * pow(alphaav, (PBRBOT_i - 1))) * PBRBOT_i * VBRinvbot;
slopesti      = -(fstopsti * fstopsti * pow(alphaav, (PBRSTI_i - 1))) * PBRSTI_i * VBRinvsti;
slopegat      = -(fstopgat * fstopgat * pow(alphaav, (PBRGAT_i - 1))) * PBRGAT_i * VBRinvgat;

//Diode_cmc code
// Series resistance calculation
resbot        = RSBOT_i * pow(auxt,STRS_i);
resgat        = RSGAT_i * pow(auxt,STRS_i);
ressti        = RSSTI_i * pow(auxt,STRS_i);
rescom        = RSCOM_i * pow(auxt,STRS_i);
//End of Diode_cmc code

//Diode_cmc recovery and high-injection equations code
NDIBOT_i = ndibot * `C_CONC;     // [cm-3] -> [m-3]
NDISTI_i = ndisti * `C_CONC;     // [cm-3] -> [m-3]
NDIGAT_i = ndigat * `C_CONC;     // [cm-3] -> [m-3]
NDI_i    = NDIBOT_i;             // [cm-3] -> [m-3]
NJL      = NFABOT_i;
MUEN_i   = `C_MUEN * `C_cm2m_p2;  // [cm2/V/sec] -> [m2/V/sec]
MUEP_i   = `C_MUEP * `C_cm2m_p2;  // [cm2/V/sec] -> [m2/V/sec]
PB       = 0.6;  //Built-in potential at P/N junction (minor) [V]
JUNCDLT  = 1e-3; //Smoothness of depletion width around zero bias (minor) [V]
//// Temperature-dependent variables
// Intrinsic Carrier Density:
Nin = `C_Nin0 * ftdbot2;
// Minority Carrier Density:
Pn0 = Nin * Nin / NDI_i;
// Ambipolar Diffusion Length:
T1 = pow(auxt, -`C_MUETMP); // temperature dependence of phonon scattering
Dn = (MUEN_i * T1) / phitdinv;
Dp = (MUEP_i * T1) / phitdinv;
Da = 2*Dn*Dp/(Dn+Dp);
T2 = pow(auxt, taut); // temperature dependence of tau
tau_HL = tau * T2;
La = sqrt(tau_HL * Da);
// High-Injection Threshold Voltages:
V_HA = (NJL / phitdinv) * ln( NDI_i / Pn0 );
V_HK = (NJL / phitdinv) * ( ln( NDI_i / Pn0 ) + wi/La );
//End of Diode_cmc recovery and high-injection equations code

// ---- end `include "DIODE_CMC_InitModel.include" ----

    end // initializeModel

    // Code independent of bias but dependent on instance parameters
    begin : initializeInstance

        // Clipping of the local model parameters
        // Note that it violates the naming convention of this code. Usually we should not recalculate the <modelparameter>_i
        // inside the code. However, fixing this will cause a lot more inconsistency between diode_cmc and juncap2

        AB_i   = `CLIP_LOW(ab  , `AB_cliplow) * SCALE_i * SCALE_i * shrinkL * shrinkL;
        LS_i   = `CLIP_LOW(ls  , `LS_cliplow) * SCALE_i * shrinkL;
        LG_i   = `CLIP_LOW(lg  , `LG_cliplow) * SCALE_i * shrinkL;

        exp_VMAX_over_phitd = 0.0;
        exp_VMAX_over_phitd_bot = 0.0;
        exp_VMAX_over_phitd_sti = 0.0;
        exp_VMAX_over_phitd_gat = 0.0;
        `JuncapInitInstance

        // Diode_cmc code
        `Juncapparametercheck
        //Total saturation current for shot noise calculation
        isattotal  = AB_i * idsatbot + LS_i * idsatsti + LG_i * idsatgat;
        // End of Diode_cmc code

        // Initialization of (global) variables; required for some verilog-A compilers
        ISATFOR1   = 0.0;
        MFOR1      = 1.0;  // The value is updated DIODE_CMC_InitModel.include
        MFOR2      = 1.0;
        ISATFOR2   = 0.0;
        MREV       = 1.0;
        ISATREV    = 0.0;
        m0flag     = 0.0;
        xhighf1    = 0.0;
        expxhf1    = 0.0;
        xhighf2    = 0.0;
        expxhf2    = 0.0;
        xhighr     = 0.0;
        expxhr     = 0.0;
        m0_rev     = 0.0;
        mcor_rev   = 0.0;
        I1_cor     = 0.0;
        I2_cor     = 0.0;
        I3_cor     = 0.0;
        I4_cor     = 0.0;
        I5_cor     = 0.0;
        tt0        = 0.0;
        tt1        = 0.0;
        tt2        = 0.0;
        zfrac      = 0.0;
        zflagbot   = 1.0;
        zflagsti   = 1.0;
        zflaggat   = 1.0;
        alphaje    = 0.0;
        tmpv       = 0.0;
        vjv        = 0.0;

        // Diode_cmc code
        `Junresistor   // calculate series resistance
        idmultbot = 0.0;
        idmultgat = 0.0;
        idmultsti = 0.0;
        // End of Diode_cmc code
        // Diode_cmc recovery and high-injection equations code
        IWnqs0_A  = 0.0;
        Inqs0_A   = 0.0;
        Inqs0_K   = 0.0;
        Q_nqs_A   = 0.0;
        Q_nqs_K   = 0.0;
        W_nqs_A   = 0.0;
        // End of Diode_cmc recovery and high-injection equations code

        q_pex0 = `QELE * AB_i;
        W_depA0 = sqrt (2 * EPSSI / (`QELE * NDI_i));
        // Punch through effect:
        `Fn_SU( W_depA0, W_depA0, wi, `C_PUNCH )

        `ExpressCodeValidation
        if (SWJUNEXP_i == 1.0) begin : JUNCAPexpressInit
            // The variables in the macro below are (re-)declared LOCALLY, to keep
            // them separated from their globally declared counterparts. This trick
            // allows one to use the "juncapcommon" macro both in the JUNCAP-express
            // initialization and in the full-JUNCAP evaluation, while in the former
            // the verilog-A compiler will still consider the variables as
            // voltage-INdependent. This is essential to avoid re-computation of the
            // JUNCAP-express initialization at each bias-step.
            `LocalGlobalVars
            // results computed here are not used elsewhere
            //                real ijunbot, ijunsti, ijungat;
            //                real ijnonbot, ijnonsti, ijnongat;
            // Initialization of (local) variables; required for some verilog-A compilers
            ysq = 0.0;
            terfc = 0.0;
            erfcpos = 0.0;
            h1 = 0.0;
            h2 = 0.0;
            h2d = 0.0;
            h3 = 0.0;
            h4 = 0.0;
            h5 = 0.0;
            VAK = 0.0;
            DQAbot  = 0.0;
            DQAsti  = 0.0;
            DQAgat  = 0.0;
            vj = 0.0;
            z = 0.0;
            zinv = 0.0;
            two_psistar = 0.0;
            vjlim = 0.0;
            vjsrh = 0.0;
            vbbt = 0.0;
            vav = 0.0;
            tmp = 0.0;
            id = 0.0;
            isrh = 0.0;
            vbi_minus_vjsrh = 0.0;
            wsrhstep = 0.0;
            dwsrh = 0.0;
            wsrh = 0.0;
            wdep = 0.0;
            asrh = 0.0;
            itat = 0.0;
            btat = 0.0;
            twoatatoverthreebtat = 0.0;
            umaxbeforelimiting = 0.0;
            umax = 0.0;
            sqrtumax = 0.0;
            umaxpoweronepointfive = 0.0;
            wgamma = 0.0;
            wtat = 0.0;
            ktat = 0.0;
            ltat = 0.0;
            mtat = 0.0;
            xerfc = 0.0;
            erfctimesexpmtat = 0.0;
            gammamax = 0.0;
            ibbt = 0.0;
            Fmaxr = 0.0;
            fbreakdown = 0.0;

            // Computation of JUNCAP-express internal parameters
            // JuncapExpressInit1 is a broken into two parts (JuncapExpressInit1 and JuncapExpressInit12) due to the size limitation of macros
            `JuncapExpressInit1

            // Diode_cmc code
            `JuncapExpressInit12
            // Diode_cmc code

            `JuncapExpressInit2
            `JuncapExpressInit3
            `JuncapExpressInit4
            `JuncapExpressInit5

        end // JUNCAPexpressInit

    end // initializeInstance

    /////////////////////////////////////////////////////////////////////////////
    //
    //  DC-bias dependent quantities (calculations for current contribs)
    //
    /////////////////////////////////////////////////////////////////////////////

    begin : evaluateStaticDynamic
        VAK = V(a, aik);

        if (SWJUNEXP_i == 1.0) begin
            `JuncapExpressCurrent(VAK)
            ijunbot = 0;
            ijunsti = 0;
            ijungat = 0;
            ijnonbot = 0;
            ijnonsti = 0;
            ijnongat = 0;
            begin : evaluateDynamic
                `JuncapExpressCharge(VAK)
            end
        end else begin
            `juncapcommon(VAK)
            ijun = AB_i * ijunbot + LS_i * ijunsti + LG_i * ijungat;
            ijnon = AB_i * ijnonbot + LS_i * ijnonsti + LG_i * ijnongat;
        end
        qjun = AB_i * qjunbot + LS_i * qjunsti + LG_i * qjungat;

        // Diode_cmc code
        VRS  = V(aik,k);

        Vtotal = V(a,k);
        // End of Diode_cmc code

    end // evaluateStaticDynamic

    // Diode_cmc code
    `Juncapcheckop(Vtotal)

    /////////////////////////////////////////////////////////////////////////////
    //
    //  Recovery charge (calculations for ddt() contribs)
    //
    /////////////////////////////////////////////////////////////////////////////

    // Diode_cmc recovery and high-injection equations code
    begin : evaluateRecoveryCharge

        if ( corecovery > 0 ) begin

            //// High-Injection part //////////////////////////////////////////////////////

            // High-Injection Coefficient for the N+/N- Junction:
            if (NJL < njh) begin
                nj_K0 = njdv * (VAK - V_HK) + NJL;
                nj0 = NJL - njdv * V_HK;
                //nj_K0 = njdv * (VAK - V_HK) + (njh + NJL)/2; //improved code but results will change
                `Fn_SU( nj_K1, nj_K0, njh, `C_NJDLT )
                `Fn_SL( nj_K,  nj_K1, NJL, `C_NJDLT )
                `Fn_SU( nj0, nj0, njh, `C_NJDLT )
                `Fn_SL( nj0, nj0, NJL, `C_NJDLT )
            end else begin //protection:
                nj_K = NJL;
                nj0 = NJL;
            end

            // Hole Density at the P+/N- Junction:
            exp_A = idmultbot;

            // Hole Density at the N+/N- Junction:
            if ( VAK - ( V_HK - V_HA ) > 0 ) begin
                `expl( phitdinv * ( VAK / nj_K - (V_HK-V_HA) / nj_K + V_HK * (nj_K-nj0) / (nj0*njh) ) ,  exp_K )
            end else begin
                exp_K = 1;
            end

            //// Carrier-distribution-based recovery model ////////////////////////////////

            /////////////////////////////////////////////////////////
            //// Injected Charge from the P+/N- Junction (Anode Side)
            /////////////////////////////////////////////////////////

            // Modification of exp_A (especially for the high-injection condition):
            if (inj2 == 0 || VAK < V_HA) begin
                exp_A2 = exp_A * inj1;
            end else begin
                exp_A2 = exp_A * inj1 * exp( - inj2*(VAK-V_HA)*(VAK-V_HA) * exp(injt*ln(tkr / tkd)) );
            end
            exp_A2 = ( exp_A2 > expceil ?  expceil : exp_A2); // safety valve

            // Hole Density at the P+/N- Junction:
            p_nA = Pn0 * exp_A2;

            // Excess Charge Density (Quasi-Static):
            q_pexA = `QELE * AB_i * ( p_nA - Pn0 );

            //// Nonquasi-Static (nqs) Effect Model Formulation
            if ( nqs > 0.0 ) begin
                Q_qs_A = q_pexA * `Q_scale;        //input: QS charge density (scaled)
                Q_nqs_A = V(charge_a) /`QV_scale;   //output: nqs charge dens. (scaled)
                Inqs0_A = (Q_nqs_A - Q_qs_A ) / nqs;      //DC current to the charge node
                // Injected Charge Density (Nonquasi-Static):
                q_pexA_nqs = Q_nqs_A / `Q_scale;   //(rescaled)
            end else begin
                Q_qs_A = q_pexA;     //input: QS charge density (unscaled)
                q_pexA_nqs = Q_qs_A; //(unscaled)
            end
            /////////////////////////////////////////////////////////
            //// Injected Charge from the N+/N- Junction (Cathode Side)
            /////////////////////////////////////////////////////////

            // Modification of exp_A (especially for the high-injection condition):
            if (inj2 == 0 || VAK < V_HK) begin
                exp_K2 = exp_K * inj1;
            end else begin
                exp_K2 = exp_K * inj1 * exp( - inj2*(VAK-V_HK)*(VAK-V_HK) * exp(injt*ln(tkr / tkd)) );
            end
            exp_K2 = ( exp_K2 > expceil ?  expceil : exp_K2); // safety valve

            // Hole Density at the N+/N- Junction:
            p_nK = Pn0 * exp_K2;

            // Excess Charge Density (Quasi-Static):
            q_pexK = `QELE * AB_i * (p_nK - Pn0);

            //// Nonquasi-Static (nqs) Effect Model Formulation
            if ( nqs > 0.0 ) begin
                Q_qs_K = q_pexK * `Q_scale;        //input: QS charge density (scaled)
                Q_nqs_K = V(charge_k) /`QV_scale;   //output: nqs charge dens. (scaled)
                Inqs0_K = (Q_nqs_K - Q_qs_K ) / nqs;      //DC current to the charge node
                // Injected Charge Density (Nonquasi-Static):
                q_pexK_nqs = Q_nqs_K / `Q_scale;   //(rescaled)
            end else begin
                Q_qs_K = q_pexK;     //input: QS charge density (unscaled)
                q_pexK_nqs = Q_qs_K; //(unscaled)
            end

            /////////////////////////////////////////////////////////
            //// Depletion part
            /////////////////////////////////////////////////////////
            //// At the P+/N- Junction:
            Vjunc_A = PB - VAK ;
            //Vjunc_A = VBIRBOT_i - VAK ; //to use the existing parameter in diode_cmc but results will change
            `Fn_SZ( Vjunc_A, Vjunc_A, JUNCDLT )
            W_depA = sqrt (2 * EPSSI * Vjunc_A / (`QELE * NDI_i));

            // Punch through effect:
            `Fn_SU( W_depA, W_depA, wi, `C_PUNCH )

            // nqs Effect on W_depA (temporary model):
            if ( depnqs > 0.0 ) begin
                W_qs_A = W_depA * `W_scale;            //input: QS value (scaled)
                W_nqs_A = V(depl_a) / `WV_scale;   //output: nqs value (scaled)
                IWnqs0_A = (W_nqs_A - W_qs_A ) / depnqs;   //DC current to the nqs node
                // Depletion Width (Nonquasi-Static):
                W_depA_nqs = W_nqs_A / `W_scale;       //(rescaled)
            end else begin
                W_qs_A = W_depA;     //input: QS value (unscaled)
                W_depA_nqs = W_qs_A; //(unscaled)
            end

            /////////////////////////////////////////////////////////
            //// Final Equations
            /////////////////////////////////////////////////////////
            //----- Analytical Integration Based on the Carrier Distribution:
            // basic majority-carrier charge:
            Q_n0 = - (NDI_i * AB_i * `QELE) * wi;
            // excess charge (Anode side):
            Q_nexA_nqs = La * q_pexA_nqs * ( exp( - wi/La ) - exp( - W_depA_nqs/La ) );
            // excess charge (Cathode side):
            Q_nexK_nqs = La * q_pexK_nqs * ( exp( - (wi - W_depA_nqs)/La ) - 1.0 );
            // depletion charge:
            //              Q_depA = + (NDI_i * AB_i * `QELE) * W_depA_nqs;

            //// Final total electron charge:
            Qrr = - ( Q_n0 + Q_nexA_nqs + Q_nexK_nqs );

            /////////////////////////////////////
            //connection with original Diode_cmc:
            /////////////////////////////////////
            qjun = qjun + Qrr;
            TT_i = 0.0; //original recovery model is inactivated

        end else begin

            Qrr = TT_i * (ijun-ijnon); //for OPinfo

        end

    end // evaluateRecoveryCharge
    // End of Diode_cmc recovery and high-injection equations code

    /////////////////////////////////////////////////////////////////////////////
    //
    //  Noise
    //
    /////////////////////////////////////////////////////////////////////////////

    begin : noise
        jnoise = (2 * `QELE) * ((ijun-ijnon) + 2 * isattotal + abs(ijnon));
        I(a, aik) <+ white_noise(jnoise, "shot");
        jfnoise = KF_i * pow(abs(ijun), AF_i);
        I(a, aik) <+ flicker_noise(jfnoise, 1.0, "flicker");
        if (restotal > 0 && restotal >= minr) begin
            jtnoise = 4 * `KBOL * tkd / restotal;
        end else begin
            jtnoise = 0.0;
        end
        I(aik,k)  <+ white_noise(jtnoise, "thermal");
    end //noise

    /////////////////////////////////////////////////////////////////////////////
    //
    //  Current contribs
    //
    /////////////////////////////////////////////////////////////////////////////

    begin : loadStatic
        I(a, aik) <+ ijun;
        I(a, aik) <+ $simparam("gmin", 0.0) * V(a, aik);
        if (restotal > 0 && restotal >= minr) begin
            I(aik,k) <+ VRS / restotal;
        end else begin
            V(aik,k) <+ 0;
        end
    end // loadStatic

    /////////////////////////////////////////////////////////////////////////////
    //
    //  nqs nodes contribs for the recovery model
    //
    /////////////////////////////////////////////////////////////////////////////

    // Diode_cmc recovery and high-injection equations code
    begin : loadRecovery
        if ( corecovery > 0 && nqs > 0.0 ) begin
            I(charge_a) <+ `QC_scale*(Inqs0_A + ddt(Q_nqs_A));
            I(charge_k) <+ `QC_scale*(Inqs0_K + ddt(Q_nqs_K));
        end else begin
            V(charge_a) <+ 0.0;
            V(charge_k) <+ 0.0;
        end
        if ( corecovery > 0 && depnqs > 0.0 ) begin
            I(depl_a) <+ `WC_scale*(IWnqs0_A + ddt(W_nqs_A));
        end else begin
            V(depl_a) <+ 0.0;
        end
    end // loadRecovery
    // End of Diode_cmc recovery and high-injection equations code

    /////////////////////////////////////////////////////////////////////////////
    //
    //  ddt() contribs from charges
    //
    /////////////////////////////////////////////////////////////////////////////

    begin : loadDynamic
        I(a, aik) <+ ddt(qjun);
        I(a, aik) <+ ddt(TT_i * (ijun-ijnon));
    end // loadDynamic
    // End of Diode_cmc code

    /////////////////////////////////////////////////////////////////////////////
    //
    // Operating point info
    //
    /////////////////////////////////////////////////////////////////////////////

    begin : OPinfo

        // The output variables defined below are currently not available in
        // Verilog-A, but only in the SiMKit-C-code which was generated from
        // this source. Similar functionality will be available in Verilog-A
        // from Verilog-A version 2.2 onwards. However, a different syntax is
        // to be used (see Verilog AMS language reference manual, version 2.2,
        // November 2004, Accellera).

        vak     = VAK;
`ifdef OPderiv
            // DQAxxx calculation is not for op output but  ADMS workaround
            DQAbot      = ddx(qjunbot, V(a));
            DQAgat      = ddx(qjungat, V(a));
            DQAsti      = ddx(qjunsti, V(a));

            cjbot   = AB_i * DQAbot;
            cjgat   = LG_i * DQAgat;
            cjsti   = LS_i * DQAsti;
            cj      = cjbot + cjgat + cjsti;
`endif // OPderiv
        if (SWJUNEXP_i == 1.0) begin
            ijbot   = 0.0;
            ijgat   = 0.0;
            ijsti   = 0.0;
        end else begin
            ijbot   = AB_i * ijunbot;
            ijgat   = LG_i * ijungat;
            ijsti   = LS_i * ijunsti;
        end
        ij      = ijun;
        si      = jnoise;

        // Diode_cmc code
        sf      = jfnoise;
        if (restotal >= minr) begin
            sr      = jtnoise;
            rseries = restotal;
            vrs     = VRS;
        end else begin
            sr      = 0.0;
            rseries = 0.0;
            vrs     = 0.0;
        end
        // End of Diode_cmc code

        // Diode_cmc recovery and high-injection equations code
        qrr     = Qrr;
        // End of Diode_cmc recovery and high-injection equations code

    end // OPinfo

end // analogBlock

endmodule
