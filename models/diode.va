// Junction diode: Shockley law with series resistance, recombination,
// high injection, breakdown, depletion charge and temperature map.
//
// Verilog-A implementation: Omar El-Sawy, University of Waterloo.
// Based on: ngspice D element (dio/dioload.c, diotemp.c, diosetup.c,
//   dionoise.c), from Berkeley SPICE3.
//   ngspice: Copyright Regents of the University of California and others,
//   modified BSD license.
//
// The junction sits on internal node `ai` behind RS; with RS = 0 the branch is
// a 0 V short and the host collapses the node (Builder.addDevice, `collapse`).
//
// Junction limiting is $limit pnjlim with ngspice's
// vcrit = vte*ln(vte/(sqrt(2)*is)). The exponent is additionally
// tangent-continued past 80*vte, not at vcrit: vcrit is a step-limiting
// threshold and converged operating points sit above it. The 80*vte guard only
// keeps unlimited evaluations (LTE probes, sweeps) finite and monotone.
//
// Temperature (diotemp.c) is bias-independent and an exact no-op at
// T == Tnom (pbfact(Tnom) == pbfact1, since 1.1150877 is egfet at 300.15 K).
//   * vte/vtr/vtebrk are k*T/q at the operating temperature.
//   * IS(T) uses the flat EG parameter (TLEV 0/1); pbfact, which moves VJ and
//     CJO, uses the silicon bandgap 1.16 - 7.02e-4*T^2/(T+1108). Same split as
//     vdmos.va and mos1.va.
//
// Geometry (diosetup.c): IS, ISR, IKF, IKR, CJO and 1/RS scale with AREA,
// JSW and CJP with PJ; LEVEL=3 takes AREA and PJ from W and L (+XW) and adds
// the metal and poly plate caps. A given JSW with NS is its own sidewall
// diode, without NS it merges into IS, as dioload.c does.
//
// ponytail: no tunnel (JTUN/NTUN/XTITUN/KEG), no TTT1/TTT2 transit-time
// tempco, no `.options scale`. Add when a deck needs one.

`include "constants.vams"
`include "disciplines.vams"

module diode(a, c);
    inout a, c;
    electrical a, c, ai;
    branch (a, ai) rsb;

    parameter real is   = 1e-14  from (0:inf);  // A    saturation current
    parameter real n    = 1.0    from (0:inf);  //      emission coefficient
    parameter real rs   = 0.0    from [0:inf);  // ohm  series resistance
    parameter real ikf  = 0.0    from [0:inf);  // A    high-injection knee (0 = off)
    parameter real isr  = 0.0    from [0:inf);  // A    recombination sat current (0 = off)
    parameter real nr   = 2.0    from (0:inf);  //      recombination emission coefficient
    parameter real bv   = 0.0    from [0:inf);  // V    reverse breakdown knee (0 = off)
    parameter real ibv  = 1e-3   from (0:inf);  // A    current magnitude at bv
    parameter real cjo  = 0.0    from [0:inf);  // F    zero-bias junction capacitance
    parameter real vj   = 1.0    from (0:inf);  // V    junction potential
    parameter real m    = 0.5    from (0:inf);  //      grading coefficient (card key `m`)
    parameter real fc   = 0.5    from (0:1);    //      forward-bias depletion coefficient
    parameter real gmin = $simparam("gmin") from [0:inf); // S  junction shunt, .options gmin
    parameter real tt   = 0.0    from [0:inf);  // s    transit time (diffusion charge)
    parameter real ikr  = 0.0    from [0:inf);  // A    reverse knee (0 = off)
    aliasparam js = is;
    aliasparam mj = m;

    // ---- geometry: instance values, model defaults (dio.c / diosetup.c) ----
    parameter integer level = 1 from [1:3];      //      3: AREA and PJ from W and L
    parameter real area = 1.0    from (0:inf);   //      area factor
    parameter real pj   = 0.0    from [0:inf);   //      perimeter factor
    aliasparam perim = pj;
    parameter real w    = 0.0    from [0:inf);   // m    width (LEVEL=3)
    parameter real l    = 0.0    from [0:inf);   // m    length (LEVEL=3)
    parameter real xw   = 0.0;                   // m    masking and etching (LEVEL=3)
    parameter real lm   = 0.0    from [0:inf);   // m    metal cap length (LEVEL=3)
    parameter real wm   = 0.0    from [0:inf);   // m    metal cap width (LEVEL=3)
    parameter real xm   = 0.0;                   // m    metal masking and etching
    parameter real xom  = 1e-6   from (0:inf);   // m    metal-to-bulk oxide
    parameter real lp   = 0.0    from [0:inf);   // m    poly cap length (LEVEL=3)
    parameter real wp   = 0.0    from [0:inf);   // m    poly cap width (LEVEL=3)
    parameter real xp   = 0.0;                   // m    poly masking and etching
    parameter real xoi  = 1e-6   from (0:inf);   // m    poly-to-bulk oxide

    // ---- sidewall junction --------------------------------------------------
    parameter real jsw  = 0.0    from [0:inf);   // A    sidewall saturation current (x PJ)
    aliasparam isw = jsw;
    parameter real ns   = 1.0    from (0:inf);   //      sidewall emission coefficient
    parameter real cjp  = 0.0    from [0:inf);   // F    sidewall zero-bias cap (x PJ)
    aliasparam cjsw = cjp;
    parameter real php  = 1.0    from (0:inf);   // V    sidewall junction potential
    aliasparam vjsw = php;
    parameter real mjsw = 0.33   from (0:inf);   //      sidewall grading
    parameter real fcs  = 0.5    from (0:1);     //      sidewall forward-bias coefficient
    parameter real ctp  = 0.0;                   // 1/K  CJP linear temp coeff (TLEVC=1)
    parameter real tphp = 0.0;                   // V/K  PHP linear temp coeff (TLEVC=1)

    // ---- temperature (diotemp.c / diosetup.c defaults) --------------------
    // tnom is in degC, like the ngspice TNOM/TREF card (diompar.c).
    parameter real tnom = $simparam("tnom");     // degC .model TNOM / TREF
    parameter real temp  = 27.0;                 // degC instance temperature, overrides $temperature
    parameter real dtemp = 0.0;                  // K    instance offset from $temperature
    parameter integer tlev  = 0 from [0:2];      // IS / EG equation selector
    parameter integer tlevc = 0 from [0:1];      // VJ / CJO equation selector
    parameter real eg   = 1.11;                  // eV   activation energy (1.16 when TLEV=2)
    parameter real gap1 = 7.02e-4;               // eV/K first bandgap correction (TLEV=2)
    parameter real gap2 = 1108.0 from (0:inf);   // K    second bandgap correction (TLEV=2)
    parameter real xti  = 3.0    from [0:inf);   //      IS temperature exponent
    parameter real nbv  = 1.0    from (0:inf);   //      breakdown emission coeff (default N)
    parameter real tcv  = 0.0;                   //      BV temperature coefficient
    parameter real tm1  = 0.0;                   // 1/K   M linear temp coeff
    parameter real tm2  = 0.0;                   // 1/K^2 M quadratic temp coeff
    parameter real cta  = 0.0;                   // 1/K   CJO linear temp coeff (TLEVC=1)
    parameter real tpb  = 0.0;                   // V/K   VJ linear temp coeff (TLEVC=1)
    parameter real trs  = 0.0;                   // 1/K   RS linear temp coeff
    parameter real trs2 = 0.0;                   // 1/K^2 RS quadratic temp coeff

    real vt, vte, vd, vcrit, u, ulim, id, ihi, wb, wlim, qj, f1, f2, f3, vfc;
    real vterec, ur, urlim, genfac, irec;
    // bias-independent temperature prep (diotemp.c)
    real tk, tnomk, ratio, dtk, vtnom, egp, nbvx, vtebrk;
    real egfet, egfet1, fact1, fact2, arg1, argt, pbfact, pbfact1;
    real pbo, gmaold, gmanew, mt, vj_t, cjo_t, is_t, isr_t, bv_t, rs_t, xbv;
    real ae, pe, issw_t, isep_t, vtsw, usw, ihisw, pbosw, gmaswold, gmaswnew, php_t, cjp_t;
    real ibvx, vfcs, ccox, epsox;

    analog begin
        // ==== diotemp.c: bias-independent temperature map ===================
        // Device temperature: the instance TEMP, else the circuit's plus
        // DTEMP (DIOtemp).
        if ($param_given(temp)) tk = temp + 273.15;
        else tk = $temperature + dtemp;
        tnomk = tnom + 273.15;
        ratio = tk / tnomk;                // diotemp.c Temp/DIOnomTemp
        dtk   = tk - tnomk;                // diotemp.c:48 `dt`
        vt    = 1.38064852e-23 / 1.6021766208e-19 * tk;
        vtnom = 1.38064852e-23 / 1.6021766208e-19 * tnomk;
        vte   = n * vt;                    // diotemp.c:39, OPERATING temp
        vtsw  = ns * vt;

        // diosetup.c: W or L without AREA/PJ resets them to 1/0; LEVEL=3
        // with both computes them from the drawn geometry.
        ae = area;
        pe = pj;
        if ($param_given(w) || $param_given(l)) begin
            if (!$param_given(area)) ae = 1.0;
            if (!$param_given(pj)) pe = 0.0;
        end
        if (level == 3 && $param_given(w) && $param_given(l)) begin
            ae = (w + xw) * (l + xw);
            pe = 2.0 * (w + xw) + 2.0 * (l + xw);
        end
        // LEVEL=3 metal and poly plate caps, epsSiO2 = 3.9/(mu0 c^2).
        epsox = 3.9 / (4.0e-7 * 3.14159265358979323846 * 299792458.0 * 299792458.0);
        ccox = 0.0;
        if (level == 3)
            ccox = epsox / xom * (wm + xm) * (lm + xm) + epsox / xoi * (wp + xp) * (lp + xp);

        // diosetup.c: EG's default depends on TLEV, so it needs the
        // given-flag; XTI/VJ/CJO/CTA/TPB/TCV/TM1/TM2 are plain defaults.
        if ($param_given(eg)) egp = eg;
        else if (tlev == 2)   egp = 1.16;
        else                  egp = 1.11;
        // diosetup.c: NBV defaults to N.
        if ($param_given(nbv)) nbvx = nbv; else nbvx = n;
        vtebrk = nbvx * vt;

        // diotemp.c: TLEV 0/1 take the hardcoded silicon curve; TLEV=2
        // takes EG/GAP1/GAP2. This egfet feeds pbfact (VJ/CJO) always, and
        // feeds IS(T) only on the TLEV=2 arm.
        if (tlev == 2) begin
            egfet  = egp - (gap1 * tk * tk)       / (tk + gap2);
            egfet1 = egp - (gap1 * tnomk * tnomk) / (tnomk + gap2);
        end else begin
            egfet  = 1.16 - (7.02e-4 * tk * tk)       / (tk + 1108.0);
            egfet1 = 1.16 - (7.02e-4 * tnomk * tnomk) / (tnomk + 1108.0);
        end

        // diotemp.c: M(T), TM1/TM2.
        mt = m * (1.0 + tm1 * dtk + tm2 * dtk * dtk);

        // diotemp.c: REFTEMP is 300.15 K, and 1.1150877 is egfet at
        // REFTEMP, which is why pbfact(Tnom) == pbfact1 exactly.
        fact1 = tnomk / 300.15;
        fact2 = tk    / 300.15;
        arg1  = -egfet1 / (2.0 * 1.38064852e-23 * tnomk)
              +  1.1150877 / (2.0 * 1.38064852e-23 * 300.15);
        argt  = -egfet  / (2.0 * 1.38064852e-23 * tk)
              +  1.1150877 / (2.0 * 1.38064852e-23 * 300.15);
        pbfact1 = -2.0 * vtnom * (1.5 * ln(fact1) + 1.6021766208e-19 * arg1);
        pbfact  = -2.0 * vt    * (1.5 * ln(fact2) + 1.6021766208e-19 * argt);

        // diotemp.c: VJ(T), CJO(T). The C's divide-by-Tnom-bracket,
        // multiply-by-T-bracket written as one ratio (1 at T == Tnom).
        if (tlevc == 1) begin
            vj_t  = vj  - tpb * (tk - 300.15);
            cjo_t = cjo * (1.0 + cta * (tk - 300.15));
        end else begin
            pbo    = (vj - pbfact1) / fact1;
            gmaold = (vj - pbo) / pbo;
            vj_t   = pbfact + fact2 * pbo;
            gmanew = (vj_t - pbo) / pbo;
            cjo_t  = cjo * (1.0 + mt * (400e-6 * (tk    - 300.15) - gmanew))
                         / (1.0 + mt * (400e-6 * (tnomk - 300.15) - gmaold));
        end
        cjo_t = cjo_t * ae;

        // Sidewall PHP(T), CJP(T), same maps with MJSW (no TM1/TM2).
        if (tlevc == 1) begin
            php_t = php - tphp * (tk - 300.15);
            cjp_t = cjp * pe * (1.0 + ctp * (tk - 300.15));
        end else begin
            pbosw    = (php - pbfact1) / fact1;
            gmaswold = (php - pbosw) / pbosw;
            php_t    = pbfact + fact2 * pbosw;
            gmaswnew = (php_t - pbosw) / pbosw;
            cjp_t    = cjp * pe * (1.0 + mjsw * (400e-6 * (tk    - 300.15) - gmaswnew))
                                / (1.0 + mjsw * (400e-6 * (tnomk - 300.15) - gmaswold));
        end

        // diotemp.c IS(T), TLEV 0/1 and TLEV 2. vte, not vtnom, in the EG
        // term, as in ngspice.
        if (tlev == 2)
            is_t = is * ae * exp(egfet1 / (n * vtnom) - egfet / vte + (xti / n) * ln(ratio));
        else
            is_t = is * ae * exp((ratio - 1.0) * egp / vte + (xti / n) * ln(ratio));
        // JSW(T) with NS. A given NS makes it its own diode; otherwise it
        // joins IS (dioload.c).
        if (tlev == 2)
            issw_t = jsw * pe * exp(egfet1 / (ns * vtnom) - egfet / vtsw + (xti / ns) * ln(ratio));
        else
            issw_t = jsw * pe * exp((ratio - 1.0) * egp / vtsw + (xti / ns) * ln(ratio));
        isep_t = 0.0;
        if ($param_given(ns)) isep_t = issw_t;
        else is_t = is_t + issw_t;

        // diotemp.c: ISR(T) rides NR and reuses XTI.
        vterec = nr * vt;
        if (tlev == 2)
            isr_t = isr * ae * exp(egfet1 / (nr * vtnom) - egfet / vterec + (xti / nr) * ln(ratio));
        else
            isr_t = isr * ae * exp((ratio - 1.0) * egp / vterec + (xti / nr) * ln(ratio));

        // diotemp.c: BV(T); TLEV 0 is subtractive, TLEV 1/2 scaling.
        if (tlev == 0) bv_t = bv - tcv * dtk;
        else           bv_t = bv * (1.0 - tcv * dtk);

        // diotemp.c: the breakdown knee xbv, placed so the breakdown branch
        // -is(T)*exp(-(xbv+vd)/vtebrk) carries IBV at vd = -BV(T). An IBV
        // too small to resolve against IS keeps xbv = BV(T).
        // ponytail: one refinement of ngspice's fixed-point loop, which
        // meets its reltol*IBV test on that first pass for any real card.
        // IS here is the total, sidewall included; LEVEL=3 scales IBV by
        // the area.
        ibvx = (level == 3) ? ibv * ae : ibv;
        xbv = bv_t;
        if (bv > 0.0 && ibvx >= (is_t + isep_t) * bv_t / vt) begin
            xbv = bv_t - vtebrk * ln(1.0 + ibvx / (is_t + isep_t));
            xbv = bv_t - vtebrk * ln(ibvx / (is_t + isep_t) + 1.0 - xbv / vt);
        end

        // diotemp.c: RS(T). Floored like vdmos.va's rtemp(): the quadratic
        // can be driven <= 0 and the stamp below divides by it.
        rs_t = rs * (1.0 + trs * dtk + trs2 * dtk * dtk) / ae;
        if (rs_t < 1.0e-9) rs_t = 1.0e-9;

        // ==== bias-dependent ================================================
        // pnjlim first, where dioload.c runs it. The tangent continuation
        // below guards evaluations at unlimited voltage.
        vcrit = vte * ln(vte / (1.4142135623730951 * (is_t + isep_t)));   // diotemp.c
        vd  = $limit(V(ai, c), "pnjlim", vte, vcrit);

        // Forward/reverse ideal current, tangent-continued past 80*vte.
        // Clamped in ratio space so the finiteness prover sees exp's argument
        // bounded by the literal 80.
        u     = vd / vte;
        ulim  = min(u, 80.0);
        // Below -3*vte dioload.c swaps the exponential for the cubic tail
        // -is*(1 + (3*vte/(e*vd))^3), continuous at -3*vte.
        if (vd >= -3.0 * vte)
            id = is_t * ((exp(ulim) * (1.0 + (u - ulim))) - 1.0);
        else
            id = -is_t * (1.0 + pow(3.0 * vte / (vd * 2.718281828459045), 3.0));
        ihisw = 0.0;
        if (isep_t > 0.0) begin
            usw = vd / vtsw;
            if (vd >= -3.0 * vtsw)
                ihisw = isep_t * ((exp(min(usw, 80.0)) * (1.0 + (usw - min(usw, 80.0)))) - 1.0);
            else
                ihisw = -isep_t * (1.0 + pow(3.0 * vtsw / (vd * 2.718281828459045), 3.0));
        end

        // ISR/NR recombination current (dioload.c), forward region only
        // (vd >= -3*vte): isr(T)*(e^{vd/(nr*vt)}-1)
        // times the depletion generation factor ((1-vd/vj(T))^2+0.005)^(M(T)/2).
        // NR multiplies the raw vt, not vte. Same tangent continuation past 80.
        irec = 0.0;
        if (isr > 0.0 && vd >= -3.0 * vte) begin
            ur     = vd / vterec;
            urlim  = min(ur, 80.0);
            genfac = pow((1.0 - vd / vj_t) * (1.0 - vd / vj_t) + 0.005, mt / 2.0);
            irec   = isr_t * ((exp(urlim) * (1.0 + (ur - urlim))) - 1.0) * genfac;
        end

        // Reverse breakdown (dioload.c): past -xbv each junction current is
        // REPLACED by -is(T)*exp(-(xbv+vd)/vtebrk), vtebrk = NBV*vt; it
        // reads -is at the knee and -IBV at -BV(T). Armed off the raw bv, as
        // ngspice's DIObreakdownVoltageGiven, and only below -3*vte, where
        // ngspice's forward branch ends. ngspice runs a mirrored pnjlim here,
        // which $limit cannot spell; the tangent continuation past
        // 80*vtebrk keeps Newton finite instead. Ratio-space clamp, as above.
        if (bv > 0.0 && vd < -3.0 * vte && vd < -xbv) begin
            wb   = -(xbv + vd) / vtebrk;
            wlim = min(wb, 80.0);
            id    = -is_t * exp(wlim) * (1.0 + (wb - wlim));
            ihisw = -isep_t * exp(wlim) * (1.0 + (wb - wlim));
        end

        // Knee roll-off (dioload.c): cd / (1 + sqrt(cd/(IKF*AREA))) on the
        // total forward current, recombination and sidewall included; IKR
        // likewise below -3*vte. IKF/IKR have no temperature coefficient.
        ihi = id + ihisw + irec;
        if (ikf > 0.0 && ihi > 0.0)
            ihi = ihi / (1.0 + sqrt(ihi / (ikf * ae)));
        if (ikr > 0.0 && vd < -3.0 * vte && ihi < -1.0e-18)
            ihi = ihi / (1.0 + sqrt(ihi / (-ikr * ae)));

        I(ai, c) <+ ihi + gmin * vd;

        // Noise (LRM §4.6.4, dionoise.c): shot noise of the junction current,
        // 2q|Id|, across (DIOposPrimeNode, DIOnegNode) = (ai, c); RS thermal
        // noise is in the series branch below. Flicker is gated on KF, which
        // ngspice defaults to 0 and this model does not carry.
        I(ai, c) <+ white_noise(2.0 * 1.6021766208e-19 * abs(ihi), "id");

        // One junction charge, depletion plus diffusion, in one ddt site:
        // ngspice truncates it as the single state DIOcapCharge (diotrunc.c).
        qj = 0.0;
        // Depletion charge, CJO(T)/VJ(T)/M(T). Below fc*vj(T) it is the exact
        // integral of cjo(T)*(1-v/vj(T))^-M(T); above it the linearized
        // f1/f2/f3 continuation (diotemp.c) avoids the singularity at v = vj.
        if (cjo > 0.0) begin
            vfc = fc * vj_t;
            if (vd < vfc) begin
                qj = cjo_t * vj_t * (1.0 - pow(1.0 - vd / vj_t, 1.0 - mt)) / (1.0 - mt);
            end else begin
                f1 = vj_t * (1.0 - pow(1.0 - fc, 1.0 - mt)) / (1.0 - mt);
                f2 = pow(1.0 - fc, 1.0 + mt);
                f3 = 1.0 - fc * (1.0 + mt);
                qj = cjo_t * (f1 + (1.0 / f2) *
                     (f3 * (vd - vfc) + (mt / (2.0 * vj_t)) * (vd * vd - vfc * vfc)));
            end
        end

        // Sidewall depletion charge, CJP(T)/PHP(T)/MJSW. Above FCS*PHP the
        // continuation reuses the bottom junction's F1, as dioload.c does.
        if (cjp > 0.0) begin
            vfcs = fcs * php_t;
            if (vd < vfcs) begin
                qj = qj + cjp_t * php_t * (1.0 - pow(1.0 - vd / php_t, 1.0 - mjsw)) / (1.0 - mjsw);
            end else begin
                f1 = vj_t * (1.0 - pow(1.0 - fc, 1.0 - mt)) / (1.0 - mt);
                qj = qj + cjp_t * f1 + cjp_t / pow(1.0 - fcs, 1.0 + mjsw)
                     * ((1.0 - fcs * (1.0 + mjsw)) * (vd - vfcs) + (mjsw / (2.0 * php_t)) * (vd * vd - vfcs * vfcs));
            end
        end
        qj = qj + ccox * vd;

        // Diffusion charge TT*cd (dioload.c), cd the whole junction current
        // including the gmin shunt, so its small-signal cap is TT*gd.
        if (tt > 0.0) qj = qj + tt * (ihi + gmin * vd);
        I(ai, c) <+ ddt(qj);

        // Guard on the raw rs: node collapse is a topology decision and must
        // not depend on temperature. rs_t is floored above.
        // RS thermal noise 4kT/rs(T) (dionoise.c) across (DIOposPrimeNode,
        // DIOposNode). With rs == 0 the node is collapsed and the generator
        // contributes nothing, as in ngspice.
        if (rs > 0.0) begin
            I(rsb) <+ V(rsb) / rs_t;
            I(rsb) <+ white_noise(4.0 * 1.38064852e-23 * tk / rs_t, "rs");
        end else V(rsb) <+ 0.0;
    end
endmodule
