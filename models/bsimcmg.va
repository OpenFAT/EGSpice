// *  BSIM-CMG 112.1.0 released on 04/28/2026                            *
// *  BSIM Common Multi-Gate Model (Verilog-A)                                *
// ****************************************************************************

// ****************************************************************************
// *  Copyright © 2026 University of California                               *
// *                                                                          *
// *  Project director: Prof. Sayeef Salahuddin                               *
// *                    Prof. Chenming Hu                                     *
// *                                                                          *
// *  Developers: https://www.bsim.berkeley.edu/models/bsimcmg/auth_cmg/      *
// ****************************************************************************

`include "constants.vams"
`include "disciplines.vams"
// ---- begin `include "bsimcmg_macros.include" ----
// *  BSIM-CMG 112.1.0 released on 04/28/2026                            *
// *  BSIM Common Multi-Gate Model (Verilog-A)                                *
// ****************************************************************************

// ****************************************************************************
// *  Copyright © 2026 University of California                               *
// *                                                                          *
// *  Project director: Prof. Sayeef Salahuddin                               *
// *                    Prof. Chenming Hu                                     *
// *                                                                          *
// *  Developers: https://www.bsim.berkeley.edu/models/bsimcmg/auth_cmg/      *
// ****************************************************************************

// Model types
`define ntype 1
`define ptype -1

// Numerical constants
`define EXPL_THRESHOLD 80.0
`define MAX_EXPL 5.540622384e34
`define MIN_EXPL 1.804851387e-35
`define N_MINLOG 1.0e-38
`define LN_N_MINLOG -87.498233534
`define DELTA_1 0.02
`define CONSTCtoK 273.15
`define REFTEMP 300.15
`define ONE_OV_3 0.333333333
`define TWO_OV_3 0.666666667
`define FOUR_OV_3 1.333333333

// Physical constants
`define q 1.60219e-19
`define EPS0 8.8542e-12
`define HBAR 1.05457e-34
`define MEL 9.11e-31
`define KboQ 8.617087e-5

// // Clamped exponential
// `define lexp(x) ((x > `EXPL_THRESHOLD) ? `MAX_EXPL * (1.0 + x - `EXPL_THRESHOLD) : (x < -`EXPL_THRESHOLD) ? `MIN_EXPL : exp(x))

// // Clamped logarithm
// `define llnf(x) ((x > `N_MINLOG) ? ln(x) : `LN_N_MINLOG)

// // Hyperbolic smoothing
// `define hypsmooth(x, c) ((x < -1e4 * (c)) ? (-(c) * (c) / (x)) : (0.5 * (x + sqrt((x) * (x) + 4.0 * (c) * (c)))))

// // Hyperbolic smoothing with a maximum value
// `define hypmax(x, xmin, c) (xmin + 0.5 * (x - (xmin) - c + sqrt((x - (xmin) - c) * (x - (xmin) - c) - 4.0 * (xmin) * c)))

// // Smoothing with a minimum value
// `define smoothminx(x, x0, deltax) (0.5 * (x + x0 + sqrt((x - (x0)) * (x - (x0)) + 0.25 * deltax * deltax)))

// // Smoothing with a maximum value
// `define smoothmaxx(x, x0, deltax) (0.5 * (x + x0 - sqrt((x - (x0)) * (x - (x0)) + 0.25 * deltax * deltax)) + 0.25 * deltax)

// // Smoothing with a maximum value
// `define smoothmaxx2(x, x0, deltax) (0.5 * (x + x0 - sqrt((x - (x0)) * (x - (x0)) + 0.25 * deltax * deltax)))

// //Gamma function
// `define gammafunc(x) (0.0385 * exp(-4.6 * (x-1)) + 7.5893e-7 * pow(2*(x) - 3, 8) + 6.9583e-5 * pow(2*(x-1), 6) - 6.583e-4 * pow(2*(x-1), 5) + 0.0065 * pow(2*(x-1), 4) - 0.026 * pow(2*(x-1), 3) + 0.1371 * pow(2*(x-1), 2) - 0.194 * 2*(x-1) + 0.959)

// Temperature dependence
`define tempdep(param_t, param_i, t_term) \
begin \
    if (tempmod != 0) begin \
        param_t = param_i + hypmax(t_term * delTemp, -param_i, 1.0e-6); \
    end else begin \
        param_t = param_i * hypsmooth((1.0 + t_term * delTemp - 1.0e-6), 1.0e-3); \
    end \
end

// Quadratic temperature dependence
`define tempdep2(param_t, param_i, t_term1, t_term2) \
begin \
    if (tempmod != 0) begin \
        param_t = param_i + hypmax((t_term1 * delTemp + t_term2 * delTemp * delTemp), -param_i, 1.0e-6); \
    end else begin \
        param_t = param_i * hypsmooth((1.0 + t_term1 * delTemp + t_term2 * delTemp * delTemp - 1.0e-6), 1.0e-3); \
    end \
end

// Binning equations
`define binning(param_i, r_term, l_term, n_term, p_term, w_term, wl_term) \
begin \
    param_i = r_term + Inv_L * l_term + Inv_NFIN * n_term + Inv_LNFIN * p_term + Inv_W * w_term + Inv_WL * wl_term; \
end

// nfin scaling
`define nfin_scaling(param_i, n1_term, n2_term) \
begin \
    if (n1_term != 0.0) begin \
        param_i = param_i * (1.0 + n1_term / nfin * llnf(1.0 + nfin / n2_term)); \
    end \
end

// nfinnom scaling
`define nfinnom_scaling(param_i, lt_term) \
begin \
    param_i = param_i * (1.0 + (nfin - nfinnom) * lt_term * Leff); \
end

// Length scaling
`define length_scaling(param, a_term, b_term) \
begin \
    param = param + a_term * lexp(-Leff / b_term); \
end

// Length scaling for CV
`define length_scaling_CV(param, a_term, b_term) \
begin \
    param = param + a_term * lexp(-LeffCV / b_term); \
end

// Junction capacitance
`define juncap_bias_indep(SJ, PB_t, MJ, MJ2, vec, pb2) \
begin \
    if (SJ > 0.0) begin \
        vec = PB_t * (1.0 - pow((1.0 / SJ), (1.0 / MJ))); \
        pb2 = PB_t * SJ * MJ2 / MJ / pow((1.0 - vec / PB_t), -(1.0 + MJ)); \
    end \
end

`define junction_cap(block_name, vex, vec, pb2, Cz, PB, SJ, MJ, MJ2, Qej) \
begin: block_name \
    real T1, T2, T3, T4, T5; \
    real arg, sarg, Qec; \
    \
    if (Cz > 0.0) begin \
        T1 = vex / PB; \
        if (T1 < 0.9) begin \
            if (SJ > 0.0) begin \
                if (vex > vec) begin \
                    arg = 1.0 - T1; \
                    if (MJ != 1) begin \
                        if (MJ == 0.5) begin \
                            sarg = 1.0 / sqrt(arg); \
                        end else begin \
                            sarg = pow(arg, -MJ); \
                        end \
                        Qej = PB * Cz * (1.0 - arg * sarg) / (1.0 - MJ); \
                    end else begin \
                        Qej = -PB * Cz * llnf(arg); \
                    end \
                end else begin \
                    arg = 1.0 - vec / PB; \
                    if (MJ != 1) begin \
                        if (MJ == 0.5) begin \
                            sarg = 1.0 / sqrt(arg); \
                        end else begin \
                            sarg = pow(arg, -MJ); \
                        end \
                        Qec = PB * Cz * (1.0 - arg * sarg) / (1.0 - MJ); \
                    end else begin \
                        Qec = -PB * Cz * llnf(arg); \
                    end \
                    arg = 1.0 - (vex - vec) / pb2; \
                    if (MJ2 != 1) begin \
                        if (MJ2 == 0.5) begin \
                            sarg = 1.0 / sqrt(arg); \
                        end else begin \
                            sarg = pow(arg, -MJ2); \
                        end \
                        Qej = Qec + SJ * pb2 * Cz * (1.0 - arg * sarg) / (1.0 - MJ2); \
                    end else begin \
                        Qej = Qec - SJ * pb2 * Cz * llnf(arg); \
                    end \
                end \
            end else begin \
                arg = 1.0 - T1; \
                if (MJ != 1) begin \
                    if (MJ == 0.5) begin \
                        sarg = 1.0 / sqrt(arg); \
                    end else begin \
                        sarg = pow(arg, -MJ); \
                    end \
                    Qej = PB * Cz * (1.0 - arg * sarg) / (1.0 - MJ); \
                end else begin \
                    Qej = -PB * Cz * llnf(arg); \
                end \
            end \
        end else begin \
            if (MJ != 1) begin \
                if (MJ == 0.5) begin \
                    T2 = 1.0 / sqrt(0.1); \
                end else begin \
                    T2 = pow(0.1, -MJ); \
                end \
                T3 = 1.0 / (1.0 - MJ); \
                T5 = T3 * (1.0 - 0.05 * MJ * (1.0 + MJ) * T2); \
            end else begin \
                T2 = 10.0; \
                T5 = 1.5 - ln(0.1); \
            end \
            T4 = T2 * (T1 - 1.0) * (5.0 * MJ * (T1 - 1.0) + (1.0 + MJ)); \
            Qej = PB * Cz * (T4 + T5); \
        end \
    end else begin \
        Qej = 0.0; \
    end \
end

// Geometry-dependent fringe capacitance
`define cfringe_2d(Hg, Hc, Wfin, Cf1, Cgg) \
begin \
    Hr = 2.3 + 0.2 * (Hg + toxp) / Hc; \
    Lr = 1.05; \
    Hgdelta = abs(Hg + toxp - Hc); \
    Lmax = lsp * Lr; \
    y = min(Hc, Hg + toxp); \
    x = lsp / (Hr + 1.0); \
    Cnon = 1.7e12; \
    CcgSat = epssp * (y - x) / lsp; \
    TT1 = Cnon * CcgSat; \
    if (TT1 > `EXPL_THRESHOLD) begin \
        Ccg1 = CcgSat; \
    end else begin \
        Ccg1 = 1.0 / Cnon * ln_one_plus_exp(TT1); \
    end \
    r1cf = 0.5 * min(Hc / (Hg + toxp), (Hg + toxp) / Hc); \
    Rcf = Hgdelta * r1cf; \
    Ccg2 = epssp * 2.0 / `M_PI * llnf((lsp + 0.5 * `M_PI * Rcf) / lsp); \
    Ccg = Wfin * (Ccg1 + Ccg2); \
    x = Lmax / Hg; \
    C1 = 4.0 / (sqrt(2.0 * (x + 1.0)) * `M_PI); \
    C2 = sqrt(toxp * toxp + 2.0 * Hg * toxp + Hg * Hg * (x + 1.0)) * sqrt(x + 1.0) + toxp + Hg * x + Hg; \
    C3 = toxp * sqrt((x + 1.0) * (x + 4.0)) + toxp * (x + 2.0); \
    Cfglog = epssp * (C1 * llnf(C2 / C3) + 12.27); \
    dcf = Hr * Lr; \
    TT0 = sqrt(dcf * dcf + 1.0); \
    TT1 = sqrt((dcf * dcf + 1.0) * ((dcf * toxp) * (dcf * toxp) + 2.0 * dcf * Lmax * toxp + (dcf * dcf + 1.0) * Lmax * Lmax)) + dcf * toxp + dcf * dcf * Lmax + Lmax; \
    TT2 = (TT0 + 1.0) * (dcf * toxp); \
    Cfgsat = 2.0 * epssp * sqrt(2.0) / `M_PI * (Cf1) * dcf / TT0 * llnf(TT1 / TT2); \
    delta = 1.2e-12; \
    TT1 = Cfgsat - Cfglog - delta; \
    Cfg = Wfin * (Cfgsat - 0.5 * (TT1 + sqrt(TT1 * TT1 + 4.0 * delta * Cfgsat))); \
    Cgg = Ccg + Cfg; \
end

//  Macros for the model/instance parameters
//  OPP: operating point parameter, includes units and description for printing
//  MPRxx: model parameter real
//  MPIxx: model parameter integer
//  IPRxx: instance parameter real
//  IPIxx: instance parameter integer
//  BPRxx: both model and instance parameter real
//  BPIxx: both model and instance parameter integer
//     ||
//     cc: closed lower bound, closed upper bound
//     oo: open lower bound, open upper bound
//     co: closed lower bound, open upper bound
//     oc: open lower bound, closed upper bound
//     cz: closed lower bound = 0, open upper bound = inf
//     oz: open lower bound = 0, open upper bound = inf
//     nb: no bounds
//     ex: no bounds with exclude
//     sw: switch (integer only, values 0 = false and 1 = true)
//     ty: switch (integer only, values -1 = p-type and +1 = n-type)
`define OPP(nam, uni, des) (* units = uni, desc = des *) real nam;
`define OPM(nam,uni,des)   (* units=uni, desc=des, multiplicity="multiply" *)  real    nam;
`define OPD(nam,uni,des)   (* units=uni, desc=des, multiplicity="divide"   *)  real    nam;
`define BPRco(nam, def, uni, lwr, upr, des) (* units = uni, type = "instance", desc = des *) parameter real nam = def from[lwr : upr);
`define BPRoc(nam, def, uni, lwr, upr, des) (* units = uni, type = "instance", desc = des *) parameter real nam = def from(lwr : upr];
`define BPRoz(nam, def, uni, des) (* units = uni, type = "instance", desc = des *) parameter real nam = def from(0.0 : inf);
`define BPRcz(nam, def, uni, des) (* units = uni, type = "instance", desc = des *) parameter real nam = def from[0.0 : inf);
`define BPRnb(nam, def, uni, des) (* units = uni, type = "instance", desc = des *) parameter real nam = def;
`define BPRoo(nam, def, uni, lwr, upr, des) (* units = uni, type = "instance", desc = des *) parameter real nam = def from(lwr : upr);
`define BPIcc(nam, def, uni, lwr, upr, des) (* units = uni, type = "instance", desc = des *) parameter integer nam = def from[lwr : upr];
`define IPIco(nam, def, uni, lwr, upr, des) (* units = uni, type = "instance", desc = des *) parameter integer nam = def from[lwr : upr);
`define MPRnb(nam, def, uni, des) (* units = uni, desc = des *) parameter real nam = def;
`define MPRex(nam, def, uni, exc, des) (* units = uni, desc = des *) parameter real nam = def exclude exc;
`define MPRcc(nam, def, uni, lwr, upr, des) (* units = uni, desc = des *) parameter real nam = def from[lwr : upr];
`define MPRoo(nam, def, uni, lwr, upr, des) (* units = uni, desc = des *) parameter real nam = def from(lwr : upr);
`define MPRco(nam, def, uni, lwr, upr, des) (* units = uni, desc = des *) parameter real nam = def from[lwr : upr);
`define MPRcz(nam, def, uni, des) (* units = uni, desc = des *) parameter real nam = def from[0.0 : inf);
`define MPRoz(nam, def, uni, des) (* units = uni, desc = des *) parameter real nam = def from(0.0 : inf);
`define MPIcc(nam, def, uni, lwr, upr, des) (* units = uni, desc = des *) parameter integer nam = def from[lwr : upr];
`define MPIty(nam, def, uni, des) (* units = uni, desc = des *) parameter integer nam = def from[ -1: 1] exclude 0;
// ---- end `include "bsimcmg_macros.include" ----
module bsimcmg_va(d, g, s, e, t);
    inout d, g, s, e, t;
    electrical d, g, s, e;
    electrical di, si, di1, si1, di2;
    electrical ge, gi, gint, gints, gintd;
    electrical q;
    electrical n;
    thermal t;
// ---- begin `include "bsimcmg_parameters.include" ----
// *  BSIM-CMG 112.1.0 released on 04/28/2026                            *
// *  BSIM Common Multi-Gate Model (Verilog-A)                                *
// ****************************************************************************

// ****************************************************************************
// *  Copyright © 2026 University of California                               *
// *                                                                          *
// *  Project director: Prof. Sayeef Salahuddin                               *
// *                    Prof. Chenming Hu                                     *
// *                                                                          *
// *  Developers: https://www.bsim.berkeley.edu/models/bsimcmg/auth_cmg/      *
// ****************************************************************************

// Both model and instance parameters
`BPRco(l, 3.0e-8, "m", 1.0e-9, inf, "Designed gate length")
`BPRco(lover, 3.0e-8, "m", 1.0e-20, inf, "Designed overlap length")
`BPRco(dia, 4.0e-8, "m", 1.0e-9, inf, "Diameter of the cylinder (geomod = 3)")
`BPRco(tfin, 1.5e-8, "m", 1.0e-9, inf, "Fin thickness")
`BPRco(fpitch, 8.0e-8, "m", tfin, inf, "Fin pitch")
`BPRoz(nfin, 1.0, "", "Number of fins per finger (real number enables optimization)")
`BPIcc(ngcon, 1, "", 1, 2, "Number of gate contact (1 or 2 sided)")
`BPRcz(aseo, 0.0, "m^2", "Source-to-substrate overlap area through oxide")
`BPRcz(adeo, 0.0, "m^2", "Drain-to-substrate overlap area through oxide")
`BPRcz(pseo, 0.0, "m", "Perimeter of source-to-substrate overlap region through oxide")
`BPRcz(pdeo, 0.0, "m", "Perimeter of drain-to-substrate overlap region through oxide")
`BPRcz(asej, 0.0, "m^2", "Source junction area (bulkmod = 1 or 2)")
`BPRcz(adej, 0.0, "m^2", "Drain junction area (bulkmod = 1 or 2)")
`BPRcz(psej, 0.0, "m", "Source-to-substrate PN junction perimeter (bulkmod = 1 or 2)")
`BPRcz(pdej, 0.0, "m", "Drain-to-substrate PN junction perimeter (bulkmod = 1 or 2)")
`BPRcz(cgsp, 0.0, "F/m", "Constant gate-to-source fringe capacitance (cgeomod = 1)")
`BPRcz(cgdp, 0.0, "F/m", "Constant gate-to-drain fringe capacitance (cgeomod = 1)")
`BPRcz(cdsp, 0.0, "F", "Constant drain-to-source fringe capacitance (all cgeomod)")
`BPRcz(nrs, 0.0, "", "Number of source diffusion squares")
`BPRcz(nrd, 0.0, "", "Number of drain diffusion squares")
`BPRoz(lrsd, l, "m", "Length of the source/drain")
`BPRcz(nfinnom, 0.0, "", "If non-zero, nominal number of fins per finger")
`BPRnb(dtemp, 0.0, "degC", "Variability in device temperature")
`BPRnb(delvtrand, 0.0, "V", "Variability in Vth")
`BPRoz(u0mult, 1.0, "", "Variability in carrier mobility")
`BPRcz(ids0mult, 1.0, "", "Variability in drain current for miscellaneous reasons")
`BPRcz(igc0mult, 1.0, "", "Gate to channel current scale factor")
`BPRcz(igb0mult, 1.0, "", "Gate to body current scale factor")

`BPRnb(covs, 0.0, "F/m", "Constant gate-to-source overlap capacitance (cgeomod = 1)")
`MPRnb(lcovs, 0.0, "F", "L-term of covs")
`MPRnb(ncovs, 0.0, "F/m", "N-term of covs")
`MPRnb(pcovs, 0.0, "F", "P-term of covs")
`MPRnb(wcovs, 0.0, "F", "W-term of covs")
`MPRnb(p2covs, 0.0, "F*m", "WL-term of covs")

`BPRnb(covd, covs, "F/m", "Constant gate-to-drain overlap capacitance (cgeomod = 1)")
`MPRnb(lcovd, lcovs, "F", "L-term of covd")
`MPRnb(ncovd, ncovs, "F/m", "N-term of covd")
`MPRnb(pcovd, pcovs, "F", "P-term of covd")
`MPRnb(wcovd, wcovs, "F", "W-term of covd")
`MPRnb(p2covd, p2covs, "F*m", "WL-term of covd")

//Gate-All-Around FET specific instance/model parameters
`BPRoo(tgaa, 5.0e-9, "m", 0.0, inf, "Thickness of individual GAA bodies")
`BPRoo(tsus, 2.0e-9, "m", 0.0, inf, "Separation between GAA bodies")
`BPRoo(hpff, 5.0e-9, "m", 0.0, inf, "Fin-height of parasitic finFET")
`BPRoo(wgaa, 6.0e-9, "m", 0.0, inf, "GAA body width")
`BPRoc(dws1, 0, "m", -inf, 0.0, "Total width correction for 1st GAA body")
`BPRoc(dach1, 0, "m^2", -inf, 0.0, "Total area correction for 1st GAA body")
`BPRoc(dws2, dws1, "m", -inf, 0.0, "Total width correction for 2nd GAA body")
`BPRoc(dach2, dach1,"m^2", -inf, 0.0, "Total area correction for 2nd GAA body")
`BPRoc(dws3, dws1, "m", -inf, 0.0, "Total width correction for 3rd GAA body")
`BPRoc(dach3, dach1, "m^2", -inf, 0.0, "Total area correction for 3rd GAA body")
`BPRoc(dws4, dws1, "m", -inf, 0.0, "Total width correction for 4th GAA body")
`BPRoc(dach4, dach1, "m^2", -inf, 0.0, "Total area correction for 4th GAA body")
`BPRoc(dws5, dws1, "m", -inf, 0.0, "Total width correction for 5th GAA body")
`BPRoc(dach5, dach1, "m^2", -inf, 0.0, "Total area correction for 5th GAA body")
`BPRoc(dws6, dws1, "m", -inf, 0.0, "Total width correction for 6th GAA body")
`BPRoc(dach6, dach1, "m^2", -inf, 0.0, "Total area correction for 6th GAA body")
`BPIcc(ngaa, 1, "", 0, 6, "Number of GAA bodies per fin")
`BPIcc(subbandmod, 0, "", 0, 1, "Switch for GAAFET quantum subband model (0: off; 1: on)")
`BPIcc(mobscmod, 0, "", 0, 1, "Switch for GAAFET geometry dependent mobility model (0: off; 1: on)")

// Pure instance parameters
`IPIco(nf, 1, "", 1, inf, "Number of fingers")

// Pure model parameters
`MPIty(type, `ntype, "", "1: NMOS; -1: PMOS")
`MPIcc(bulkmod, 0, "", 0, 2, "0: SOI multi-gate; 1: Bulk multi-gate; 2: for decoupled bulk multi-gate")
`MPIcc(geomod, 0, "", 0, 5, "0: Double gate; 1: Triple gate; 2: Quadruple gate; 3: Cylindrical gate; 4: Unified fin Shape; 5: GAAFETs")
`MPIcc(cgeo1sw, 0, "", 0, 1, "For cgeomod = 1 only, this switch enables the parameters covs, covd, cgsp, and cgdp to be in F per fin, per gate-finger, per unit channel width")
`MPIcc(rdsmod, 0, "", 0, 2, "0: Bias-dependent S/D resistances internal and bias-independent S/D resistances external, 1: Both bias-dependent and independent of S/D resistances external, 2: Both bias-dependent and independent of S/D resistances internal")
`MPIcc(hvmod, 0, "", 0, 1, "0: LDMOS charges off, 1: LDMOS charges on")
`MPIcc(asymmod, 0, "", 0, 1, "0: Turn off asymmetry model - forward mode parameters used; 1: Turn on asymmetry model")
`MPIcc(cvmod, 0, "", 0, 1, "0: Consistent I-V & C-V, 1: Decoupled I-V & C-V")
`MPIcc(igcmod, 0, "", 0, 1, "0: Turn off Igc, Igs and Igd; 1: Turn on Igc, Igs and Igd")
`MPIcc(igbmod, 0, "", 0, 1, "0: Turn off Igb; 1: Turn on Igb")
`MPIcc(gidlmod, 0, "", 0, 3, "0: Turn off GIDL/GISL current; 1: Turn on GIDL/GISL current; 2: Turn on GIDL/GISL with parasitic substrate component for geomod = 2 or 3 or 5 and bulkmod != 0; 3: Turn on TAT GIDL/GISL with all features of gidlmod = 2")
`MPIcc(iimod, 0, "", 0, 2, "0: Turn off impact ionization current; 1: BSIM4-based model; 2: BSIMSOI-based model")
`MPIcc(tnoimod, 0, "", 0, 1, "0: Charge-based, 1: Correlated thermal noise model")
`MPIcc(nqsmod, 0, "", 0, 2, "0: Turn off NQS model; 1: NQS gate resistance (with gi node); 2: NQS charge deficit model from BSIM4 (with q node)")
`MPIcc(shmod, 0, "", 0, 1, "0: Turn off self-heating; 1: Turn on self-heating")
`MPIcc(tempmod, 0, "", 0, 1, "1: Change temperature dependence of specific parameters")
`MPIcc(rgatemod, 0, "", 0, 2, "0: Turn off gate electrode resistance (without ge node); 1: Turn on gate electrode resistance (with ge node); 2: Improved bias-dependence with source/drain branching")
`MPIcc(rgeomod, 0, "", 0, 1, "Geometry-dependent source/drain resistance; 0: RSH-based; 1: Holistic")
`MPIcc(cgeomod, 0, "", 0, 3, "Geometry-dependent parasitic capacitance model selector")
`MPIcc(fnmod  ,0 ,"" ,0 ,2 ,"0: Old flicker noise model; 1: New flicker noise model; 2: Flicker noise model for pure number fluctuations")
`MPIcc(cryomod, 0, "", 0, 2, "0: Turn off cryogenic temperature model; 1: Most physical cryogenic temperature models; 2: Cryogenic models converge to BSIM-CMG 111.1.0 temperature models for T > 210 K")
`MPIcc(sh_warn, 0, "", 0, 1, "0: Disable self-heating warnings; 1: Enable self-heating warnings")
`MPIcc(igclamp, 1, "", 0, 1, "0: Disable gate current clamps; 1: Enable gate current clamps")
`MPRnb(ll, 0.0, "m^(lln+1)", "Length reduction parameter (dopant diffusion effect)")
`MPRnb(lln, 1.0, "", "Length reduction parameter (dopant diffusion effect)")
`MPRnb(dlc, 0.0, "m", "Delta l for C-V model")
`MPRnb(dlcacc, 0.0, "m", "Delta l for C-V model in accumulation region (bulkmod = 1 or 2)")
`MPRnb(dwcacc, 0.0, "m", "GAA delta W for C-V model in accumulation region (bulkmod = 1 or 2)")
`MPRnb(llc, 0.0, "m^(lln+1)", "Length reduction parameter (dopant diffusion effect)")
`MPRco(eot, 1.0e-9, "m", 1.0e-10, inf, "Equivalent oxide thickness")
`MPRco(toxp, 1.2e-9, "m", 1.0e-10, inf, "Physical oxide thickness")
`MPRco(eotbox, 1.4e-7, "m", 1.0e-9, inf, "Equivalent oxide thickness of the buried oxide (SOI FinFET)")
`MPRco(hfin, 3.0e-8, "m", 1.0e-9, inf, "Fin height")
`MPRnb(deltaw, 0.0, "m", "Change of effective width due to shape of fin/cylinder")
`MPRnb(deltawcv, 0.0, "m", "CV change of effective width due to shape of fin/cylinder")
`MPRnb(nbodyn1, 0.0, "", "nfin dependence of channel (body) doping")
`MPRex(nbodyn2, 1.0e5, "", 0.0, "nfin dependence of channel (body) doping")
`MPRcc(nsd, 2.0e26, "/m^3", 2.0e25, 1.0e27, "Source/drain active doping concentration")
`MPRnb(phigl, 0.0, "eV/m", "Length dependence of gate workfunction")
`MPRnb(phiglt, 0.0, "/m", "Coupled nfin and length dependence of gate workfunction")
`MPRnb(phign1, 0.0, "", "nfin dependence of gate workfunction")
`MPRex(phign2, 1.0e5, "", 0.0, "nfin dependence of gate workfunction")
`MPRco(epsrox, 3.9, "", 1.0, inf, "Relative dielectric constant of the gate dielectric")
`MPRco(epsrsub, 11.9, "", 1.0, inf, "Relative dielectric constant of the channel material")
`MPRcz(easub, 4.05, "eV", "Electron affinity of substrate")
`MPRoz(ni0sub, 1.1e16, "/m^3", "Intrinsic carrier constant at 300.15K")
`MPRoz(bg0sub, 1.12, "eV", "Bandgap of substrate at 300.15K")
`MPRoz(nc0sub, 2.86e25, "/m^3", "Conduction band density of states")
`MPRoz(imin, 1.0e-15, "A/m^2", "Parameter for Vgs clamping for inversion region calculation in accumulation")

`BPRnb(xl, 0.0, "m", "L offset for channel length due to mask/etch effect")
`MPRnb(lxl, 0.0, "m^2", "L-term of xl")
`MPRnb(nxl, 0.0, "m", "N-term of xl")
`MPRnb(pxl, 0.0, "m^2", "P-term of xl")

`MPRnb(lint, 0.0, "m", "Length reduction parameter (dopant diffusion effect)")
`MPRnb(llint, 0.0, "m^2", "L-term of lint")
`MPRnb(nlint, 0.0, "m", "N-term of lint")
`MPRnb(plint, 0.0, "m^2", "P-term of lint")

`MPRnb(dlbin, 0.0, "m", "Delta l for binning")
`MPRnb(ldlbin, 0.0, "m^2", "L-term of dlbin")
`MPRnb(ndlbin, 0.0, "m", "N-term of dlbin")
`MPRnb(pdlbin, 0.0, "m^2", "P-term of dlbin")

`BPRnb(xw, 0.0, "m", "W offset for GAA channel width due to mask/etch effect")
`MPRnb(lxw, 0.0, "m^2", "L-term of xw")
`MPRnb(nxw, 0.0, "m", "N-term of xw")
`MPRnb(pxw, 0.0, "m^2", "P-term of xw")
`MPRnb(wxw, 0.0, "m^2", "W-term of xw")
`MPRnb(p2xw, 0.0, "m^3", "WL-term of xw")

`MPRnb(dwbin, 0.0, "m", "GAA Delta W for binning")
`MPRnb(ldwbin, 0.0, "m^2", "L-term of dwbin")
`MPRnb(ndwbin, 0.0, "m", "N-term of dwbin")
`MPRnb(pdwbin, 0.0, "m^2", "P-term of dwbin")
`MPRnb(wdwbin, 0.0, "m^2", "W-term of dwbin")
`MPRnb(p2dwbin, 0.0, "m^3", "WL-term of dwbin")

`MPRnb(nbody, 1.0e22, "/m^3", "Channel (body) doping")
`MPRnb(lnbody, 0.0, "/m^2", "L-term of nbody")
`MPRnb(nnbody, 0.0, "/m^3", "N-term of nbody")
`MPRnb(pnbody, 0.0, "/m^2", "P-term of nbody")

`MPRnb(phig, 4.61, "eV", "Gate workfunction")
`MPRnb(lphig, 0.0, "m*eV", "L-term of phig")
`MPRnb(nphig, 0.0, "eV", "N-term of phig")
`MPRnb(pphig, 0.0, "m*eV", "P-term of phig")
`MPRnb(wphig, 0.0, "m*eV", "W-term of phig")
`MPRnb(p2phig, 0.0, "(m^2)*eV", "WL-term of phig")

`MPRnb(vfbdriftd, -0.2, "V", "Drift region flat-band voltage")
`MPRnb(vfbdrifts, -0.2, "V", "Drift region flat-band voltage")

`MPRnb(ngate, 0.0, "/m^3", "Parameter for poly gate doping. For metal gate please set ngate = 0")
`MPRnb(lngate, 0.0, "/m^2", "L-term of ngate")
`MPRnb(nngate, 0.0, "/m^3", "N-term of ngate")
`MPRnb(pngate, 0.0, "/m^2", "P-term of ngate")
`MPRnb(wngate, 0.0, "/m^2", "W-term of ngate")
`MPRnb(p2ngate, 0.0, "/m", "WL-term of ngate")

// Minimum resistance value
`MPRcz(minr, $simparam("minr", 1m), "Ohm", "minr is the value below which the simulator expects elimination of source/drain resitance and it will improve simulation efficiency without significantly altering the results")

// Short channel effects
`MPRnb(cdscn1, 0.0, "", "nfin dependence of cdsc")
`MPRex(cdscn2, 1.0e5, "", 0.0, "nfin dependence of cdsc")
`MPRnb(cdscdn1, 0.0, "", "nfin dependence of cdscd")
`MPRex(cdscdn2, 1.0e5, "", 0.0, "nfin dependence of cdscd")
`MPRnb(cdscdrn1, cdscdn1, "", "nfin dependence of cdscd")
`MPRex(cdscdrn2, cdscdn2, "", 0.0, "nfin dependence of cdscd")
`MPRnb(eta0n1, 0.0, "", "nfin dependence of eta0")
`MPRco(eta0n2, 1.0e5, "", 1.0e-5, inf, "nfin dependence of eta0")
`MPRnb(eta0lt, 0.0, "/m", "Coupled nfin and length dependence of eta0")
`MPRnb(eta0n1cv, eta0n1, "", "nfin dependence of eta0cv")
`MPRco(eta0n2cv, eta0n2, "", 1.0e-5, inf, "nfin dependence of eta0cv")
`MPRnb(eta0ltcv, eta0lt, "/m", "Coupled nfin and length dependence of eta0cv")
`MPRnb(teta0, 0.0, "/K", "Temperature dependence of DIBL coefficient")
`MPRnb(teta0cv, teta0, "/K", "cvmod = 1 temperature dependence of DIBL coefficient")
`MPRnb(teta0r, teta0, "/K", "Temperature dependence of reverse-mode DIBL coefficient")
`MPRnb(advtp0, 0.0, "", "Pre-exponential coefficient for DITS")
`MPRex(bdvtp0, 1.0e-7, "", 0.0, "Exponential coefficient for DITS")
`MPRnb(advtp1, 0.0, "", "Pre-exponential coefficient for dvtp1")
`MPRex(bdvtp1, 1.0e-7, "", 0.0, "Exponential coefficient for dvtp1")
`MPRnb(dvtp2, 0.0, "", "DITS model parameter")
`MPRnb(thetasce, 0.0, "", "User-designated Vth roll-off length dependence.")
`MPRnb(thetadibl, 0.0, "", "User-designated DIBL length dependence.")
`MPRnb(thetasw, 0.0, "", "User-designated subthreshold swing length dependence.")
`MPRcz(nvtm, 0.0, "V", "If non-zero, subthreshold swing factor multiplied by Vtm.")

`MPRnb(dvtp0, 0.0, "", "Coefficient for drain-induced Vth shift (DITS)")
`MPRnb(ldvtp0, 0.0, "m", "L-term of dvtp0")
`MPRnb(ndvtp0, 0.0, "", "N-term of dvtp0")
`MPRnb(pdvtp0, 0.0, "m", "P-term of dvtp0")
`MPRnb(wdvtp0, 0.0, "m", "W-term of dvtp0")
`MPRnb(p2dvtp0, 0.0, "m^2", "WL-term of dvtp0")

`MPRnb(dvtp1, 0.0, "", "DITS exponent coefficient")
`MPRnb(ldvtp1, 0.0, "m", "L-term of dvtp1")
`MPRnb(ndvtp1, 0.0, "", "N-term of dvtp1")
`MPRnb(pdvtp1, 0.0, "m", "P-term of dvtp1")
`MPRnb(wdvtp1, 0.0, "m", "W-term of dvtp1")
`MPRnb(p2dvtp1, 0.0, "m^2", "WL-term of dvtp1")

`MPRnb(cit, 0.0, "F/m^2", "Parameter for interface traps")
`MPRnb(lcit, 0.0, "F/m", "L-term of cit")
`MPRnb(ncit, 0.0, "F/m^2", "N-term of cit")
`MPRnb(pcit, 0.0, "F/m", "P-term of cit")
`MPRnb(wcit, 0.0, "F/m", "W-term of cit")
`MPRnb(p2cit, 0.0, "F", "WL-term of cit")

`MPRnb(citr, cit, "F/m^2", "Parameter for interface traps in reverse mode for asymmetric model")
`MPRnb(lcitr, lcit, "F/m", "L-term of citr")
`MPRnb(ncitr, ncit, "F/m^2", "N-term of citr")
`MPRnb(pcitr, pcit, "F/m", "P-term of citr")
`MPRnb(wcitr, wcit, "F/m", "W-term of citr")
`MPRnb(p2citr, p2cit, "F", "WL-term of citr")

`MPRnb(cdsc, 7.0e-3, "F/m^2", "Coupling capacitance between S/D and channel")
`MPRnb(lcdsc, 0.0, "F/m", "L-term of cdsc")
`MPRnb(ncdsc, 0.0, "F/m^2", "N-term of cdsc")
`MPRnb(pcdsc, 0.0, "F/m", "P-term of cdsc")
`MPRnb(wcdsc, 0.0, "F/m", "W-term of cdsc")
`MPRnb(p2cdsc, 0.0, "F", "WL-term of cdsc")

`MPRnb(cdscd, 7.0e-3, "F/m^2", "Drain-bias sensitivity of cdsc")
`MPRnb(lcdscd, 0.0, "F/m", "L-term of cdscd")
`MPRnb(ncdscd, 0.0, "F/m^2", "N-term of cdscd")
`MPRnb(pcdscd, 0.0, "F/m", "P-term of cdscd")
`MPRnb(wcdscd, 0.0, "F/m", "W-term of cdscd")
`MPRnb(p2cdscd, 0.0, "F", "WL-term of cdscd")

`MPRnb(cdscdr, cdscd, "F/m^2", "Reverse-mode drain-bias sensitivity of cdsc")
`MPRnb(lcdscdr, lcdscd, "F/m", "L-term of cdscdr")
`MPRnb(ncdscdr, ncdscd, "F/m^2", "N-term of cdscdr")
`MPRnb(pcdscdr, pcdscd, "F/m", "P-term of cdscdr")
`MPRnb(wcdscdr, wcdscd, "F/m", "W-term of cdscdr")
`MPRnb(p2cdscdr, p2cdscd, "F", "WL-term of cdscdr")

`MPRnb(dvt0, 0.0, "", "SCE coefficient")
`MPRnb(ldvt0, 0.0, "m", "L-term of dvt0")
`MPRnb(ndvt0, 0.0, "", "N-term of dvt0")
`MPRnb(pdvt0, 0.0, "m", "P-term of dvt0")
`MPRnb(wdvt0, 0.0, "m", "W-term of dvt0")
`MPRnb(p2dvt0, 0.0, "m^2", "WL-term of dvt0")

`MPRnb(dvt1, 0.6, "", "SCE exponent coefficient. After binning it should be within (0 : inf)")
`MPRnb(ldvt1, 0.0, "m", "L-term of dvt1")
`MPRnb(ndvt1, 0.0, "", "N-term of dvt1")
`MPRnb(pdvt1, 0.0, "m", "P-term of dvt1")
`MPRnb(wdvt1, 0.0, "m", "W-term of dvt1")
`MPRnb(p2dvt1, 0.0, "m^2", "WL-term of dvt1")

`MPRnb(dvt1ss, dvt1, "", "Subthreshold swing exponent coefficient. After binning it should be within (0 : inf)")
`MPRnb(ldvt1ss, ldvt1, "m", "L-term of dvt1ss")
`MPRnb(ndvt1ss, ndvt1, "", "N-term of dvt1ss")
`MPRnb(pdvt1ss, pdvt1, "m", "P-term of dvt1ss")
`MPRnb(wdvt1ss, wdvt1, "m", "W-term of dvt1ss")
`MPRnb(p2dvt1ss, p2dvt1, "m^2", "WL-term of dvt1ss")

`MPRnb(phin, 0.05, "V", "Nonuniform vertical doping effect on surface potential")
`MPRnb(lphin, 0.0, "m*V", "L-term of phin")
`MPRnb(nphin, 0.0, "V", "N-term of phin")
`MPRnb(pphin, 0.0, "m*V", "P-term of phin")
`MPRnb(wphin, 0.0, "m*V", "W-term of phin")
`MPRnb(p2phin, 0.0, "(m^2)*V", "WL-term of phin")

`MPRnb(eta0, 0.6, "", "DIBL coefficient")
`MPRnb(leta0, 0.0, "m", "L-term of eta0")
`MPRnb(neta0, 0.0, "", "N-term of eta0")
`MPRnb(peta0, 0.0, "m", "P-term of eta0")
`MPRnb(weta0, 0.0, "m", "W-term of eta0")
`MPRnb(p2eta0, 0.0, "m^2", "WL-term of eta0")

`MPRnb(eta1, 0.0, "", "DIBL coefficient for low gate overdrive")
`MPRnb(leta1, 0.0, "m", "L-term of eta1")
`MPRnb(neta1, 0.0, "", "N-term of eta1")
`MPRnb(peta1, 0.0, "m", "P-term of eta1")
`MPRnb(weta1, 0.0, "m", "W-term of eta1")
`MPRnb(p2eta1, 0.0, "m^2", "WL-term of eta1")

`MPRnb(eta0r, eta0, "", "Reverse-mode DIBL coefficient")
`MPRnb(leta0r, leta0, "m", "L-term of eta0r")
`MPRnb(neta0r, neta0, "", "N-term of eta0r")
`MPRnb(peta0r, peta0, "m", "P-term of eta0r")
`MPRnb(weta0r, weta0, "m", "W-term of eta0r")
`MPRnb(p2eta0r, p2eta0, "m^2", "WL-term of eta0r")

`MPRnb(eta0cv, eta0, "", "cvmod = 1 DIBL coefficient")
`MPRnb(leta0cv, leta0, "m", "L-term of eta0cv")
`MPRnb(neta0cv, neta0, "", "N-term of eta0cv")
`MPRnb(peta0cv, peta0, "m", "P-term of eta0cv")
`MPRnb(weta0cv, weta0, "m", "W-term of eta0cv")
`MPRnb(p2eta0cv, p2eta0, "m^2", "WL-term of eta0cv")

`MPRnb(dsub, 1.06, "", "DIBL exponent coefficient")
`MPRnb(ldsub, 0.0, "m", "L-term of dsub")
`MPRnb(ndsub, 0.0, "", "N-term of dsub")
`MPRnb(pdsub, 0.0, "m", "P-term of dsub")
`MPRnb(wdsub, 0.0, "m", "W-term of dsub")
`MPRnb(p2dsub, 0.0, "m^2", "WL-term of dsub")

`MPRnb(k1rsce, 0.0, "V^0.5", "k1 for reverse short channel effect calculation")
`MPRnb(lk1rsce, 0.0, "m*V^0.5", "L-term of k1rsce")
`MPRnb(nk1rsce, 0.0, "V^0.5", "N-term of k1rsce")
`MPRnb(pk1rsce, 0.0, "m*V^0.5", "P-term of k1rsce")
`MPRnb(wk1rsce, 0.0, "m*V^0.5", "W-term of k1rsce")
`MPRnb(p2k1rsce, 0.0, "(m^2)*V^0.5", "WL-term of k1rsce")

`MPRnb(lpe0, 5.0e-9, "m", "Equivalent length of pocket region at zero bias")
`MPRnb(llpe0, 0.0, "m^2", "L-term of lpe0")
`MPRnb(nlpe0, 0.0, "m", "N-term of lpe0")
`MPRnb(plpe0, 0.0, "m^2", "P-term of lpe0")
`MPRnb(wlpe0, 0.0, "m^2", "W-term of lpe0")
`MPRnb(p2lpe0, 0.0, "m^3", "WL-term of lpe0")

`MPRnb(dvtshift, 0.0, "V", "Vth shift handle")
`MPRnb(ldvtshift, 0.0, "m*V", "L-term of dvtshift")
`MPRnb(ndvtshift, 0.0, "V", "N-term of dvtshift")
`MPRnb(pdvtshift, 0.0, "m*V", "P-term of dvtshift")
`MPRnb(wdvtshift, 0.0, "m*V", "W-term of dvtshift")
`MPRnb(p2dvtshift, 0.0, "(m^2)*V", "WL-term of dvtshift")

`MPRnb(dvtshiftr, dvtshift, "V", "Vth shift handle for asymmetric mode")
`MPRnb(ldvtshiftr, ldvtshift, "m*V", "L-term of dvtshiftr")
`MPRnb(ndvtshiftr, ndvtshift, "V", "N-term of dvtshiftr")
`MPRnb(pdvtshiftr, pdvtshift, "m*V", "P-term of dvtshiftr")
`MPRnb(wdvtshiftr, wdvtshift, "m*V", "W-term of dvtshiftr")
`MPRnb(p2dvtshiftr, p2dvtshift, "(m^2)*V", "WL-term of dvtshiftr")

// Lateral non-uniform doping effect (Vth shift between I-V and C-V)
`MPRnb(k0, 0.0, "V", "Lateral nud voltage parameter")
`MPRnb(lk0, 0.0, "m*V", "L-term of k0")
`MPRnb(nk0, 0.0, "V", "N-term of k0")
`MPRnb(pk0, 0.0, "m*V", "P-term of k0")
`MPRnb(wk0, 0.0, "m*V", "W-term of k0")
`MPRnb(p2k0, 0.0, "(m^2)*V", "WL-term of k0")

`MPRnb(k01, 0.0, "V/K", "Temperature dependence of lateral nud voltage parameter")
`MPRnb(lk01, 0.0, "(m*V)/K", "L-term of k01")
`MPRnb(nk01, 0.0, "V/K", "N-term of k01")
`MPRnb(pk01, 0.0, "(m*V)/K", "P-term of k01")
`MPRnb(wk01, 0.0, "(m*V)/K", "W-term of k01")
`MPRnb(p2k01, 0.0, "(m^2)*V/K", "WL-term of k01")

`MPRnb(k0si, 1.0, "", "Correction factor for strong inversion used in Mnud. After binning it should be within (0 : inf)")
`MPRnb(lk0si, 0.0, "m", "L-term of k0si")
`MPRnb(nk0si, 0.0, "", "N-term of k0si")
`MPRnb(pk0si, 0.0, "m", "P-term of k0si")
`MPRnb(wk0si, 0.0, "m", "W-term of k0si")
`MPRnb(p2k0si, 0.0, "m^2", "WL-term of k0si")

`MPRnb(k0si1, 0.0, "/K", "Temperature dependence of k0si")
`MPRnb(lk0si1, 0.0, "m/K", "L-term of k0si1")
`MPRnb(nk0si1, 0.0, "/K", "N-term of k0si1")
`MPRnb(pk0si1, 0.0, "m/K", "P-term of k0si1")
`MPRnb(wk0si1, 0.0, "m/K", "W-term of k0si1")
`MPRnb(p2k0si1, 0.0, "m^2/K", "WL-term of k0si1")

`MPRnb(k2si, k0si, "", "Correction factor for strong inversion used in Mob")
`MPRnb(lk2si, lk0si, "m", "L-term of k2si")
`MPRnb(nk2si, nk0si, "", "N-term of k2si")
`MPRnb(pk2si, pk0si, "m", "P-term of k2si")
`MPRnb(wk2si, wk0si, "m", "W-term of k2si")
`MPRnb(p2k2si, p2k0si, "m^2", "WL-term of k2si")

`MPRnb(k2si1, k0si1, "/K", "Temperature dependence of k2si")
`MPRnb(lk2si1, lk0si1, "m/K", "L-term of k2si1")
`MPRnb(nk2si1, nk0si1, "/K", "N-term of k2si1")
`MPRnb(pk2si1, pk0si1, "m/K", "P-term of k2si1")
`MPRnb(wk2si1, wk0si1, "m/K", "W-term of k2si1")
`MPRnb(p2k2si1, p2k0si1, "m^2/K", "WL-term of k2si1")

`MPRnb(k0sisat, 0.0, "", "Correction factor for strong inversion used in Mnud")
`MPRnb(lk0sisat, 0.0, "m", "L-term of k0sisat")
`MPRnb(nk0sisat, 0.0, "", "N-term of k0sisat")
`MPRnb(pk0sisat, 0.0, "m", "P-term of k0sisat")
`MPRnb(wk0sisat, 0.0, "m", "W-term of k0sisat")
`MPRnb(p2k0sisat, 0.0, "m^2", "WL-term of k0sisat")

`MPRnb(k0sisat1, 0.0, "", "Temperature dependence of k0sisat")
`MPRnb(lk0sisat1, 0.0, "m", "L-term of k0sisat1")
`MPRnb(nk0sisat1, 0.0, "", "N-term of k0sisat1")
`MPRnb(pk0sisat1, 0.0, "m", "P-term of k0sisat1")
`MPRnb(wk0sisat1, 0.0, "m", "W-term of k0sisat1")
`MPRnb(p2k0sisat1, 0.0, "m^2", "WL-term of k0sisat1")

`MPRnb(k2sisat, k0sisat, "", "Correction factor for strong inversion used in Mob")
`MPRnb(lk2sisat, lk0sisat, "m", "L-term of k2sisat")
`MPRnb(nk2sisat, nk0sisat, "", "N-term of k2sisat")
`MPRnb(pk2sisat, pk0sisat, "m", "P-term of k2sisat")
`MPRnb(wk2sisat, wk0sisat, "m", "W-term of k2sisat")
`MPRnb(p2k2sisat, p2k0sisat, "m^2", "WL-term of k2sisat")

`MPRnb(k2sisat1, k0sisat1, "", "Temperature dependence of k2sisat")
`MPRnb(lk2sisat1, lk0sisat1, "m", "L-term of k2sisat1")
`MPRnb(nk2sisat1, nk0sisat1, "", "N-term of k2sisat1")
`MPRnb(pk2sisat1, pk0sisat1, "m", "P-term of k2sisat1")
`MPRnb(wk2sisat1, wk0sisat1, "m", "W-term of k2sisat1")
`MPRnb(p2k2sisat1, p2k0sisat1, "m^2", "WL-term of k2sisat1")

// Body effect for bulk substrate
`MPRnb(phibe, 0.7, "V", "Body effect voltage parameter. After binning it should be within [0.2 : 1.2]")
`MPRnb(lphibe, 0.0, "m*V", "L-term of phibe")
`MPRnb(nphibe, 0.0, "V", "N-term of phibe")
`MPRnb(pphibe, 0.0, "m*V", "P-term of phibe")
`MPRnb(wphibe, 0.0, "m*V", "W-term of phibe")
`MPRnb(p2phibe, 0.0, "(m^2)*V", "WL-term of phibe")

`MPRnb(k1, 1.0e-6, "V^0.5", "Body effect coefficient for subthreshold region")
`MPRnb(lk1, 0.0, "m*V^0.5", "L-term of k1")
`MPRnb(nk1, 0.0, "V^0.5", "N-term of k1")
`MPRnb(pk1, 0.0, "m*V^0.5", "P-term of k1")
`MPRnb(wk1, 0.0, "m*V^0.5", "W-term of k1")
`MPRnb(p2k1, 0.0, "(m^2)*V^0.5", "WL-term of k1")

`MPRnb(k11, 0.0, "V^0.5/K", "Temperature dependence of k1")
`MPRnb(lk11, 0.0, "m*V^0.5/K", "L-term of k11")
`MPRnb(nk11, 0.0, "V^0.5/K", "N-term of k11")
`MPRnb(pk11, 0.0, "m*V^0.5/K", "P-term of k11")
`MPRnb(wk11, 0.0, "m*V^0.5/K", "W-term of k11")
`MPRnb(p2k11, 0.0, "(m^2)*V^0.5/K", "WL-term of k11")

`MPRnb(k2sat, 0.0, "", "Correction factor for k2 in saturation (high Vds)")
`MPRnb(lk2sat, 0.0, "m", "L-term of k2sat")
`MPRnb(nk2sat, 0.0, "", "N-term of k2sat")
`MPRnb(pk2sat, 0.0, "m", "P-term of k2sat")
`MPRnb(wk2sat, 0.0, "m", "W-term of k2sat")
`MPRnb(p2k2sat, 0.0, "m^2", "WL-term of k2sat")

`MPRnb(k2sat1, 0.0, "", "Temperature dependence of k2sat")
`MPRnb(lk2sat1, 0.0, "m", "L-term of k2sat1")
`MPRnb(nk2sat1, 0.0, "", "N-term of k2sat1")
`MPRnb(pk2sat1, 0.0, "m", "P-term of k2sat1")
`MPRnb(wk2sat1, 0.0, "m", "W-term of k2sat1")
`MPRnb(p2k2sat1, 0.0, "m^2", "WL-term of k2sat1")

`MPRnb(k2, 0.0, "", "Body effect coefficient for bulkmod = 2")
`MPRnb(lk2, 0.0, "m", "L-term of k2")
`MPRnb(nk2, 0.0, "", "N-term of k2")
`MPRnb(pk2, 0.0, "m", "P-term of k2")
`MPRnb(wk2, 0.0, "m", "W-term of k2")
`MPRnb(p2k2, 0.0, "m^2", "WL-term of k2")

`MPRnb(k21, 0.0, "", "Temperature dependence of k2")
`MPRnb(lk21, 0.0, "m", "L-term of k21")
`MPRnb(nk21, 0.0, "", "N-term of k21")
`MPRnb(pk21, 0.0, "m", "P-term of k21")
`MPRnb(wk21, 0.0, "m", "W-term of k21")
`MPRnb(p2k21, 0.0, "m^2", "WL-term of k21")

// Quantum mechanical effect
`MPRnb(aqmtcen, 0.0, "", "Parameter for geometric dependence of Tcen on R/tfin/hfin")
`MPRex(bqmtcen, 1.2e-8, "", 0.0, "Parameter for geometric dependence of Tcen on R/tfin/hfin")
`MPRoz(qm0, 1.0e-3, "V", "Knee-point for Tcen in inversion (Charge normalized to Cox)")
`MPRoz(qm0acc, 1.0e-3, "V", "Knee-point for Tcen in accumulation (Charge normalized to Cox)")
`MPRnb(pqmacc, 0.66, "", "Slope of normalized Tcen in accumulation")

`MPRnb(qmfactor, 0.0, "", "Prefactor + switch for QM Vth correction")
`MPRnb(lqmfactor, 0.0, "m", "L-term of qmfactor")
`MPRnb(nqmfactor, 0.0, "", "N-term of qmfactor")
`MPRnb(pqmfactor, 0.0, "m", "P-term of qmfactor")
`MPRnb(wqmfactor, 0.0, "m", "W-term of qmfactor")
`MPRnb(p2qmfactor, 0.0, "m^2", "WL-term of qmfactor")

`MPRnb(qmtcencv, 0.0, "", "Prefactor + switch for QM Width and Toxeff correction for CV")
`MPRnb(lqmtcencv, 0.0, "m", "L-term of qmtcencv")
`MPRnb(nqmtcencv, 0.0, "", "N-term of qmtcencv")
`MPRnb(pqmtcencv, 0.0, "m", "P-term of qmtcencv")
`MPRnb(wqmtcencv, 0.0, "m", "W-term of qmtcencv")
`MPRnb(p2qmtcencv, 0.0, "m^2", "WL-term of qmtcencv")

`MPRnb(qmtcencva, 0.0, "", "Prefactor + switch for QM Width and Toxeff correction for CV (accumulation region)")
`MPRnb(lqmtcencva, 0.0, "m", "L-term of qmtcencva")
`MPRnb(nqmtcencva, 0.0, "", "N-term of qmtcencva")
`MPRnb(pqmtcencva, 0.0, "m", "P-term of qmtcencva")
`MPRnb(wqmtcencva, 0.0, "m", "W-term of qmtcencva")
`MPRnb(p2qmtcencva, 0.0, "m^2", "WL-term of qmtcencva")

`MPRnb(pqm, 0.66, "", "Slope of normalized Tcen in inversion")
`MPRnb(lpqm, 0.0, "m", "L-term of pqm")
`MPRnb(npqm, 0.0, "", "N-term of pqm")
`MPRnb(ppqm, 0.0, "m", "P-term of pqm")
`MPRnb(wpqm, 0.0, "m", "W-term of pqm")
`MPRnb(p2pqm, 0.0, "m^2", "WL-term of pqm")

`MPRnb(pqml, 0.0, "/m", "Length dependence of pqm")

// Velocity saturation model
`MPRnb(vsatn1, 0.0, "", "nfin dependence of vsat")
`MPRex(vsatn2, 1.0e5, "", 0.0, "nfin dependence of vsat")
`MPRnb(avsat, 0.0, "", "Pre-exponential coefficient for vsat")
`MPRex(bvsat, 1.0e-7, "", 0.0, "Exponential coefficient for vsat")
`MPRnb(vsat1n1, vsatn1, "", "nfin dependence of vsat1")
`MPRex(vsat1n2, vsatn2, "", 0.0, "nfin dependence of vsat1")
`MPRnb(vsat1rn1, vsat1n1, "", "nfin dependence of vsat1r")
`MPRex(vsat1rn2, vsat1n2, "", 0.0, "nfin dependence of vsat1r")
`MPRnb(avsat1, avsat, "", "Pre-exponential coefficient for vsat1")
`MPRex(bvsat1, bvsat, "", 0.0, "Exponential coefficient for vsat1")
`MPRnb(apsat, 0.0, "", "Pre-exponential coefficient for psat")
`MPRex(bpsat, 1.0, "", 0.0, "Exponential coefficient for psat")
`MPRnb(avsatcv, avsat, "", "Pre-exponential coefficient for vsatcv")
`MPRex(bvsatcv, bvsat, "", 0.0, "Exponential coefficient for vsatcv")
`MPRnb(apsatcv, apsat, "", "Pre-exponential coefficient for psatcv")
`MPRex(bpsatcv, bpsat, "", 0.0, "Exponential coefficient for psatcv")
`MPRnb(amexp, 0.0, "", "Pre-exponential coefficient for mexp")
`MPRnb(bmexp, 1.0, "", "Exponential coefficient for mexp")
`MPRnb(amexpr, amexp, "", "Pre-exponential coefficient for mexpr")
`MPRnb(bmexpr, bmexp, "", "Exponential coefficient for mexpr")
`MPRnb(aptwg, 0.0, "", "Pre-exponential coefficient for ptwg")
`MPRex(bptwg, 1.0e-7, "", 0.0, "Exponential coefficient for ptwg")
`MPRnb(tmexp, 0.0, "/K", "Temperature coefficient for Vdseff smoothing")
`MPRnb(tmexp2, -4.0e-6, "/K^2", "cryomod != 0 temperature coefficient for Vdseff smoothing")
`MPRnb(tmexpr, tmexp, "/K", "Reverse-mode temperature coefficient for Vdseff smoothing")
`MPRco(dvsatclamp, 0.01, "m", 0.01, inf, "Minimum clamp on Dvsat")

`MPRnb(vsatdr, 8.5e4, "m/s", "Saturation velocity for the saturation region under overlap")
`MPRnb(vsat, 8.5e4, "m/s", "Saturation velocity for the saturation region")
`MPRnb(lvsat, 0.0, "m^2/s", "L-term of vsat")
`MPRnb(nvsat, 0.0, "m/s", "N-term of vsat")
`MPRnb(pvsat, 0.0, "m^2/s", "P-term of vsat")
`MPRnb(wvsat, 0.0, "m^2/s", "W-term of vsat")
`MPRnb(p2vsat, 0.0, "m^3/s", "WL-term of vsat")

`MPRnb(vsatr, vsat, "m/s", "Saturation velocity for the saturation region in the reverse mode")
`MPRnb(lvsatr, lvsat, "m^2/s", "L-term of vsatr")
`MPRnb(nvsatr, nvsat, "m/s", "N-term of vsatr")
`MPRnb(pvsatr, pvsat, "m^2/s", "P-term of vsatr")
`MPRnb(wvsatr, wvsat, "m^2/s", "W-term of vsatr")
`MPRnb(p2vsatr, p2vsat, "m^3/s", "WL-term of vsatr")

`MPRnb(vsat1, vsat, "m/s", "Velocity saturation parameter for Ion degradation - forward mode")
`MPRnb(lvsat1, lvsat, "m^2/s", "L-term of vsat1")
`MPRnb(nvsat1, nvsat, "m/s", "N-term of vsat1")
`MPRnb(pvsat1, pvsat, "m^2/s", "P-term of vsat1")
`MPRnb(wvsat1, wvsat, "m^2/s", "W-term of vsat1")
`MPRnb(p2vsat1, p2vsat, "m^3/s", "WL-term of vsat1")

`MPRnb(vsat1r, vsat1, "m/s", "Velocity saturation parameter for Ion degradation - reverse mode")
`MPRnb(lvsat1r, lvsat1, "m^2/s", "L-term of vsat1r")
`MPRnb(nvsat1r, nvsat1, "m/s", "N-term of vsat1r")
`MPRnb(pvsat1r, pvsat1, "m^2/s", "P-term of vsat1r")
`MPRnb(wvsat1r, wvsat1, "m^2/s", "W-term of vsat1r")
`MPRnb(p2vsat1r, p2vsat1, "m^3/s", "WL-term of vsat1r")

`MPRnb(deltavsat, 1.0, "", "velocity saturation parameter in the linear region")
`MPRnb(ldeltavsat, 0.0, "m", "L-term of deltavsat")
`MPRnb(ndeltavsat, 0.0, "", "N-term of deltavsat")
`MPRnb(pdeltavsat, 0.0, "m", "P-term of deltavsat")
`MPRnb(wdeltavsat, 0.0, "m", "W-term of deltavsat")
`MPRnb(p2deltavsat, 0.0, "m^2", "WL-term of deltavsat")

`MPRnb(psat, 2.0, "", "Velocity saturation exponent, after binning should be from [2.0 : inf)")
`MPRnb(lpsat, 0.0, "m", "L-term of psat")
`MPRnb(npsat, 0.0, "", "N-term of psat")
`MPRnb(ppsat, 0.0, "m", "P-term of psat")
`MPRnb(wpsat, 0.0, "m", "W-term of psat")
`MPRnb(p2psat, 0.0, "m^2", "WL-term of psat")

`MPRnb(ksativdr, 1.0, "", "Parameter for long channel Vdsat in the overlap region")
`MPRnb(ksativ, 1.0, "", "Parameter for long channel Vdsat")
`MPRnb(lksativ, 0.0, "m", "L-term of ksativ")
`MPRnb(nksativ, 0.0, "", "N-term of ksativ")
`MPRnb(pksativ, 0.0, "m", "P-term of ksativ")
`MPRnb(wksativ, 0.0, "m", "W-term of ksativ")
`MPRnb(p2ksativ, 0.0, "m^2", "WL-term of ksativ")
`MPRnb(ksativt1, -2.0e-4, "/K", "cryomod != 0 temperature coefficient for ksativ")
`MPRnb(ksativt2, -2.0e-7, "/K^2", "cryomod != 0 temperature coefficient for ksativ")

`MPRnb(ksativr, ksativ, "", "ksativ in asymmetric mode")
`MPRnb(lksativr, lksativ, "m", "L-term of ksativr")
`MPRnb(nksativr, nksativ, "", "N-term of ksativr")
`MPRnb(pksativr, pksativ, "m", "P-term of ksativr")
`MPRnb(wksativr, wksativ, "m", "W-term of ksativr")
`MPRnb(p2ksativr, p2ksativ, "m^2", "WL-term of ksativr")

`MPRnb(vsatcv, vsat, "m/s", "Velocity saturation parameter for CV")
`MPRnb(lvsatcv, lvsat, "m^2/s", "L-term of vsatcv")
`MPRnb(nvsatcv, nvsat, "m/s", "N-term of vsatcv")
`MPRnb(pvsatcv, pvsat, "m^2/s", "P-term of vsatcv")
`MPRnb(wvsatcv, wvsat, "m^2/s", "W-term of vsatcv")
`MPRnb(p2vsatcv, p2vsat, "m^3/s", "WL-term of vsatcv")

`MPRnb(asat, 1, "", "Velocity saturation fitting parameter for CV")
`MPRnb(lasat, 0, "m", "L-term of asat")
`MPRnb(nasat, 0, "", "N-term of asat")
`MPRnb(pasat, 0, "m", "P-term of asat")
`MPRnb(wasat, 0, "m", "W-term of asat")
`MPRnb(p2asat, 0, "m^2", "WL-term of asat")

`MPRnb(deltavsatcv, deltavsat, "", "Velocity saturation parameter in the linear region for the capacitance model")
`MPRnb(ldeltavsatcv, ldeltavsat, "m", "L-term of deltavsatcv")
`MPRnb(ndeltavsatcv, ndeltavsat, "", "N-term of deltavsatcv")
`MPRnb(pdeltavsatcv, pdeltavsat, "m", "P-term of deltavsatcv")
`MPRnb(wdeltavsatcv, wdeltavsat, "m", "W-term of deltavsatcv")
`MPRnb(p2deltavsatcv, p2deltavsat, "m^2", "WL-term of deltavsatcv")

`MPRnb(psatcv, psat, "", "Velocity saturation exponent for C-V")
`MPRnb(lpsatcv, lpsat, "m", "L-term of psatcv")
`MPRnb(npsatcv, npsat, "", "N-term of psatcv")
`MPRnb(ppsatcv, ppsat, "m", "P-term of psatcv")
`MPRnb(wpsatcv, wpsat, "m", "W-term of psatcv")
`MPRnb(p2psatcv, p2psat, "m^2", "WL-term of psatcv")

`MPRoz(mexpdr, 4.0, "", "Smoothing function factor for Vdsat in the overlap region")
`MPRnb(mexp, 4.0, "", "Smoothing function factor for Vdsat")
`MPRnb(lmexp, 0.0, "m", "L-term of mexp")
`MPRnb(nmexp, 0.0, "", "N-term of mexp")
`MPRnb(pmexp, 0.0, "m", "P-term of mexp")
`MPRnb(wmexp, 0.0, "m", "W-term of mexp")
`MPRnb(p2mexp, 0.0, "m^2", "WL-term of mexp")

`MPRnb(mexpr, mexp, "", "Reverse-mode smoothing function factor for Vdsat")
`MPRnb(lmexpr, lmexp, "m", "L-term of mexpr")
`MPRnb(nmexpr, nmexp, "", "N-term of mexpr")
`MPRnb(pmexpr, pmexp, "m", "P-term of mexpr")
`MPRnb(wmexpr, wmexp, "m", "W-term of mexpr")
`MPRnb(p2mexpr, p2mexp, "m^2", "WL-term of mexpr")

`MPRnb(ptwg, 0.0, "/V^2", "Gmsat degradation parameter - forward mode")
`MPRnb(lptwg, 0.0, "m/V^2", "L-term of ptwg")
`MPRnb(nptwg, 0.0, "/V^2", "N-term of ptwg")
`MPRnb(pptwg, 0.0, "m/V^2", "P-term of ptwg")
`MPRnb(wptwg, 0.0, "m/V^2", "W-term of ptwg")
`MPRnb(p2ptwg, 0.0, "m^2/V^2", "WL-term of ptwg")

`MPRnb(ptwgr, ptwg, "/V^2", "Gmsat degradation parameter - reverse mode")
`MPRnb(lptwgr, lptwg, "m/V^2", "L-term of ptwgr")
`MPRnb(nptwgr, nptwg, "/V^2", "N-term of ptwgr")
`MPRnb(pptwgr, pptwg, "m/V^2", "P-term of ptwgr")
`MPRnb(wptwgr, wptwg, "m/V^2", "W-term of ptwgr")
`MPRnb(p2ptwgr, p2ptwg, "m^2/V^2", "WL-term of ptwgr")

`MPRnb(at, -1.56e-3, "/K", "Saturation velocity temperature coefficient")
`MPRnb(lat, 0.0, "m/K", "L-term of at")
`MPRnb(nat, 0.0, "/K", "N-term of at")
`MPRnb(pat, 0.0, "m/K", "P-term of at")
`MPRnb(wat, 0.0, "m/K", "W-term of at")
`MPRnb(p2at, 0.0, "m^2/K", "WL-term of at")
`MPRnb(at2, 2.0e-6, "/K^2", "cryomod != 0 saturation velocity temperature coefficient")

`MPRnb(atr, at, "/K", "Reverse-mode saturation velocity temperature coefficient")
`MPRnb(latr, lat, "m/K", "L-term of atr")
`MPRnb(natr, nat, "/K", "N-term of atr")
`MPRnb(patr, pat, "m/K", "P-term of atr")
`MPRnb(watr, wat, "m/K", "W-term of atr")
`MPRnb(p2atr, p2at, "m^2/K", "WL-term of atr")

`MPRnb(atcv, at, "/K", "Saturation velocity temperature coefficient for CV")
`MPRnb(latcv, lat, "m/K", "L-term of atcv")
`MPRnb(natcv, nat, "/K", "N-term of atcv")
`MPRnb(patcv, pat, "m/K", "P-term of atcv")
`MPRnb(watcv, wat, "m/K", "W-term of atcv")
`MPRnb(p2atcv, p2at, "m^2/K", "WL-term of atcv")
`MPRnb(at2cv, at2, "/K^2", "cryomod != 0 saturation velocity temperature coefficient for CV")

`MPRnb(ptwgt, 4.0e-3, "/K", "ptwg temperature coefficient")
`MPRnb(lptwgt, 0.0, "m/K", "L-term of ptwgt")
`MPRnb(nptwgt, 0.0, "/K", "N-term of ptwgt")
`MPRnb(pptwgt, 0.0, "m/K", "P-term of ptwgt")
`MPRnb(wptwgt, 0.0, "m/K", "W-term of ptwgt")
`MPRnb(p2ptwgt, 0.0, "m^2/K", "WL-term of ptwgt")

// Mobility model
`MPRnb(u0n1, 0.0, "", "nfin dependence of u0")
`MPRnb(u0n1cv, u0n1, "", "cvmod = 1 nfin dependence of u0cv")
`MPRnb(u0n1r, u0n1, "", "Reverse-mode nfin dependence of u0")
`MPRex(u0n2, 1.0e5, "", 0.0, "nfin dependence of u0")
`MPRex(u0n2cv, u0n2, "", 0.0, "cvmod=1 nfin dependence of u0cv")
`MPRex(u0n2r, u0n2, "", 0.0, "Reverse-mode nfin dependence of u0")
`MPRnb(u0lt, 0.0, "/m", "Coupled nfin and length dependence of u0")
`MPRnb(u0ltcv, 0.0, "/m", "Coupled nfin and length dependence of u0cv")
`MPRnb(lpa, 1.0, "", "Mobility l power coefficient")
`MPRnb(lpar, lpa, "", "Reverse-mode mobility l power coefficient")
`MPRnb(aua, 0.0, "", "Pre-exponential coefficient for ua")
`MPRnb(auar, aua, "", "Reverse-mode pre-exponential coefficient for ua")
`MPRex(bua, 1.0e-7, "", 0.0, "Exponential coefficient for ua")
`MPRex(buar, bua, "", 0.0, "Reverse-mode exponential coefficient for uar")
`MPRnb(aeu, 0.0, "", "Pre-exponential coefficient for eu")
`MPRnb(aeur, aeu, "", "Reverse-mode pre-exponential coefficient for eu")
`MPRex(beu, 1.0e-7, "", 0.0, "Exponential coefficient for eu")
`MPRex(beur, beu, "", 0.0, "Reverse-mode exponential coefficient for eu")
`MPRnb(aud, 0.0, "", "Pre-exponential coefficient for ud")
`MPRnb(audr, aud, "", "Reverse-mode pre-exponential coefficient for ud")
`MPRex(bud, 5.0e-8, "", 0.0, "Exponential coefficient for ud")
`MPRex(budr, bud, "", 0.0, "Reverse-mode exponential coefficient for ud")
`MPRcc(chargewf, 0.0, "", -1.0, 1.0, "Average channel charge weighting factor, 1: source-side, 0: middle, -1: drain-side")
`MPRco(dmobclamp, 0.01, "m", 0.01, inf, "Minimum clamp on Dmob")

`MPRnb(u0, 3.0e-2, "m^2/(V*s)", "Low-field mobility")
`MPRnb(lu0, 0.0, "m^3/(V*s)", "L-term of u0")
`MPRnb(nu0, 0.0, "m^2/(V*s)", "N-term of u0")
`MPRnb(pu0, 0.0, "m^3/(V*s)", "P-term of u0")
`MPRnb(wu0, 0.0, "m^3/(V*s)", "W-term of u0")
`MPRnb(p2u0, 0.0, "m^4/(V*s)", "WL-term of u0")

`MPRnb(u0r, u0, "m^2/(V*s)", "Reverse-mode low-field mobility")
`MPRnb(lu0r, lu0, "m^3/(V*s)", "L-term of u0r")
`MPRnb(nu0r, nu0, "m^2/(V*s)", "N-term of u0r")
`MPRnb(pu0r, pu0, "m^3/(V*s)", "P-term of u0r")
`MPRnb(wu0r, wu0, "m^3/(V*s)", "W-term of u0r")
`MPRnb(p2u0r, p2u0, "m^4/(V*s)", "WL-term of u0r")

`MPRnb(u0cv, u0, "m^2/(V*s)", "cvmod = 1 low-field mobility")
`MPRnb(lu0cv, lu0, "m^3/(V*s)", "L-term of u0cv")
`MPRnb(nu0cv, nu0, "m^2/(V*s)", "N-term of u0cv")
`MPRnb(pu0cv, pu0, "m^3/(V*s)", "P-term of u0cv")
`MPRnb(wu0cv, wu0, "m^3/(V*s)", "W-term of u0cv")
`MPRnb(p2u0cv, p2u0, "m^4/(V*s)", "WL-term of u0cv")

`MPRnb(etamob, 2.0, "", "Effective field parameter")
`MPRnb(letamob, 0.0, "m", "L-term of etamob")
`MPRnb(netamob, 0.0, "", "N-term of etamob")
`MPRnb(petamob, 0.0, "m", "P-term of etamob")
`MPRnb(wetamob, 0.0, "m", "W-term of etamob")
`MPRnb(p2etamob, 0.0, "m^2", "WL-term of etamob")

`MPRnb(up, 0.0, "um^lpa", "Mobility l coefficient")
`MPRnb(lup, 0.0, "m*(um^lpa)", "L-term of up")
`MPRnb(nup, 0.0, "um^lpa", "N-term of up")
`MPRnb(pup, 0.0, "m*(um^lpa)", "P-term of up")
`MPRnb(wup, 0.0, "m*(um^lpa)", "W-term of up")
`MPRnb(p2up, 0.0, "(m^2)*(um^lpa)", "WL-term of up")

`MPRnb(upr, up, "um^lpa", "Reverse-mode mobility l coefficient")
`MPRnb(lupr, lup, "m*(um^lpa)", "L-term of upr")
`MPRnb(nupr, nup, "um^lpa", "N-term of upr")
`MPRnb(pupr, pup, "m*(um^lpa)", "P-term of upr")
`MPRnb(wupr, wup, "m*(um^lpa)", "W-term of upr")
`MPRnb(p2upr, p2up, "(m^2)*(um^lpa)", "WL-term of upr")

`MPRnb(ua, 0.3, "(cm/MV)^eu", "Phonon/surface roughness scattering parameter")
`MPRnb(lua, 0.0, "m*(cm/MV)^eu", "L-term of ua")
`MPRnb(nua, 0.0, "(cm/MV)^eu", "N-term of ua")
`MPRnb(pua, 0.0, "m*(cm/MV)^eu", "P-term of ua")
`MPRnb(wua, 0.0, "m*(cm/MV)^eu", "W-term of ua")
`MPRnb(p2ua, 0.0, "(m^2)*(cm/MV)^eu", "WL-term of ua")

`MPRnb(uar, ua, "(cm/MV)^eu", "Reverse-mode phonon/surface roughness scattering parameter")
`MPRnb(luar, lua, "m*(cm/MV)^eu", "L-term of uar")
`MPRnb(nuar, nua, "(cm/MV)^eu", "N-term of uar")
`MPRnb(puar, pua, "m*(cm/MV)^eu", "P-term of uar")
`MPRnb(wuar, wua, "m*(cm/MV)^eu", "W-term of uar")
`MPRnb(p2uar, p2ua, "(m^2)*(cm/MV)^eu", "WL-term of uar")

`MPRnb(uacv, ua, "(cm/MV)^eu", "cvmod = 1 phonon/surface roughness scattering parameter")
`MPRnb(luacv, lua, "m*(cm/MV)^eu", "L-term of uacv")
`MPRnb(nuacv, nua, "(cm/MV)^eu", "N-term of uacv")
`MPRnb(puacv, pua, "m*(cm/MV)^eu", "P-term of uacv")
`MPRnb(wuacv, wua, "m*(cm/MV)^eu", "W-term of uacv")
`MPRnb(p2uacv, p2ua, "(m^2)*(cm/MV)^eu", "WL-term of uacv")

`MPRnb(uc, 0.0, "(1e-6*cm/MV^2)^eu", "Body effect for mobility degradation parameter - bulkmod = 1 or 2")
`MPRnb(luc, 0.0, "m*(1e-6*cm/MV^2)^eu", "L-term of uc")
`MPRnb(nuc, 0.0, "(1e-6*cm/MV^2)^eu", "N-term of uc")
`MPRnb(puc, 0.0, "m*(1e-6*cm/MV^2)^eu", "P-term of uc")
`MPRnb(wuc, 0.0, "m*(1e-6*cm/MV^2)^eu", "W-term of uc")
`MPRnb(p2uc, 0.0, "(m^2)*(1e-6*cm/MV^2)^eu", "WL-term of uc")

`MPRnb(ucr, uc, "(1e-6*cm/MV^2)^eu", "Reverse-mode body effect for mobility degradation parameter - bulkmod = 1 or 2")
`MPRnb(lucr, luc, "m*(1e-6*cm/MV^2)^eu", "L-term of ucr")
`MPRnb(nucr, nuc, "(1e-6*cm/MV^2)^eu", "N-term of ucr")
`MPRnb(pucr, puc, "m*(1e-6*cm/MV^2)^eu", "P-term of ucr")
`MPRnb(wucr, wuc, "m*(1e-6*cm/MV^2)^eu", "W-term of ucr")
`MPRnb(p2ucr, p2uc, "(m^2)*(1e-6*cm/MV^2)^eu", "WL-term of ucr")

`MPRnb(uccv, uc, "(1e-6*cm/MV^2)^eu", "cvmod = 1 body effect for mobility degradation parameter (bulkmod = 1 or 2)")
`MPRnb(luccv, luc, "m*(1e-6*cm/MV^2)^eu", "L-term of uccv")
`MPRnb(nuccv, nuc, "(1e-6*cm/MV^2)^eu", "N-term of uccv")
`MPRnb(puccv, puc, "m*(1e-6*cm/MV^2)^eu", "P-term of uccv")
`MPRnb(wuccv, wuc, "m*(1e-6*cm/MV^2)^eu", "W-term of uccv")
`MPRnb(p2uccv, p2uc, "(m^2)*(1e-6*cm/MV^2)^eu", "WL-term of uccv")

`MPRnb(eu, 2.5, "cm/MV", "Phonon/surface roughness scattering parameter")
`MPRnb(leu, 0.0, "m*(cm/MV)", "L-term of eu")
`MPRnb(neu, 0.0, "cm/MV", "N-term of eu")
`MPRnb(peu, 0.0, "m*(cm/MV)", "P-term of eu")
`MPRnb(weu, 0.0, "m*(cm/MV)", "W-term of eu")
`MPRnb(p2eu, 0.0, "(m^2)*(cm/MV)", "WL-term of eu")

`MPRnb(eur, eu, "cm/MV", "Reverse-mode phonon/surface roughness scattering parameter")
`MPRnb(leur, leu, "m*(cm/MV)", "L-term of eur")
`MPRnb(neur, neu, "cm/MV", "N-term of eur")
`MPRnb(peur, peu, "m*(cm/MV)", "P-term of eur")
`MPRnb(weur, weu, "m*(cm/MV)", "W-term of eur")
`MPRnb(p2eur, p2eu, "(m^2)*(cm/MV)", "WL-term of eur")

`MPRnb(ud, 0.0, "cm/MV", "Coulomb scattering parameter")
`MPRnb(lud, 0.0, "m*(cm/MV)", "L-term of ud")
`MPRnb(nud, 0.0, "cm/MV", "N-term of ud")
`MPRnb(pud, 0.0, "m*(cm/MV)", "P-term of ud")
`MPRnb(wud, 0.0, "m*(cm/MV)", "W-term of ud")
`MPRnb(p2ud, 0.0, "(m^2)*(cm/MV)", "WL-term of ud")

`MPRnb(udr, ud, "cm/MV", "Reverse-mode Coulomb scattering parameter")
`MPRnb(ludr, lud, "m*(cm/MV)", "L-term of udr")
`MPRnb(nudr, nud, "cm/MV", "N-term of udr")
`MPRnb(pudr, pud, "m*(cm/MV)", "P-term of udr")
`MPRnb(wudr, wud, "m*(cm/MV)", "W-term of udr")
`MPRnb(p2udr, p2ud, "(m^2)*(cm/MV)", "WL-term of udr")

`MPRnb(udcv, ud, "cm/MV", "cvmod = 1 coulomb scattering parameter")
`MPRnb(ludcv, lud, "m*(cm/MV)", "L-term of udcv")
`MPRnb(nudcv, nud, "cm/MV", "N-term of udcv")
`MPRnb(pudcv, pud, "m*(cm/MV)", "P-term of udcv")
`MPRnb(wudcv, wud, "m*(cm/MV)", "W-term of udcv")
`MPRnb(p2udcv, p2ud, "(m^2)*(cm/MV)", "WL-term of udcv")

`MPRnb(ucs, 1.0, "", "Coulomb scattering parameter")
`MPRnb(lucs, 0.0, "m", "L-term of ucs")
`MPRnb(nucs, 0.0, "", "N-term of ucs")
`MPRnb(pucs, 0.0, "m", "P-term of ucs")
`MPRnb(wucs, 0.0, "m", "W-term of ucs")
`MPRnb(p2ucs, 0.0, "m^2", "WL-term of ucs")

`MPRnb(uds, 2.0e-5, "", "cryomod != 0 weight factor correction for source side inversion charge density in Coulomb scattering model")
`MPRnb(luds, 0.0, "m", "L-term of uds")
`MPRnb(nuds, 0.0, "", "N-term of uds")
`MPRnb(puds, 0.0, "m", "P-term of uds")
`MPRnb(wuds, 0.0, "m", "W-term of uds")
`MPRnb(p2uds, 0.0, "m^2", "WL-term of uds")

`MPRnb(uds1, -10.0, "", "cryomod != 0 temperature coefficient for uds")
`MPRnb(luds1, 0.0, "m", "L-term of uds1")
`MPRnb(nuds1, 0.0, "", "N-term of uds1")
`MPRnb(puds1, 0.0, "m", "P-term of uds1")
`MPRnb(wuds1, 0.0, "m", "W-term of uds1")
`MPRnb(p2uds1, 0.0, "m^2", "WL-term of uds1")

`MPRnb(udd, -2.0e-5, "", "cryomod != 0 weight factor correction for drain side inversion charge density in Coulomb scattering model")
`MPRnb(ludd, 0.0, "m", "L-term of udd")
`MPRnb(nudd, 0.0, "", "N-term of udd")
`MPRnb(pudd, 0.0, "m", "P-term of udd")
`MPRnb(wudd, 0.0, "m", "W-term of udd")
`MPRnb(p2udd, 0.0, "m^2", "WL-term of udd")

`MPRnb(udd1, -10.0, "", "cryomod != 0 temperature coefficient for udd")
`MPRnb(ludd1, 0.0, "m", "L-term of udd1")
`MPRnb(nudd1, 0.0, "", "N-term of udd1")
`MPRnb(pudd1, 0.0, "m", "P-term of udd1")
`MPRnb(wudd1, 0.0, "m", "W-term of udd1")
`MPRnb(p2udd1, 0.0, "m^2", "WL-term of udd1")

`MPRnb(ute, 0.0, "", "Mobility temperature coefficient")
`MPRnb(lute, 0.0, "m", "L-term of ute")
`MPRnb(nute, 0.0, "", "N-term of ute")
`MPRnb(pute, 0.0, "m", "P-term of ute")
`MPRnb(wute, 0.0, "m", "W-term of ute")
`MPRnb(p2ute, 0.0, "m^2", "WL-term of ute")

`MPRnb(uter, ute, "", "Reverse-mode for mobility temperature coefficient")
`MPRnb(luter, lute, "m", "L-term of uter")
`MPRnb(nuter, nute, "", "N-term of uter")
`MPRnb(puter, pute, "m", "P-term of uter")
`MPRnb(wuter, wute, "m", "W-term of uter")
`MPRnb(p2uter, p2ute, "m^2", "WL-term of uter")

`MPRnb(utecv, ute, "", "cvmod = 1 mobility temperature coefficient")
`MPRnb(lutecv, lute, "m", "L-term of utecv")
`MPRnb(nutecv, nute, "", "N-term of utecv")
`MPRnb(putecv, pute, "m", "P-term of utecv")
`MPRnb(wutecv, wute, "m", "W-term of utecv")
`MPRnb(p2utecv, p2ute, "m^2", "WL-term of utecv")

`MPRnb(ute1, -0.4, "", "cryomod != 0 mobility temperature coefficient")
`MPRnb(lute1, 0.0, "m", "L-term of ute1")
`MPRnb(nute1, 0.0, "", "N-term of ute1")
`MPRnb(pute1, 0.0, "m", "P-term of ute1")
`MPRnb(wute1, 0.0, "m", "W-term of ute1")
`MPRnb(p2ute1, 0.0, "m^2", "WL-term of ute1")

`MPRnb(ute1cv, ute1, "", "cryomod != 0 and cvmod = 1 mobility temperature coefficient")
`MPRnb(lute1cv, lute1, "m", "L-term of ute1cv")
`MPRnb(nute1cv, nute1, "", "N-term of ute1cv")
`MPRnb(pute1cv, pute1, "m", "P-term of ute1cv")
`MPRnb(wute1cv, wute1, "m", "W-term of ute1cv")
`MPRnb(p2ute1cv, p2ute1, "m^2", "WL-term of ute1cv")

`MPRnb(utl, -1.5e-3, "", "Mobility temperature coefficient")
`MPRnb(lutl, 0.0, "m", "L-term of utl")
`MPRnb(nutl, 0.0, "", "N-term of utl")
`MPRnb(putl, 0.0, "m", "P-term of utl")
`MPRnb(wutl, 0.0, "m", "W-term of utl")
`MPRnb(p2utl, 0.0, "m^2", "WL-term of utl")

`MPRnb(utlr, utl, "", "Reverse-mode for mobility temperature coefficient")
`MPRnb(lutlr, lutl, "m", "L-term of utlr")
`MPRnb(nutlr, nutl, "", "N-term of utlr")
`MPRnb(putlr, putl, "m", "P-term of utlr")
`MPRnb(wutlr, wutl, "m", "W-term of utlr")
`MPRnb(p2utlr, p2utl, "m^2", "WL-term of utlr")

`MPRnb(utlcv, utl, "", "cvmod = 1 mobility temperature coefficient")
`MPRnb(lutlcv, lutl, "m", "L-term of utlcv")
`MPRnb(nutlcv, nutl, "", "N-term of utlcv")
`MPRnb(putlcv, putl, "m", "P-term of utlcv")
`MPRnb(wutlcv, wutl, "m", "W-term of utlcv")
`MPRnb(p2utlcv, p2utl, "m^2", "WL-term of utlcv")

`MPRnb(emobt, 0.0, "", "Temperature coefficient of etamob")
`MPRnb(lemobt, 0.0, "m", "L-term of emobt")
`MPRnb(nemobt, 0.0, "", "N-term of emobt")
`MPRnb(pemobt, 0.0, "m", "P-term of emobt")
`MPRnb(wemobt, 0.0, "m", "W-term of emobt")
`MPRnb(p2emobt, 0.0, "m^2", "WL-term of emobt")

`MPRnb(ua1, 1.032e-3, "", "Mobility temperature coefficient for ua")
`MPRnb(lua1, 0.0, "m", "L-term of ua1")
`MPRnb(nua1, 0.0, "", "N-term of ua1")
`MPRnb(pua1, 0.0, "m", "P-term of ua1")
`MPRnb(wua1, 0.0, "m", "W-term of ua1")
`MPRnb(p2ua1, 0.0, "m^2", "WL-term of ua1")

`MPRnb(ua1r, ua1, "", "Reverse-mode mobility temperature coefficient for ua")
`MPRnb(lua1r, lua1, "m", "L-term of ua1r")
`MPRnb(nua1r, nua1, "", "N-term of ua1r")
`MPRnb(pua1r, pua1, "m", "P-term of ua1r")
`MPRnb(wua1r, wua1, "m", "W-term of ua1r")
`MPRnb(p2ua1r, p2ua1, "m^2", "WL-term of ua1r")

`MPRnb(ua1cv, ua1, "", "cvmod = 1 mobility temperature coefficient for ua")
`MPRnb(lua1cv, lua1, "m", "L-term of ua1cv")
`MPRnb(nua1cv, nua1, "", "N-term of ua1cv")
`MPRnb(pua1cv, pua1, "m", "P-term of ua1cv")
`MPRnb(wua1cv, wua1, "m", "W-term of ua1cv")
`MPRnb(p2ua1cv, p2ua1, "m^2", "WL-term of ua1cv")

`MPRnb(ua2, -0.04, "", "cryomod != 0 mobility temperature coefficient for ua")
`MPRnb(lua2, 0.0, "m", "L-term of ua2")
`MPRnb(nua2, 0.0, "", "N-term of ua2")
`MPRnb(pua2, 0.0, "m", "P-term of ua2")
`MPRnb(wua2, 0.0, "m", "W-term of ua2")
`MPRnb(p2ua2, 0.0, "m^2", "WL-term of ua2")

`MPRnb(ua2cv, ua2, "", "cryomod != 0 and cvmod = 1 mobility temperature coefficient for ua")
`MPRnb(lua2cv, lua2, "m", "L-term of ua2cv")
`MPRnb(nua2cv, nua2, "", "N-term of ua2cv")
`MPRnb(pua2cv, pua2, "m", "P-term of ua2cv")
`MPRnb(wua2cv, wua2, "m", "W-term of ua2cv")
`MPRnb(p2ua2cv, p2ua2, "m^2", "WL-term of ua2cv")

`MPRnb(eu1, -1.0e-3, "", "cryomod != 0 mobility temperature coefficient for eu")
`MPRnb(leu1, 0.0, "m", "L-term of eu1")
`MPRnb(neu1, 0.0, "", "N-term of eu1")
`MPRnb(peu1, 0.0, "m", "P-term of eu1")
`MPRnb(weu1, 0.0, "m", "W-term of eu1")
`MPRnb(p2eu1, 0.0, "m^2", "WL-term of eu1")

`MPRnb(uc1, 5.6e-11, "", "Mobility temperature coefficient for uc")
`MPRnb(luc1, 0.0, "m", "L-term of uc1")
`MPRnb(nuc1, 0.0, "", "N-term of uc1")
`MPRnb(puc1, 0.0, "m", "P-term of uc1")
`MPRnb(wuc1, 0.0, "m", "W-term of uc1")
`MPRnb(p2uc1, 0.0, "m^2", "WL-term of uc1")

`MPRnb(uc1r, uc1, "", "Reverse-mode mobility temperature coefficient for uc")
`MPRnb(luc1r, luc1, "m", "L-term of uc1r")
`MPRnb(nuc1r, nuc1, "", "N-term of uc1r")
`MPRnb(puc1r, puc1, "m", "P-term of uc1r")
`MPRnb(wuc1r, wuc1, "m", "W-term of uc1r")
`MPRnb(p2uc1r, p2uc1, "m^2", "WL-term of uc1r")

`MPRnb(uc1cv, uc1, "", "cvmod = 1 mobility temperature coefficient for uc")
`MPRnb(luc1cv, luc1, "m", "L-term of uc1cv")
`MPRnb(nuc1cv, nuc1, "", "N-term of uc1cv")
`MPRnb(puc1cv, puc1, "m", "P-term of uc1cv")
`MPRnb(wuc1cv, wuc1, "m", "W-term of uc1cv")
`MPRnb(p2uc1cv, p2uc1, "m^2", "WL-term of uc1cv")

`MPRnb(ud1, 0.0, "", "Mobility temperature coefficient for ud")
`MPRnb(lud1, 0.0, "m", "L-term of ud1")
`MPRnb(nud1, 0.0, "", "N-term of ud1")
`MPRnb(pud1, 0.0, "m", "P-term of ud1")
`MPRnb(wud1, 0.0, "m", "W-term of ud1")
`MPRnb(p2ud1, 0.0, "m^2", "WL-term of ud1")

`MPRnb(ud1r, ud1, "", "Reverse-mode mobility temperature coefficient for ud")
`MPRnb(lud1r, lud1, "m", "L-term of ud1r")
`MPRnb(nud1r, nud1, "", "N-term of ud1r")
`MPRnb(pud1r, pud1, "m", "P-term of ud1r")
`MPRnb(wud1r, wud1, "m", "W-term of ud1r")
`MPRnb(p2ud1r, p2ud1, "m^2", "WL-term of ud1r")

`MPRnb(ud1cv, ud1, "", "cvmod = 1 mobility temperature coefficient for ud")
`MPRnb(lud1cv, lud1, "m", "L-term of ud1cv")
`MPRnb(nud1cv, nud1, "", "N-term of ud1cv")
`MPRnb(pud1cv, pud1, "m", "P-term of ud1cv")
`MPRnb(wud1cv, wud1, "m", "W-term of ud1cv")
`MPRnb(p2ud1cv, p2ud1, "m^2", "WL-term of ud1cv")

`MPRnb(ud2, -0.04, "", "cryomod != 0 mobility temperature coefficient for ud")
`MPRnb(lud2, 0.0, "m", "L-term of ud2")
`MPRnb(nud2, 0.0, "", "N-term of ud2")
`MPRnb(pud2, 0.0, "m", "P-term of ud2")
`MPRnb(wud2, 0.0, "m", "W-term of ud2")
`MPRnb(p2ud2, 0.0, "m^2", "WL-term of ud2")

`MPRnb(ud2cv, ud2, "", "cryomod != 0 and cvmod = 1 mobility temperature coefficient for ud")
`MPRnb(lud2cv, lud2, "m", "L-term of ud2cv")
`MPRnb(nud2cv, nud2, "", "N-term of ud2cv")
`MPRnb(pud2cv, pud2, "m", "P-term of ud2cv")
`MPRnb(wud2cv, wud2, "m", "W-term of ud2cv")
`MPRnb(p2ud2cv, p2ud2, "m^2", "WL-term of ud2cv")

`MPRnb(ucste, -4.775e-3, "", "Mobility temperature coefficient")
`MPRnb(lucste, 0.0, "m", "L-term of ucste")
`MPRnb(nucste, 0.0, "", "N-term of ucste")
`MPRnb(pucste, 0.0, "m", "P-term of ucste")
`MPRnb(wucste, 0.0, "m", "W-term of ucste")
`MPRnb(p2ucste, 0.0, "m^2", "WL-term of ucste")

`MPRnb(ucste1, -0.04, "", "cryomod != 0 mobility temperature coefficient for ucs")
`MPRnb(lucste1, 0.0, "m", "L-term of ucste1")
`MPRnb(nucste1, 0.0, "", "N-term of ucste1")
`MPRnb(pucste1, 0.0, "m", "P-term of ucste1")
`MPRnb(wucste1, 0.0, "m", "W-term of ucste1")
`MPRnb(p2ucste1, 0.0, "m^2", "WL-term of ucste1")

`MPRoo(muhc0, 0.0, "", -inf, 1.0, "Coefficient for hot-carrier induced mobility degradation")
`MPRco(muhc1, 0.0, "", 0.0, inf, "Exponential coefficient for hot-carrier induced mobility degradation")

//Gate-All-Around geometry dependent mobility
`MPRnb(etamobthin, etamob, "", "Effective field parameter for thin GAA bodies")
`MPRcz(etamobtni, 7.5e-9, "m", "Critical tgaa for non-ideality")
`MPRoz(etamobir, 0.1, "nm", "Ideality parameter")

`MPRnb(uathin, ua, "(cm/MV)^eu", "Phonon/surface roughness scattering parameter for thin GAA bodies")
`MPRcz(uatsat, 9e-9, "m", "Critical tgaa for ua saturation")
`MPRcz(uartsc, 0.09, "1/nm", "Rate of ua decay with tgaa scaling")
`MPRcz(uatni, 6.4e-9, "m", "Critical tgaa for non-ideality")
`MPRoz(uair, 0.2, "nm", "Ideality parameter")

`MPRnb(euthin, eu, "cm/MV", "Phonon/surface roughness scattering parameter for thin GAA bodies")
`MPRcz(euptsc, 3.5, "", "Exponent for tgaa scaling power law")
`MPRcz(eutni, 6e-9, "m", "Critical tgaa for non-ideality")
`MPRoz(euir, 0.2, "nm", "Ideality parameter")

`MPRnb(udthin, ud, "cm/MV", "Coulomb scattering parameter for thin GAA bodies")
`MPRcz(udtsat, 8.1e-9, "m", "Crtitcal tgaa for ud saturation")
`MPRcz(udptsc, 1.3, "", "Exponent for ud power law")

`MPRcz(u0etawsc, 1.5, "", "Ratio of primary carrier low-field mobilities: U0_[110]/U0_[100]")
`MPRcz(egbulk, 1.1, "eV", "Bulk band-gap")
`MPRcz(u0emsm1, 26.6, "meVnm^2", "Parameter for effective mass scaling")
`MPRnb(u0emsm2, 4, "", "Parameter for effective mass scaling")

// Access resistance model
`MPRcz(rdswmin, 0.0, "ohm*(um^(wr))", "rdsmod = 0 S/D extension resistance per unit width at high Vgs")
`MPRnb(ardsw, 0.0, "", "Pre-exponential coefficient for rdsw")
`MPRex(brdsw, 1.0e-7, "", 0.0, "exponential coefficient for rdsw")
`MPRcz(rswmin, 0.0, "ohm*(um^(wr))", "rdsmod = 1 source extension resistance per unit width at high Vgs")
`MPRnb(arsw, 0.0, "", "Pre-exponential coefficient for rsw")
`MPRex(brsw, 1.0e-7, "", 0.0, "Exponential coefficient for rsw")
`MPRcz(rdwmin, 0.0, "ohm*(um^(wr))", "rdsmod = 1 drain extension resistance per unit width at high Vgs")
`MPRnb(ardw, 0.0, "", "Pre-exponential coefficient for rdw")
`MPRex(brdw, 1.0e-7, "", 0.0, "Exponential coefficient for rdw")
`MPRcz(rsdr, 0.0, "V^(-prsdr)", "Source-side drift resistance parameter - forward mode")
`MPRcz(rsdrr, rsdr, "V^(-prsdr)", "Source-side drift resistance parameter - reverse mode")
`MPRcz(rddr, rsdr, "V^(-prddr)", "Drain-side drift resistance parameter - forward mode")
`MPRcz(rddrr, rddr, "V^(-prddr)", "Drain-side drift resistance parameter - reverse mode")
`MPRnb(prsdr, 1.0, "", "Source-side quasi-saturation parameter")
`MPRnb(prddr, prsdr, "", "Drain-side quasi-saturation parameter")
`MPRnb(trsdr, 0.0, "/K", "Source-side drift resistance temperature coefficient")
`MPRnb(trddr, trsdr, "/K", "Drain-side drift resistance temperature coefficient")

`MPRnb(rdsw, 1.0e2, "(ohm-um^wr)", "rdsmod = 0 zero bias S/D extension resistance per unit width")
`MPRnb(lrdsw, 0.0, "m*(ohm-um^wr)", "L-term of rdsw")
`MPRnb(nrdsw, 0.0, "(ohm-um^wr)", "N-term of rdsw")
`MPRnb(prdsw, 0.0, "m*(ohm-um^wr)", "P-term of rdsw")
`MPRnb(wrdsw, 0.0, "m*(ohm-um^wr)", "W-term of rdsw")
`MPRnb(p2rdsw, 0.0, "(m^2)*(ohm-um^wr)", "WL-term of rdsw")

`MPRnb(rsw, 5.0e1, "(ohm-um^wr)", "rdsmod = 1 zero bias source extension resistance per unit width")
`MPRnb(lrsw, 0.0, "m*(ohm-um^wr)", "L-term of rsw")
`MPRnb(nrsw, 0.0, "(ohm-um^wr)", "N-term of rsw")
`MPRnb(prsw, 0.0, "m*(ohm-um^wr)", "P-term of rsw")
`MPRnb(wrsw, 0.0, "m*(ohm-um^wr)", "W-term of rsw")
`MPRnb(p2rsw, 0.0, "(m^2)*(ohm-um^wr)", "WL-term of rsw")

`MPRnb(rdw, 5.0e1, "(ohm-um^wr)", "rdsmod = 1 zero bias drain extension resistance per unit width")
`MPRnb(lrdw, 0.0, "m*(ohm-um^wr)", "L-term of rdw")
`MPRnb(nrdw, 0.0, "(ohm-um^wr)", "N-term of rdw")
`MPRnb(prdw, 0.0, "m*(ohm-um^wr)", "P-term of rdw")
`MPRnb(wrdw, 0.0, "m*(ohm-um^wr)", "W-term of rdw")
`MPRnb(p2rdw, 0.0, "(m^2)*(ohm-um^wr)", "WL-term of rdw")

`MPRnb(prwgs, 0.0, "/V", "Gate bias dependence of source extension resistance")
`MPRnb(lprwgs, 0.0, "m/V", "L-term of prwgs")
`MPRnb(nprwgs, 0.0, "/V", "N-term of prwgs")
`MPRnb(pprwgs, 0.0, "m/V", "P-term of prwgs")
`MPRnb(wprwgs, 0.0, "m/V", "W-term of prwgs")
`MPRnb(p2prwgs, 0.0, "(m^2)/V", "WL-term of prwgs")

`MPRnb(prwgd, prwgs, "/V", "Gate bias dependence of drain extension resistance")
`MPRnb(lprwgd, 0.0, "m/V", "L-term of prwgd")
`MPRnb(nprwgd, 0.0, "/V", "N-term of prwgd")
`MPRnb(pprwgd, 0.0, "m/V", "P-term of prwgd")
`MPRnb(wprwgd, 0.0, "m/V", "W-term of prwgd")
`MPRnb(p2prwgd, 0.0, "(m^2)/V", "WL-term of prwgd")

`MPRnb(wr, 1.0, "", "W dependence parameter of S/D extension resistance")
`MPRnb(lwr, 0.0, "m", "L-term of wr")
`MPRnb(nwr, 0.0, "", "N-term of wr")
`MPRnb(pwr, 0.0, "m", "P-term of wr")
`MPRnb(wwr, 0.0, "m", "W-term of wr")
`MPRnb(p2wr, 0.0, "m^2", "WL-term of wr")

`MPRnb(prt, 1.0e-3, "/K", "Series resistance temperature coefficient")
`MPRnb(lprt, 0.0, "m/K", "L-term of prt")
`MPRnb(nprt, 0.0, "/K", "N-term of prt")
`MPRnb(pprt, 0.0, "m/K", "P-term of prt")
`MPRnb(wprt, 0.0, "m/K", "W-term of prt")
`MPRnb(p2prt, 0.0, "(m^2)/K", "WL-term of prt")

`MPRnb(prt1, 4.0e-4, "/K", "cryomod != 0 series resistance temperature coefficient at low temperatures")
`MPRnb(lprt1, 0.0, "m/K", "L-term of prt1")
`MPRnb(nprt1, 0.0, "/K", "N-term of prt1")
`MPRnb(pprt1, 0.0, "m/K", "P-term of prt1")
`MPRnb(wprt1, 0.0, "m/K", "W-term of prt1")
`MPRnb(p2prt1, 0.0, "(m^2)/K", "WL-term of prt1")

`MPRnb(tr0, 170.0, "K", "cryomod != 0 corner temperature in dual-slope temperature model of series resistance")
`MPRnb(ltr0, 0.0, "m*K", "L-term of tr0")
`MPRnb(ntr0, 0.0, "K", "N-term of tr0")
`MPRnb(ptr0, 0.0, "m*K", "P-term of tr0")
`MPRnb(wtr0, 0.0, "m*K", "W-term of tr0")
`MPRnb(p2tr0, 0.0, "(m^2)*K", "WL-term of tr0")

`MPRnb(sprt, 1.0e-2, "", "cryomod != 0 parameter for corner temperature smoothing in dual-slope temperature model of series resistance")
`MPRnb(lsprt, 0.0, "m", "L-term of sprt")
`MPRnb(nsprt, 0.0, "", "N-term of sprt")
`MPRnb(psprt, 0.0, "m", "P-term of sprt")
`MPRnb(wsprt, 0.0, "m", "W-term of sprt")
`MPRnb(p2sprt, 0.0, "m^2", "WL-term of sprt")

// DIBL model
`MPRnb(pdibl1, 1.3, "", "DIBL output conductance parameter - forward mode")
`MPRnb(lpdibl1, 0.0, "m", "L-term of pdibl1")
`MPRnb(npdibl1, 0.0, "", "N-term of pdibl1")
`MPRnb(ppdibl1, 0.0, "m", "P-term of pdibl1")
`MPRnb(wpdibl1, 0.0, "m", "W-term of pdibl1")
`MPRnb(p2pdibl1, 0.0, "m^2", "WL-term of pdibl1")

`MPRnb(pdibl2, 2.0e-4, "", "DIBL output conductance parameter")
`MPRnb(lpdibl2, 0.0, "m", "L-term of pdibl2")
`MPRnb(npdibl2, 0.0, "", "N-term of pdibl2")
`MPRnb(ppdibl2, 0.0, "m", "P-term of pdibl2")
`MPRnb(wpdibl2, 0.0, "m", "W-term of pdibl2")
`MPRnb(p2pdibl2, 0.0, "m^2", "WL-term of pdibl2")

`MPRnb(pdibl1r, pdibl1, "", "DIBL output conductance parameter - reverse mode")
`MPRnb(lpdibl1r, lpdibl1, "m", "L-term of pdibl1r")
`MPRnb(npdibl1r, npdibl1, "", "N-term of pdibl1r")
`MPRnb(ppdibl1r, ppdibl1, "m", "P-term of pdibl1r")
`MPRnb(wpdibl1r, wpdibl1, "m", "W-term of pdibl1r")
`MPRnb(p2pdibl1r, p2pdibl1, "m^2", "WL-term of pdibl1r")

`MPRnb(pdibl2r, pdibl2, "", "DIBL output conductance parameter - reverse mode")
`MPRnb(lpdibl2r, lpdibl2, "m", "L-term of pdibl2r")
`MPRnb(npdibl2r, npdibl2, "", "N-term of pdibl2r")
`MPRnb(ppdibl2r, ppdibl2, "m", "P-term of pdibl2r")
`MPRnb(wpdibl2r, wpdibl2, "m", "W-term of pdibl2r")
`MPRnb(p2pdibl2r, p2pdibl2, "m^2", "WL-term of pdibl2r")

`MPRnb(drout, 1.06, "", "l dependence of DIBL effect on Rout")
`MPRnb(ldrout, 0.0, "m", "L-term of drout")
`MPRnb(ndrout, 0.0, "", "N-term of drout")
`MPRnb(pdrout, 0.0, "m", "P-term of drout")
`MPRnb(wdrout, 0.0, "m", "W-term of drout")
`MPRnb(p2drout, 0.0, "m^2", "WL-term of drout")

`MPRnb(pvag, 1.0, "", "Vgs dependence on early voltage")
`MPRnb(lpvag, 0.0, "m", "L-term of pvag")
`MPRnb(npvag, 0.0, "", "N-term of pvag")
`MPRnb(ppvag, 0.0, "m", "P-term of pvag")
`MPRnb(wpvag, 0.0, "m", "W-term of pvag")
`MPRnb(p2pvag, 0.0, "m^2", "WL-term of pvag")

// Channel length modulation effect
`MPRnb(apclm, 0.0, "", "Pre-exponential coefficient for pclm")
`MPRnb(apclmr, apclm, "", "Reverse-mode pre-exponential coefficient for pclm")
`MPRex(bpclm, 1.0e-7, "", 0.0, "Exponential coefficient for pclm")
`MPRex(bpclmr, bpclm, "", 0.0, "Reverse-mode exponential coefficient for pclm")

`MPRnb(pclm, 1.3e-2, "", "Channel length modulation (CLM) parameter")
`MPRnb(pclmt, -2.0e-5, "/K", "cryomod != 0 temperature coefficient for pclm")
`MPRnb(lpclm, 0.0, "m", "L-term of pclm")
`MPRnb(npclm, 0.0, "", "N-term of pclm")
`MPRnb(ppclm, 0.0, "m", "P-term of pclm")
`MPRnb(wpclm, 0.0, "m", "W-term of pclm")
`MPRnb(p2pclm, 0.0, "m^2", "WL-term of pclm")

`MPRnb(pclmr, pclm, "", "Reverse model pclm parameter")
`MPRnb(lpclmr, lpclm, "m", "L-term of pclmr")
`MPRnb(npclmr, npclm, "", "N-term of pclmr")
`MPRnb(ppclmr, ppclm, "m", "P-term of pclmr")
`MPRnb(wpclmr, wpclm, "m", "W-term of pclmr")
`MPRnb(p2pclmr, p2pclm, "m^2", "WL-term of pclmr")

`MPRnb(pclmg, 0.0, "/V", "Gate bias dependence parameter for CLM")
`MPRnb(lpclmg, 0.0, "m/V", "L-term of pclmg")
`MPRnb(npclmg, 0.0, "/V", "N-term of pclmg")
`MPRnb(ppclmg, 0.0, "m/V", "P-term of pclmg")
`MPRnb(wpclmg, 0.0, "m/V", "W-term of pclmg")
`MPRnb(p2pclmg, 0.0, "(m^2)/V", "WL-term of pclmg")

`MPRnb(pclmcv, pclm, "", "CLM parameter for short-channel CV")
`MPRnb(lpclmcv, lpclm, "m", "L-term of pclmcv")
`MPRnb(npclmcv, npclm, "", "N-term of pclmcv")
`MPRnb(ppclmcv, ppclm, "m", "P-term of pclmcv")
`MPRnb(wpclmcv, wpclm, "m", "W-term of pclmcv")
`MPRnb(p2pclmcv, p2pclm, "m^2", "WL-term of pclmcv")

// Non-saturation effect
`MPRnb(a1, 0.0, "/V^2", "Non-saturation effect parameter for strong inversion Region")
`MPRnb(la1, 0.0, "m/V^2", "L-term of a1")
`MPRnb(na1, 0.0, "/V^2", "N-term of a1")
`MPRnb(pa1, 0.0, "m/V^2", "P-term of a1")
`MPRnb(wa1, 0.0, "m/V^2", "W-term of a1")
`MPRnb(p2a1, 0.0, "(m^2)/V^2", "WL-term of a1")

`MPRnb(a11, 0.0, "/(V^2*K)", "Temperature dependence of a1")
`MPRnb(la11, 0.0, "m/(V^2*K)", "L-term of a11")
`MPRnb(na11, 0.0, "/(V^2*K)", "N-term of a11")
`MPRnb(pa11, 0.0, "m/(V^2*K)", "P-term of a11")
`MPRnb(wa11, 0.0, "m/(V^2*K)", "W-term of a11")
`MPRnb(p2a11, 0.0, "(m^2)/(V^2*K)", "WL-term of a11")

`MPRnb(a2, 0.0, "/V", "Non-saturation effect parameter for moderate Inversion Region")
`MPRnb(la2, 0.0, "m/V", "L-term of a2")
`MPRnb(na2, 0.0, "/V", "N-term of a2")
`MPRnb(pa2, 0.0, "m/V", "P-term of a2")
`MPRnb(wa2, 0.0, "m/V", "W-term of a2")
`MPRnb(p2a2, 0.0, "(m^2)/V", "WL-term of a2")

`MPRnb(a21, 0.0, "/(V*K)", "Temperature dependence of a2")
`MPRnb(la21, 0.0, "m/(V*K)", "L-term of a21")
`MPRnb(na21, 0.0, "/(V*K)", "N-term of a21")
`MPRnb(pa21, 0.0, "m/(V*K)", "P-term of a21")
`MPRnb(wa21, 0.0, "m/(V*K)", "W-term of a21")
`MPRnb(p2a21, 0.0, "(m^2)/(V*K)", "WL-term of a21")

// Gate electrode resistance
`MPRcz(rgext, 0.0, "ohm", "Effective gate electrode external resistance")
`MPRco(rgfin, 1.0e-3, "ohm", 1.0e-3, inf, "Effective gate electrode per finger per fin resistance")
`MPRcz(rgint, 0.0, "ohm", "Effective gate electrode internal resistance")
`MPRcz(rgp, 0.0, "ohm", "Effective gate electrode resistance charging parasitic capacitances")

// Geometry-dependent source/drain resistance of rgeomod = 0
`MPRnb(rshs, 0.0, "ohm", "Source-side sheet resistance")
`MPRnb(rshd, rshs, "ohm", "Drain-side sheet resistance")

// Geometry-dependent source/drain resistance of rgeomod = 1
`MPRnb(hepi, 1.0e-8, "m", "Height of the raised source/drain on top of the fin")
`MPRnb(tsili, 1.0e-8, "m", "Thickness of the silicide on top of the raised source/drain")
`MPRcc(rhoc, 1.0e-12, "ohm*(m^2)", 1.0e-18, 1.0e-9, "Contact resistivity at the silicon/silicide interface")
`MPRoz(rhorsd, 1.0, "ohm*(m)", "If non-zero, average resistivity of silicon in the raised source/drain region")
`MPRcc(cratio, 0.5, "", 0.0, 1.0, "Ratio of the corner area filled with silicon to the total corner area")
`MPRnb(deltaprsd, 0.0, "m", "Change in silicon/silicide interface length due to non-rectangular epi")
`MPIcc(sdterm, 0, "", 0, 1, "Indicator of whether the source/drain are terminated with silicide")
`MPRoz(lsp, 6.0e-9, "m", "Thickness of the gate sidewall spacer")
`MPRco(epsrsp, 3.9, "", 1.0, inf, "Relative dielectric constant of the spacer")
`MPRoz(tgate, 3.0e-8, "m", "Gate height on top of the hard mask")
`MPRcz(tmask, 3.0e-8, "m", "Height of hard mask on top of the fin")
`MPRcz(asiliend, 0.0, "m^2", "Extra silicide cross sectional area at the two ends of the FinFET")
`MPRcz(arsdend, 0.0, "m^2", "Extra raised source/drain cross sectional areaat the two ends of the finFET")
`MPRcz(prsdend, 0.0, "m", "Extra silicon/silicide interface perimeter at the two ends of the finFET")
`MPRnb(rgeoa, 1.0, "", "Fitting parameter for rgeomod = 1")
`MPRnb(rgeob, 0.0, "/m", "Fitting parameter for rgeomod = 1")
`MPRnb(rgeoc, 0.0, "/m", "Fitting parameter for rgeomod = 1")
`MPRnb(rgeod, 0.0, "/m", "Fitting parameter for rgeomod = 1")
`MPRnb(rgeoe, 0.0, "/m", "Fitting parameter for rgeomod = 1")
`MPRnb(cgeoa, 1.0, "", "Fitting parameter for cgeomod = 2 and 3")
`MPRnb(cgeob, 0.0, "/m", "Fitting parameter for cgeomod = 2 and 3")
`MPRnb(cgeoc, 0.0, "/m", "Fitting parameter for cgeomod = 2 and 3")
`MPRnb(cgeod, 0.0, "/m", "Fitting parameter for cgeomod = 2 and 3")
`MPRcz(cgeoe, 1.0, "", "Fitting parameter for cgeomod = 2 and 3")

// Gate currents
`MPRnb(dlcigs, 0.0, "m", "Delta l for Igs model")
`MPRnb(dlcigd, dlcigs, "m", "Delta l for Igd model")
`MPRnb(vfbsd, 0.0, "V", "User-designated flatband voltage for S/D region")
`MPRnb(vfbsdcv, vfbsd, "V", "User-designated flatband voltage for S/D region for C-V calculations")
`MPRoz(toxref, 1.2e-9, "m", "Target tox value")
`MPRco(toxg, toxp, "m", 1.0e-10, inf, "Oxide thickness for gate current model")
`MPRoz(igbinvclamp, 1.0e-3, "", "Clamping value of the exponent for Igb in inversion")
`MPRoz(igbaccclamp, 1.0e-3, "", "Clamping value of the exponent for Igb in accumulation")
`MPRoz(igcinvclamp, 5.0e-4, "", "Clamping value of the exponent for Igc in inversion")

`MPRnb(ntox, 1.0, "", "Exponent for Tox ratio")
`MPRnb(lntox, 0.0, "m", "L-term of ntox")
`MPRnb(nntox, 0.0, "", "N-term of ntox")
`MPRnb(pntox, 0.0, "m", "P-term of ntox")
`MPRnb(wntox, 0.0, "m", "W-term of ntox")
`MPRnb(p2ntox, 0.0, "m^2", "WL-term of ntox")

`MPRnb(aigbinv, 1.11e-2, "(F*s^2/g)^0.5/m", "Parameter for Igb in inversion")
`MPRnb(laigbinv, 0.0, "(F*s^2/g)^0.5", "L-term of aigbinv")
`MPRnb(naigbinv, 0.0, "(F*s^2/g)^0.5/m", "N-term of aigbinv")
`MPRnb(paigbinv, 0.0, "(F*s^2/g)^0.5", "P-term of aigbinv")
`MPRnb(waigbinv, 0.0, "(F*s^2/g)^0.5", "W-term of aigbinv")
`MPRnb(p2aigbinv, 0.0, "m*(F*s^2/g)^0.5", "WL-term of aigbinv")

`MPRnb(aigbinv1, 0.0, "(F*s^2/g)^0.5/(m*K)", "Parameter for Igb in inversion")
`MPRnb(laigbinv1, 0.0, "(F*s^2/g)^0.5/K", "L-term of aigbinv1")
`MPRnb(naigbinv1, 0.0, "(F*s^2/g)^0.5/(m*K)", "N-term of aigbinv1")
`MPRnb(paigbinv1, 0.0, "(F*s^2/g)^0.5/K", "P-term of aigbinv1")
`MPRnb(waigbinv1, 0.0, "(F*s^2/g)^0.5/K", "W-term of aigbinv1")
`MPRnb(p2aigbinv1, 0.0, "m*(F*s^2/g)^0.5/K", "WL-term of aigbinv1")

`MPRnb(bigbinv, 9.49e-4, "(F*s^2/g)^0.5/(m*V)", "Parameter for Igb in inversion")
`MPRnb(lbigbinv, 0.0, "(F*s^2/g)^0.5/V", "L-term of bigbinv")
`MPRnb(nbigbinv, 0.0, "(F*s^2/g)^0.5/(m*V)", "N-term of bigbinv")
`MPRnb(pbigbinv, 0.0, "(F*s^2/g)^0.5/V", "P-term of bigbinv")
`MPRnb(wbigbinv, 0.0, "(F*s^2/g)^0.5/V", "W-term of bigbinv")
`MPRnb(p2bigbinv, 0.0, "m*(F*s^2/g)^0.5/V", "WL-term of bigbinv")

`MPRnb(cigbinv, 6.0e-3, "/V", "Parameter for Igb in inversion")
`MPRnb(lcigbinv, 0.0, "m/V", "L-term of cigbinv")
`MPRnb(ncigbinv, 0.0, "/V", "N-term of cigbinv")
`MPRnb(pcigbinv, 0.0, "m/V", "P-term of cigbinv")
`MPRnb(wcigbinv, 0.0, "m/V", "W-term of cigbinv")
`MPRnb(p2cigbinv, 0.0, "(m^2)/V", "WL-term of cigbinv")

`MPRnb(eigbinv, 1.1, "V", "Parameter for Igb in inversion")
`MPRnb(leigbinv, 0.0, "m*V", "L-term of eigbinv")
`MPRnb(neigbinv, 0.0, "V", "N-term of eigbinv")
`MPRnb(peigbinv, 0.0, "m*V", "P-term of eigbinv")
`MPRnb(weigbinv, 0.0, "m*V", "W-term of eigbinv")
`MPRnb(p2eigbinv, 0.0, "(m^2)*V", "WL-term of eigbinv")

`MPRnb(nigbinv, 3.0, "", "Parameter for Igb in inversion")
`MPRnb(lnigbinv, 0.0, "m", "L-term of nigbinv")
`MPRnb(nnigbinv, 0.0, "", "N-term of nigbinv")
`MPRnb(pnigbinv, 0.0, "m", "P-term of nigbinv")
`MPRnb(wnigbinv, 0.0, "m", "W-term of nigbinv")
`MPRnb(p2nigbinv, 0.0, "m^2", "WL-term of nigbinv")

`MPRnb(aigbacc, 1.36e-2, "(F*s^2/g)^0.5/m", "Parameter for Igb in accumulation")
`MPRnb(laigbacc, 0.0, "(F*s^2/g)^0.5", "L-term of aigbacc")
`MPRnb(naigbacc, 0.0, "(F*s^2/g)^0.5/m", "N-term of aigbacc")
`MPRnb(paigbacc, 0.0, "(F*s^2/g)^0.5", "P-term of aigbacc")
`MPRnb(waigbacc, 0.0, "(F*s^2/g)^0.5", "W-term of aigbacc")
`MPRnb(p2aigbacc, 0.0, "m*(F*s^2/g)^0.5", "WL-term of aigbacc")

`MPRnb(aigbacc1, 0.0, "(F*s^2/g)^0.5/(m*K)", "Parameter for Igb in accumulation")
`MPRnb(laigbacc1, 0.0, "(F*s^2/g)^0.5/K", "L-term of aigbacc1")
`MPRnb(naigbacc1, 0.0, "(F*s^2/g)^0.5/(m*K)", "N-term of aigbacc1")
`MPRnb(paigbacc1, 0.0, "(F*s^2/g)^0.5/K", "P-term of aigbacc1")
`MPRnb(waigbacc1, 0.0, "(F*s^2/g)^0.5/K", "W-term of aigbacc1")
`MPRnb(p2aigbacc1, 0.0, "m*(F*s^2/g)^0.5/K", "WL-term of aigbacc1")

`MPRnb(bigbacc, 1.71e-3, "(F*s^2/g)^0.5/(m*V)", "Parameter for Igb in accumulation")
`MPRnb(lbigbacc, 0.0, "(F*s^2/g)^0.5/V", "L-term of bigbacc")
`MPRnb(nbigbacc, 0.0, "(F*s^2/g)^0.5/(m*V)", "N-term of bigbacc")
`MPRnb(pbigbacc, 0.0, "(F*s^2/g)^0.5/V", "P-term of bigbacc")
`MPRnb(wbigbacc, 0.0, "(F*s^2/g)^0.5/V", "W-term of bigbacc")
`MPRnb(p2bigbacc, 0.0, "m*(F*s^2/g)^0.5/V", "WL-term of bigbacc")

`MPRnb(cigbacc, 7.5e-2, "/V", "Parameter for Igb in accumulation")
`MPRnb(lcigbacc, 0.0, "m/V", "L-term of cigbacc")
`MPRnb(ncigbacc, 0.0, "/V", "N-term of cigbacc")
`MPRnb(pcigbacc, 0.0, "m/V", "P-term of cigbacc")
`MPRnb(wcigbacc, 0.0, "m/V", "W-term of cigbacc")
`MPRnb(p2cigbacc, 0.0, "(m^2)/V", "WL-term of cigbacc")

`MPRnb(nigbacc, 1.0, "", "Parameter for Igb in accumulation")
`MPRnb(lnigbacc, 0.0, "m", "L-term of nigbacc")
`MPRnb(nnigbacc, 0.0, "", "N-term of nigbacc")
`MPRnb(pnigbacc, 0.0, "m", "P-term of nigbacc")
`MPRnb(wnigbacc, 0.0, "m", "W-term of nigbacc")
`MPRnb(p2nigbacc, 0.0, "m^2", "WL-term of nigbacc")

`MPRnb(aigc, 1.36e-2, "(F*s^2/g)^0.5/m", "Parameter for Igc in inversion")
`MPRnb(laigc, 0.0, "(F*s^2/g)^0.5", "L-term of aigc")
`MPRnb(naigc, 0.0, "(F*s^2/g)^0.5/m", "N-term of aigc")
`MPRnb(paigc, 0.0, "(F*s^2/g)^0.5", "P-term of aigc")
`MPRnb(waigc, 0.0, "(F*s^2/g)^0.5", "W-term of aigc")
`MPRnb(p2aigc, 0.0, "m*(F*s^2/g)^0.5", "WL-term of aigc")

`MPRnb(aigc1, 0.0, "(F*s^2/g)^0.5/(m*K)", "Parameter for Igc in inversion")
`MPRnb(laigc1, 0.0, "(F*s^2/g)^0.5/K", "L-term of aigc1")
`MPRnb(naigc1, 0.0, "(F*s^2/g)^0.5/(m*K)", "N-term of aigc1")
`MPRnb(paigc1, 0.0, "(F*s^2/g)^0.5/K", "P-term of aigc1")
`MPRnb(waigc1, 0.0, "(F*s^2/g)^0.5/K", "W-term of aigc1")
`MPRnb(p2aigc1, 0.0, "m*(F*s^2/g)^0.5/K", "WL-term of aigc1")

`MPRnb(bigc, 1.71e-3, "(F*s^2/g)^0.5/(m*V)", "Parameter for Igc in inversion")
`MPRnb(lbigc, 0.0, "(F*s^2/g)^0.5/V", "L-term of bigc")
`MPRnb(nbigc, 0.0, "(F*s^2/g)^0.5/(m*V)", "N-term of bigc")
`MPRnb(pbigc, 0.0, "(F*s^2/g)^0.5/V", "P-term of bigc")
`MPRnb(wbigc, 0.0, "(F*s^2/g)^0.5/V", "W-term of bigc")
`MPRnb(p2bigc, 0.0, "m*(F*s^2/g)^0.5/V", "WL-term of bigc")

`MPRnb(cigc, 7.5e-2, "/V", "Parameter for Igc in inversion")
`MPRnb(lcigc, 0.0, "m/V", "L-term of cigc")
`MPRnb(ncigc, 0.0, "/V", "N-term of cigc")
`MPRnb(pcigc, 0.0, "m/V", "P-term of cigc")
`MPRnb(wcigc, 0.0, "m/V", "W-term of cigc")
`MPRnb(p2cigc, 0.0, "(m^2)/V", "WL-term of cigc")

`MPRnb(pigcd, 1.0, "", "Parameter for Igc partition")
`MPRnb(lpigcd, 0.0, "m", "L-term of pigcd")
`MPRnb(npigcd, 0.0, "", "N-term of pigcd")
`MPRnb(ppigcd, 0.0, "m", "P-term of pigcd")
`MPRnb(wpigcd, 0.0, "m", "W-term of pigcd")
`MPRnb(p2pigcd, 0.0, "m^2", "WL-term of pigcd")

`MPRnb(aigs, 1.36e-2, "(F*s^2/g)^0.5/m", "Parameter for Igs in inversion")
`MPRnb(laigs, 0.0, "(F*s^2/g)^0.5", "L-term of aigs")
`MPRnb(naigs, 0.0, "(F*s^2/g)^0.5/m", "N-term of aigs")
`MPRnb(paigs, 0.0, "(F*s^2/g)^0.5", "P-term of aigs")
`MPRnb(waigs, 0.0, "(F*s^2/g)^0.5", "W-term of aigs")
`MPRnb(p2aigs, 0.0, "m*(F*s^2/g)^0.5", "WL-term of aigs")

`MPRnb(aigs1, 0.0, "(F*s^2/g)^0.5/(m*K)", "Parameter for Igs in inversion")
`MPRnb(laigs1, 0.0, "(F*s^2/g)^0.5/K", "L-term of aigs1")
`MPRnb(naigs1, 0.0, "(F*s^2/g)^0.5/(m*K)", "N-term of aigs1")
`MPRnb(paigs1, 0.0, "(F*s^2/g)^0.5/K", "P-term of aigs1")
`MPRnb(waigs1, 0.0, "(F*s^2/g)^0.5/K", "W-term of aigs1")
`MPRnb(p2aigs1, 0.0, "m*(F*s^2/g)^0.5/K", "WL-term of aigs1")

`MPRnb(bigs, 1.71e-3, "(F*s^2/g)^0.5/(m*V)", "Parameter for Igs in inversion")
`MPRnb(lbigs, 0.0, "(F*s^2/g)^0.5/V", "L-term of bigs")
`MPRnb(nbigs, 0.0, "(F*s^2/g)^0.5/(m*V)", "N-term of bigs")
`MPRnb(pbigs, 0.0, "(F*s^2/g)^0.5/V", "P-term of bigs")
`MPRnb(wbigs, 0.0, "(F*s^2/g)^0.5/V", "W-term of bigs")
`MPRnb(p2bigs, 0.0, "m*(F*s^2/g)^0.5/V", "WL-term of bigs")

`MPRnb(cigs, 7.5e-2, "/V", "Parameter for Igs in inversion")
`MPRnb(lcigs, 0.0, "m/V", "L-term of cigs")
`MPRnb(ncigs, 0.0, "/V", "N-term of cigs")
`MPRnb(pcigs, 0.0, "m/V", "P-term of cigs")
`MPRnb(wcigs, 0.0, "m/V", "W-term of cigs")
`MPRnb(p2cigs, 0.0, "(m^2)/V", "WL-term of cigs")

`MPRnb(aigd, aigs, "(F*s^2/g)^0.5/m", "Parameter for Igd in inversion")
`MPRnb(laigd, laigs, "(F*s^2/g)^0.5", "L-term of aigd")
`MPRnb(naigd, naigs, "(F*s^2/g)^0.5/m", "N-term of aigd")
`MPRnb(paigd, paigs, "(F*s^2/g)^0.5", "P-term of aigd")
`MPRnb(waigd, waigs, "(F*s^2/g)^0.5", "W-term of aigd")
`MPRnb(p2aigd, p2aigs, "m*(F*s^2/g)^0.5", "WL-term of aigd")

`MPRnb(aigd1, aigs1, "(F*s^2/g)^0.5/(m*K)", "Parameter for Igd in inversion")
`MPRnb(laigd1, laigs1, "(F*s^2/g)^0.5/K", "L-term of aigd1")
`MPRnb(naigd1, naigs1, "(F*s^2/g)^0.5/(m*K)", "N-term of aigd1")
`MPRnb(paigd1, paigs1, "(F*s^2/g)^0.5/K", "P-term of aigd1")
`MPRnb(waigd1, waigs1, "(F*s^2/g)^0.5/K", "W-term of aigd1")
`MPRnb(p2aigd1, p2aigs1, "m*(F*s^2/g)^0.5/K", "WL-term of aigd1")

`MPRnb(bigd, bigs, "(F*s^2/g)^0.5/(m*V)", "Parameter for Igd in inversion")
`MPRnb(lbigd, lbigs, "(F*s^2/g)^0.5/V", "L-term of bigd")
`MPRnb(nbigd, nbigs, "(F*s^2/g)^0.5/(m*V)", "N-term of bigd")
`MPRnb(pbigd, pbigs, "(F*s^2/g)^0.5/V", "P-term of bigd")
`MPRnb(wbigd, wbigs, "(F*s^2/g)^0.5/V", "W-term of bigd")
`MPRnb(p2bigd, p2bigs, "m*(F*s^2/g)^0.5/V", "WL-term of bigd")

`MPRnb(cigd, cigs, "/V", "Parameter for Igd in inversion")
`MPRnb(lcigd, lcigs, "m/V", "L-term of cigd")
`MPRnb(ncigd, ncigs, "/V", "N-term of cigd")
`MPRnb(pcigd, pcigs, "m/V", "P-term of cigd")
`MPRnb(wcigd, wcigs, "m/V", "W-term of cigd")
`MPRnb(p2cigd, p2cigs, "(m^2)/V", "WL-term of cigd")

`MPRnb(poxedge, 1.0, "", "Factor for the gate edge Tox")
`MPRnb(lpoxedge, 0.0, "m", "L-term of poxedge")
`MPRnb(npoxedge, 0.0, "", "N-term of poxedge")
`MPRnb(ppoxedge, 0.0, "m", "P-term of poxedge")
`MPRnb(wpoxedge, 0.0, "m", "W-term of poxedge")
`MPRnb(p2poxedge, 0.0, "m^2", "WL-term of poxedge")

// GIDL, GISL currents
`MPRnb(agidl, 6.055e-12, "/ohm", "Pre-exponential coefficient for GIDL")
`MPRnb(lagidl, 0.0, "m/ohm", "L-term of agidl")
`MPRnb(nagidl, 0.0, "/ohm", "N-term of agidl")
`MPRnb(pagidl, 0.0, "m/ohm", "P-term of agidl")
`MPRnb(wagidl, 0.0, "m/ohm", "W-term of agidl")
`MPRnb(p2agidl, 0.0, "(m^2)/ohm", "WL-term of agidl")

`MPRnb(bgidl, 3.0e8, "V/m", "Exponential coefficient for GIDL")
`MPRnb(lbgidl, 0.0, "V", "L-term of bgidl")
`MPRnb(nbgidl, 0.0, "V/m", "N-term of bgidl")
`MPRnb(pbgidl, 0.0, "V", "P-term of bgidl")
`MPRnb(wbgidl, 0.0, "V", "W-term of bgidl")
`MPRnb(p2bgidl, 0.0, "m*V", "WL-term of bgidl")

`MPRnb(cgidl, 0.5, "V^3", "Parameter for body-effect of GIDL")
`MPRnb(lcgidl, 0.0, "m*(V^3)", "L-term of cgidl")
`MPRnb(ncgidl, 0.0, "V^3", "N-term of cgidl")
`MPRnb(pcgidl, 0.0, "m*(V^3)", "P-term of cgidl")
`MPRnb(wcgidl, 0.0, "m*(V^3)", "W-term of cgidl")
`MPRnb(p2cgidl, 0.0, "(m^2)*(V^3)", "WL-term of cgidl")

`MPRnb(egidl, 0.2, "V", "Band bending parameter for GIDL")
`MPRnb(legidl, 0.0, "m*V", "L-term of egidl")
`MPRnb(negidl, 0.0, "V", "N-term of egidl")
`MPRnb(pegidl, 0.0, "m*V", "P-term of egidl")
`MPRnb(wegidl, 0.0, "m*V", "W-term of egidl")
`MPRnb(p2egidl, 0.0, "(m^2)*V", "WL-term of egidl")

`MPRnb(pgidl, 1.0, "", "Parameter for body-bias effect on GIDL")
`MPRnb(lpgidl, 0.0, "m", "L-term of pgidl")
`MPRnb(npgidl, 0.0, "", "N-term of pgidl")
`MPRnb(ppgidl, 0.0, "m", "P-term of pgidl")
`MPRnb(wpgidl, 0.0, "m", "W-term of pgidl")
`MPRnb(p2pgidl, 0.0, "m^2", "WL-term of pgidl")

`MPRnb(agisl, agidl, "/ohm", "Pre-exponential coefficient for GISL")
`MPRnb(lagisl, lagidl, "m/ohm", "L-term of agisl")
`MPRnb(nagisl, nagidl, "/ohm", "N-term of agisl")
`MPRnb(pagisl, pagidl, "m/ohm", "P-term of agisl")
`MPRnb(wagisl, wagidl, "m/ohm", "W-term of agisl")
`MPRnb(p2agisl, p2agidl, "(m^2)/ohm", "WL-term of agisl")

`MPRnb(bgisl, bgidl, "V/m", "Exponential coefficient for GISL")
`MPRnb(lbgisl, lbgidl, "V", "L-term of bgisl")
`MPRnb(nbgisl, nbgidl, "V/m", "N-term of bgisl")
`MPRnb(pbgisl, pbgidl, "V", "P-term of bgisl")
`MPRnb(wbgisl, wbgidl, "V", "W-term of bgisl")
`MPRnb(p2bgisl, p2bgidl, "m*V", "WL-term of bgisl")

`MPRnb(cgisl, cgidl, "V^3", "Parameter for body-effect of GISL")
`MPRnb(lcgisl, lcgidl, "m*(V^3)", "L-term of cgisl")
`MPRnb(ncgisl, ncgidl, "V^3", "N-term of cgisl")
`MPRnb(pcgisl, pcgidl, "m*(V^3)", "P-term of cgisl")
`MPRnb(wcgisl, wcgidl, "m*(V^3)", "W-term of cgisl")
`MPRnb(p2cgisl, p2cgidl, "(m^2)*(V^3)", "WL-term of cgisl")

`MPRnb(egisl, egidl, "V", "Band bending parameter for GISL")
`MPRnb(legisl, legidl, "m*V", "L-term of egisl")
`MPRnb(negisl, negidl, "V", "N-term of egisl")
`MPRnb(pegisl, pegidl, "m*V", "P-term of egisl")
`MPRnb(wegisl, wegidl, "m*V", "W-term of egisl")
`MPRnb(p2egisl, p2egidl, "(m^2)*V", "WL-term of egisl")

`MPRnb(pgisl, pgidl, "", "Parameter for body-bias effect on GISL")
`MPRnb(lpgisl, lpgidl, "m", "L-term of pgisl")
`MPRnb(npgisl, npgidl, "", "N-term of pgisl")
`MPRnb(ppgisl, ppgidl, "m", "P-term of pgisl")
`MPRnb(wpgisl, wpgidl, "m", "W-term of pgisl")
`MPRnb(p2pgisl, p2pgidl, "m^2", "WL-term of pgisl")

// TAT GIDL, GISL currents
`MPRnb(atatd, 1.0e-27, "A*(m^2)", "Pre-exponential coefficient for TAT GIDL")
`MPRnb(latatd, 0.0, "A*(m^3)", "L-term of atatd")
`MPRnb(natatd, 0.0, "A*(m^2)", "N-term of atatd")
`MPRnb(patatd, 0.0, "A*(m^3)", "P-term of atatd")
`MPRnb(watatd, 0.0, "A*(m^3)", "W-term of atatd")
`MPRnb(p2atatd, 0.0, "A*(m^4)", "WL-term of atatd")

`MPRnb(btatd, 6.3e-5, "V^-1", "Field correction parameter for TAT GIDL")
`MPRnb(lbtatd, 0.0, "m*(V^-1)", "L-term of btatd")
`MPRnb(nbtatd, 0.0, "V^-1", "N-term of btatd")
`MPRnb(pbtatd, 0.0, "V^-1*m", "P-term of btatd")
`MPRnb(wbtatd, 0.0, "m*(V^-1)", "W-term of btatd")
`MPRnb(p2btatd, 0.0, "(m^2)*(V^-1)", "WL-term of btatd")

`MPRnb(ctatd, 0.215, "", "Field correction parameter for TAT GIDL")
`MPRnb(lctatd, 0.0, "m", "L-term of ctatd")
`MPRnb(nctatd, 0.0, "", "N-term of ctatd")
`MPRnb(pctatd, 0.0, "m", "P-term of ctatd")
`MPRnb(wctatd, 0.0, "m", "W-term of ctatd")
`MPRnb(p2ctatd, 0.0, "m^2", "WL-term of ctatd")

`MPRnb(dtatd, 0.382, "V", "Field correction parameter for TAT GIDL")
`MPRnb(ldtatd, 0.0, "m*V", "L-term of dtatd")
`MPRnb(ndtatd, 0.0, "V", "N-term of dtatd")
`MPRnb(pdtatd, 0.0, "m*V", "P-term of dtatd")
`MPRnb(wdtatd, 0.0, "m*V", "W-term of dtatd")
`MPRnb(p2dtatd, 0.0, "(m^2)*V", "WL-term of dtatd")

`MPRnb(atats, atatd, "A*(m^2)", "Pre-exponential coefficient for TAT GISL")
`MPRnb(latats, 0.0, "A*(m^3)", "L-term of atats")
`MPRnb(natats, 0.0, "A*(m^2)", "N-term of atats")
`MPRnb(patats, 0.0, "A*(m^3)", "P-term of atats")
`MPRnb(watats, 0.0, "A*(m^3)", "W-term of atats")
`MPRnb(p2atats, 0.0, "A*(m^4)", "WL-term of atats")

`MPRnb(btats, btatd, "V^-1", "Field correction parameter for TAT GISL")
`MPRnb(lbtats, 0.0, "m*(V^-1)", "L-term of btats")
`MPRnb(nbtats, 0.0, "V^-1", "N-term of btats")
`MPRnb(pbtats, 0.0, "V^-1*m", "P-term of btats")
`MPRnb(wbtats, 0.0, "m*(V^-1)", "W-term of btats")
`MPRnb(p2btats, 0.0, "(m^2)*(V^-1)", "WL-term of btats")

`MPRnb(ctats, ctatd, "", "Field correction parameter for TAT GISL")
`MPRnb(lctats, 0.0, "m", "L-term of ctats")
`MPRnb(nctats, 0.0, "", "N-term of ctats")
`MPRnb(pctats, 0.0, "m", "P-term of ctats")
`MPRnb(wctats, 0.0, "m", "W-term of ctats")
`MPRnb(p2ctats, 0.0, "m^2", "WL-term of ctats")

`MPRnb(dtats, dtatd, "V", "Field correction parameter for TAT GISL")
`MPRnb(ldtats, 0.0, "m*V", "L-term of dtats")
`MPRnb(ndtats, 0.0, "V", "N-term of dtats")
`MPRnb(pdtats, 0.0, "m*V", "P-term of dtats")
`MPRnb(wdtats, 0.0, "m*V", "W-term of dtats")
`MPRnb(p2dtats, 0.0, "(m^2)*V", "WL-term of dtats")

//Parasitic substrate GIDL, GISL currents
`MPRnb(agidlb, 6.055e-12, "/ohm", "Pre-exponential coefficient for parasitic substrate GIDL")
`MPRnb(lagidlb, 0.0, "m/ohm", "L-term of agidlb")
`MPRnb(nagidlb, 0.0, "/ohm", "N-term of agidlb")
`MPRnb(pagidlb, 0.0, "m/ohm", "P-term of agidlb")
`MPRnb(wagidlb, 0.0, "m/ohm", "W-term of agidlb")
`MPRnb(p2agidlb, 0.0, "(m^2)/ohm", "WL-term of agidlb")

`MPRnb(bgidlb, 3.0e8, "V/m", "Exponential coefficient for parasitic substrate GIDL")
`MPRnb(lbgidlb, 0.0, "V", "L-term of bgidlb")
`MPRnb(nbgidlb, 0.0, "V/m", "N-term of bgidlb")
`MPRnb(pbgidlb, 0.0, "V", "P-term of bgidlb")
`MPRnb(wbgidlb, 0.0, "V", "W-term of bgidlb")
`MPRnb(p2bgidlb, 0.0, "m*V", "WL-term of bgidlb")

`MPRnb(cgidlb, 0.5, "V^3", "Parameter for body-effect of parasitic substrate GIDL")
`MPRnb(lcgidlb, 0.0, "m*(V^3)", "L-term of cgidlb")
`MPRnb(ncgidlb, 0.0, "V^3", "N-term of cgidlb")
`MPRnb(pcgidlb, 0.0, "m*(V^3)", "P-term of cgidlb")
`MPRnb(wcgidlb, 0.0, "m*(V^3)", "W-term of cgidlb")
`MPRnb(p2cgidlb, 0.0, "(m^2)*(V^3)", "WL-term of cgidlb")

`MPRnb(egidlb, 0.2, "V", "Band bending parameter for parasitic substrate GIDL")
`MPRnb(legidlb, 0.0, "m*V", "L-term of egidlb")
`MPRnb(negidlb, 0.0, "V", "N-term of egidlb")
`MPRnb(pegidlb, 0.0, "m*V", "P-term of egidlb")
`MPRnb(wegidlb, 0.0, "m*V", "W-term of egidlb")
`MPRnb(p2egidlb, 0.0, "(m^2)*V", "WL-term of egidlb")

`MPRnb(pgidlb, 1.0, "", "Parameter for body-bias effect on parasitic substrate GIDL")
`MPRnb(lpgidlb, 0.0, "m", "L-term of pgidlb")
`MPRnb(npgidlb, 0.0, "", "N-term of pgidlb")
`MPRnb(ppgidlb, 0.0, "m", "P-term of pgidlb")
`MPRnb(wpgidlb, 0.0, "m", "W-term of pgidlb")
`MPRnb(p2pgidlb, 0.0, "m^2", "WL-term of pgidlb")

`MPRnb(agislb, agidlb, "/ohm", "Pre-exponential coefficient for parasitic substrate GISL")
`MPRnb(lagislb, lagidlb, "m/ohm", "L-term of agislb")
`MPRnb(nagislb, nagidlb, "/ohm", "N-term of agislb")
`MPRnb(pagislb, pagidlb, "m/ohm", "P-term of agislb")
`MPRnb(wagislb, wagidlb, "m/ohm", "W-term of agislb")
`MPRnb(p2agislb, p2agidlb, "(m^2)/ohm", "WL-term of agislb")

`MPRnb(bgislb, bgidlb, "V/m", "Exponential coefficient for parasitic substrate GISL")
`MPRnb(lbgislb, lbgidlb, "V", "L-term of bgislb")
`MPRnb(nbgislb, nbgidlb, "V/m", "N-term of bgislb")
`MPRnb(pbgislb, pbgidlb, "V", "P-term of bgislb")
`MPRnb(wbgislb, wbgidlb, "V", "W-term of bgislb")
`MPRnb(p2bgislb, p2bgidlb, "m*V", "WL-term of bgislb")

`MPRnb(cgislb, cgidlb, "V^3", "Parameter for body-effect of parasitic substrate GISL")
`MPRnb(lcgislb, lcgidlb, "m*(V^3)", "L-term of cgislb")
`MPRnb(ncgislb, ncgidlb, "V^3", "N-term of cgislb")
`MPRnb(pcgislb, pcgidlb, "m*(V^3)", "P-term of cgislb")
`MPRnb(wcgislb, wcgidlb, "m*(V^3)", "W-term of cgislb")
`MPRnb(p2cgislb, p2cgidlb, "(m^2)*(V^3)", "WL-term of cgislb")

`MPRnb(egislb, egidlb, "V", "Band bending parameter for parasitic substrate GISL")
`MPRnb(legislb, legidlb, "m*V", "L-term of egislb")
`MPRnb(negislb, negidlb, "V", "N-term of egislb")
`MPRnb(pegislb, pegidlb, "m*V", "P-term of egislb")
`MPRnb(wegislb, wegidlb, "m*V", "W-term of egislb")
`MPRnb(p2egislb, p2egidlb, "(m^2)*V", "WL-term of egislb")

`MPRnb(pgislb, pgidlb, "", "Parameter for body-bias effect on parasitic substrate GISL")
`MPRnb(lpgislb, lpgidlb, "m", "L-term of pgislb")
`MPRnb(npgislb, npgidlb, "", "N-term of pgislb")
`MPRnb(ppgislb, ppgidlb, "m", "P-term of pgislb")
`MPRnb(wpgislb, wpgidlb, "m", "W-term of pgislb")
`MPRnb(p2pgislb, p2pgidlb, "m^2", "WL-term of pgislb")

// Impact ionization current
`MPRnb(alpha01, 0.0, "m/(V*K)", "Temperature dependence of alpha0")
`MPRnb(alpha11, 0.0, "/(V*K)", "Temperature dependence alpha1")
`MPRnb(alphaii01, 0.0, "m/(V*K)", "Temperature dependence of alphaii0")
`MPRnb(alphaii11, 0.0, "m/(V*K)", "Temperature dependence of alphaii1")
`MPRoz(iimod2clamp1, 0.1, "V", "Clamp1 of sii1 * Vg term in iimod = 2")
`MPRoz(iimod2clamp2, 0.1, "V", "Clamp2 of sii0 * Vg term in iimod = 2")
`MPRoz(iimod2clamp3, 0.1, "m*V", "Clamp3 of ratio term in iimod = 2")

`MPRnb(alpha0, 0.0, "m/V", "First parameter of Iii")
`MPRnb(lalpha0, 0.0, "m^2/V", "L-term of alpha0")
`MPRnb(nalpha0, 0.0, "m/V", "N-term of alpha0")
`MPRnb(palpha0, 0.0, "m^2/V", "P-term of alpha0")
`MPRnb(walpha0, 0.0, "m^2/V", "W-term of alpha0")
`MPRnb(p2alpha0, 0.0, "m^3/V", "WL-term of alpha0")

`MPRnb(alpha1, 0.0, "/V", "l scaling parameter of Iii")
`MPRnb(lalpha1, 0.0, "m/V", "L-term of alpha1")
`MPRnb(nalpha1, 0.0, "/V", "N-term of alpha1")
`MPRnb(palpha1, 0.0, "m/V", "P-term of alpha1")
`MPRnb(walpha1, 0.0, "m/V", "W-term of alpha1")
`MPRnb(p2alpha1, 0.0, "(m^2)/V", "WL-term of alpha1")

`MPRnb(beta0, 0.0, "/V", "Vds dependence parameter of Iii")
`MPRnb(lbeta0, 0.0, "m/V", "L-term of beta0")
`MPRnb(nbeta0, 0.0, "/V", "N-term of beta0")
`MPRnb(pbeta0, 0.0, "m/V", "P-term of beta0")
`MPRnb(wbeta0, 0.0, "m/V", "W-term of beta0")
`MPRnb(p2beta0, 0.0, "m^2/V", "WL-term of beta0")

`MPRnb(alphaii0, 0.0, "m/V", "First parameter of Iii for iimod = 2")
`MPRnb(lalphaii0, 0.0, "(m^2)/V", "L-term of alphaii0")
`MPRnb(nalphaii0, 0.0, "m/V", "N-term of alphaii0")
`MPRnb(palphaii0, 0.0, "(m^2)/V", "P-term of alphaii0")
`MPRnb(walphaii0, 0.0, "(m^2)/V", "W-term of alphaii0")
`MPRnb(p2alphaii0, 0.0, "(m^3)/V", "WL-term of alphaii0")

`MPRnb(alphaii1, 0.0, "/V", "l scaling parameter of Iii for iimod = 2")
`MPRnb(lalphaii1, 0.0, "m/V", "L-term of alphaii1")
`MPRnb(nalphaii1, 0.0, "/V", "N-term of alphaii1")
`MPRnb(palphaii1, 0.0, "m/V", "P-term of alphaii1")
`MPRnb(walphaii1, 0.0, "m/V", "W-term of alphaii1")
`MPRnb(p2alphaii1, 0.0, "(m^2)/V", "WL-term of alphaii1")

`MPRnb(betaii0, 0.0, "/V", "Vds dependence parameter of Iii")
`MPRnb(lbetaii0, 0.0, "m/V", "L-term of betaii0")
`MPRnb(nbetaii0, 0.0, "/V", "N-term of betaii0")
`MPRnb(pbetaii0, 0.0, "m/V", "P-term of betaii0")
`MPRnb(wbetaii0, 0.0, "m/V", "W-term of betaii0")
`MPRnb(p2betaii0, 0.0, "(m^2)/V", "WL-term of betaii0")

`MPRnb(betaii1, 0.0, "", "Vds dependence parameter of Iii")
`MPRnb(lbetaii1, 0.0, "m", "L-term of betaii1")
`MPRnb(nbetaii1, 0.0, "", "N-term of betaii1")
`MPRnb(pbetaii1, 0.0, "m", "P-term of betaii1")
`MPRnb(wbetaii1, 0.0, "m", "W-term of betaii1")
`MPRnb(p2betaii1, 0.0, "m^2", "WL-term of betaii1")

`MPRnb(betaii2, 0.1, "V", "Vds dependence parameter of Iii")
`MPRnb(lbetaii2, 0.0, "m*V", "L-term of betaii2")
`MPRnb(nbetaii2, 0.0, "V", "N-term of betaii2")
`MPRnb(pbetaii2, 0.0, "m*V", "P-term of betaii2")
`MPRnb(wbetaii2, 0.0, "m*V", "W-term of betaii2")
`MPRnb(p2betaii2, 0.0, "(m^2)*V", "WL-term of betaii2")

`MPRnb(esatii, 1.0e7, "V/m", "Saturation channel E-field for Iii")
`MPRnb(lesatii, 0.0, "V", "L-term of esatii")
`MPRnb(nesatii, 0.0, "V/m", "N-term of esatii")
`MPRnb(pesatii, 0.0, "V", "P-term of esatii")
`MPRnb(wesatii, 0.0, "V", "W-term of esatii")
`MPRnb(p2esatii, 0.0, "m*V", "WL-term of esatii")

`MPRnb(lii, 0.5e-9, "m*V", "Channel length dependence parameter of Iii")
`MPRnb(llii, 0.0, "m^2*V", "L-term of lii")
`MPRnb(nlii, 0.0, "m*V", "N-term of lii")
`MPRnb(plii, 0.0, "m^2*V", "P-term of lii")
`MPRnb(wlii, 0.0, "m^2*V", "W-term of lii")
`MPRnb(p2lii, 0.0, "(m^3)*V", "WL-term of lii")

`MPRnb(sii0, 0.5, "/V", "Vgs dependence parameter of Iii")
`MPRnb(lsii0, 0.0, "m/V", "L-term of sii0")
`MPRnb(nsii0, 0.0, "/V", "N-term of sii0")
`MPRnb(psii0, 0.0, "m/V", "P-term of sii0")
`MPRnb(wsii0, 0.0, "m/V", "W-term of sii0")
`MPRnb(p2sii0, 0.0, "(m^2)/V", "WL-term of sii0")

`MPRnb(sii1, 0.1, "", "1st Vgs dependence parameter of Iii")
`MPRnb(lsii1, 0.0, "m", "L-term of sii1")
`MPRnb(nsii1, 0.0, "", "N-term of sii1")
`MPRnb(psii1, 0.0, "m", "P-term of sii1")
`MPRnb(wsii1, 0.0, "m", "W-term of sii1")
`MPRnb(p2sii1, 0.0, "m^2", "WL-term of sii1")

`MPRnb(sii2, 0.0, "V", "2nd Vgs dependence parameter of Iii")
`MPRnb(lsii2, 0.0, "m*V", "L-term of sii2")
`MPRnb(nsii2, 0.0, "V", "N-term of sii2")
`MPRnb(psii2, 0.0, "m*V", "P-term of sii2")
`MPRnb(wsii2, 0.0, "m*V", "W-term of sii2")
`MPRnb(p2sii2, 0.0, "(m^2)*V", "WL-term of sii2")

`MPRnb(siid, 0.0, "V", "3rd Vds dependence parameter of Iii")
`MPRnb(lsiid, 0.0, "m*V", "L-term of siid")
`MPRnb(nsiid, 0.0, "V", "N-term of siid")
`MPRnb(psiid, 0.0, "m*V", "P-term of siid")
`MPRnb(wsiid, 0.0, "m*V", "W-term of siid")
`MPRnb(p2siid, 0.0, "(m^2)*V", "WL-term of siid")

// Accumulation capacitance
`MPRco(eotacc, eot, "m", 1.0e-10, inf, "Equivalent oxide thickness for accumulation region")
`MPRnb(delvfbacc, 0.0, "V", "Change in flatband voltage: Vfb_accumulation - Vfb_inversion")

// Fringe capacitance
`MPRnb(cfs, 2.5e-11, "F/m", "Outer fringe capacitance at source side")
`MPRnb(lcfs, 0.0, "F", "L-term of cfs")
`MPRnb(ncfs, 0.0, "F/m", "N-term of cfs")
`MPRnb(pcfs, 0.0, "F", "P-term of cfs")
`MPRnb(wcfs, 0.0, "F", "W-term of cfs")
`MPRnb(p2cfs, 0.0, "F*m", "WL-term of cfs")

`MPRnb(cfd, cfs, "F/m", "Outer fringe capacitance at drain side")
`MPRnb(lcfd, lcfs, "F", "L-term of cfd")
`MPRnb(ncfd, ncfs, "F/m", "N-term of cfd")
`MPRnb(pcfd, pcfs, "F", "P-term of cfd")
`MPRnb(wcfd, wcfs, "F", "W-term of cfd")
`MPRnb(p2cfd, p2cfs, "F*m", "WL-term of cfd")

// Overlap capacitance
`MPRcz(cgso, 0.0, "F/m", "User-designated non-LDD region source-gate overlap capacitance per unit channel width")
`MPRcz(cgdo, cgso, "F/m", "User-designated non-LDD region drain-gate overlap capacitance per unit channel width")
`MPRcz(cgbo, 0.0, "F/m", "Gate-to-substrate overlap capacitance per unit channel length per finger per ngcon")
`MPRcz(cgbn, 0.0, "F/m", "Gate-to-substrate overlap capacitance per unit channel length per fin per finger")
`MPRcz(cgbw, 0.0, "F/m^2", "GAA gate-to-substrate overlap capacitance per unit area per fin per finger")

`MPRnb(cgsl, 0.0, "F/m", "Overlap capacitance between gate and lightly-doped source region (cgeomod = 0, 2, 3)")
`MPRnb(lcgsl, 0.0, "F", "L-term of cgsl")
`MPRnb(ncgsl, 0.0, "F/m", "N-term of cgsl")
`MPRnb(pcgsl, 0.0, "F", "P-term of cgsl")
`MPRnb(wcgsl, 0.0, "F", "W-term of cgsl")
`MPRnb(p2cgsl, 0.0, "F*m", "WL-term of cgsl")

`MPRnb(cgdl, cgsl, "F/m", "Overlap capacitance between gate and lightly-doped drain region (cgeomod = 0, 2, 3)")
`MPRnb(lcgdl, lcgsl, "F", "L-term of cgdl")
`MPRnb(ncgdl, ncgsl, "F/m", "N-term of cgdl")
`MPRnb(pcgdl, pcgsl, "F", "P-term of cgdl")
`MPRnb(wcgdl, wcgsl, "F", "W-term of cgdl")
`MPRnb(p2cgdl, p2cgsl, "F*m", "WL-term of cgdl")

`MPRnb(cgbl, 0.0, "F/m", "Bias-dependent component of gate-to-substrate overlap capacitance per unit channel length per fin per finger")
`MPRnb(lcgbl, 0.0, "F", "L-term of cgbl")
`MPRnb(ncgbl, 0.0, "F/m", "N-term of cgbl")
`MPRnb(pcgbl, 0.0, "F", "P-term of cgbl")
`MPRnb(wcgbl, 0.0, "F", "W-term of cgbl")
`MPRnb(p2cgbl, 0.0, "F*m", "WL-term of cgbl")

`MPRnb(ckappas, 0.6, "V", "Coefficient of bias-dependent overlap capacitance for the source side (cgeomod = 0, 2, 3)")
`MPRnb(lckappas, 0.0, "m*V", "L-term of ckappas")
`MPRnb(nckappas, 0.0, "V", "N-term of ckappas")
`MPRnb(pckappas, 0.0, "m*V", "P-term of ckappas")
`MPRnb(wckappas, 0.0, "m*V", "W-term of ckappas")
`MPRnb(p2ckappas, 0.0, "(m^2)*V", "WL-term of ckappas")

`MPRnb(ckappad, ckappas, "V", "Coefficient of bias-dependent overlap capacitance for the drain side (cgeomod = 0, 2, 3)")
`MPRnb(lckappad, lckappas, "m*V", "L-term of ckappad")
`MPRnb(nckappad, nckappas, "V", "N-term of ckappad")
`MPRnb(pckappad, pckappas, "m*V", "P-term of ckappad")
`MPRnb(wckappad, wckappas, "m*V", "W-term of ckappad")
`MPRnb(p2ckappad, p2ckappas, "(m^2)*V", "WL-term of ckappad")

`MPRnb(ckappab, 0.6, "V", "Bias-dependent gate-to-substrate parasitic capacitance")
`MPRnb(lckappab, 0.0, "m*V", "L-term of ckappab")
`MPRnb(nckappab, 0.0, "V", "N-term of ckappab")
`MPRnb(pckappab, 0.0, "m*V", "P-term of ckappab")
`MPRnb(wckappab, 0.0, "m*V", "W-term of ckappab")
`MPRnb(p2ckappab, 0.0, "(m^2)*V", "WL-term of ckappab")

// Source/drain-to-substrate sidewall capacitance
`MPRcz(csdesw, 0.0, "F/m", "Coefficient for source/drain-to-substrate sidewall capacitance")

// Junction capacitance
`MPRcz(cjs, 5.0e-4, "F/m^2", "Unit area source-side junction capacitance at zero bias")
`MPRcz(cjd, cjs, "F/m^2", "Unit area drain-side junction capacitance at zero bias")
`MPRcz(cjsws, 5.0e-10, "F/m", "Unit length source-side sidewall junction capacitance at zero bias")
`MPRcz(cjswd, cjsws, "F/m", "Unit length drain-side sidewall junction capacitance at zero bias")
`MPRcz(cjswgs, 0.0, "F/m", "Unit length source-side gate sidewall junction capacitance at zero bias")
`MPRcz(cjswgd, cjswgs, "F/m", "Unit length drain-side gate sidewall junction capacitance at zero bias")
`MPRnb(pbs, 1.0, "V", "Source-side bulk junction built-in potential")
`MPRnb(pbd, pbs, "V", "Drain-side bulk junction built-in potential")
`MPRnb(pbsws, 1.0, "V", "Built-in potential for Source-side sidewall junction capacitance")
`MPRnb(pbswd, pbsws, "V", "Built-in potential for Drain-side sidewall junction capacitance")
`MPRnb(pbswgs, pbsws, "V", "Built-in potential for Source-side gate sidewall junction capacitance")
`MPRnb(pbswgd, pbswgs, "V", "Built-in potential for Drain-side gate sidewall junction capacitance")
`MPRoz(mjs, 0.5, "", "Source bottom junction capacitance grading coefficient")
`MPRoz(mjd, mjs, "", "Drain bottom junction capacitance grading coefficient")
`MPRoz(mjsws, 0.33, "", "Source sidewall junction capacitance grading coefficient")
`MPRoz(mjswd, mjsws, "", "Drain sidewall junction capacitance grading coefficient")
`MPRoz(mjswgs, mjsws, "", "Source-side gate sidewall junction capacitance grading coefficient")
`MPRoz(mjswgd, mjswgs, "", "Drain-side gate sidewall junction capacitance grading coefficient")

// Second junction for two-step junction capacitance
`MPRcz(sjs, 0.0, "", "Constant for source-side two-step second junction")
`MPRcz(sjd, sjs, "", "Constant for drain-side two-step second junction")
`MPRcz(sjsws, 0.0, "", "Constant for source-side sidewall two-step second junction")
`MPRcz(sjswd, sjsws, "", "Constant for drain-side sidewall two-step second junction")
`MPRcz(sjswgs, 0.0, "", "Constant for source-side gate sidewall two-step second junction")
`MPRcz(sjswgd, sjswgs, "", "Constant for source-side gate sidewall two-step second junction")
`MPRnb(mjs2, 1.25e-1, "", "Source bottom two-step second junction capacitance grading coefficient")
`MPRnb(mjd2, mjs2, "", "Drain bottom two-step second junction capacitance grading coefficient")
`MPRnb(mjsws2, 8.3e-2, "", "Source sidewall two-step second junction capacitance grading coefficient")
`MPRnb(mjswd2, mjsws2, "", "Drain sidewall two-step second junction capacitance grading coefficient")
`MPRnb(mjswgs2, mjsws2, "", "Source-side gate sidewall two-step second junction capacitance grading coefficient")
`MPRnb(mjswgd2, mjswgs2, "", "Drain-side gate sidewall two-step second junction capacitance grading coefficient")

// Junction current
`MPRcz(jss, 1.0e-4, "A/m^2", "Bottom source junction reverse saturation current density")
`MPRcz(jsd, jss, "A/m^2", "Bottom drain junction reverse saturation current density")
`MPRcz(jsws, 0.0, "A/m", "Unit length reverse saturation current for sidewall source junction")
`MPRcz(jswd, jsws, "A/m", "Unit length reverse saturation current for sidewall drain junction")
`MPRcz(jswgs, 0.0, "A/m", "Unit length reverse saturation current for gate-edge sidewall source junction")
`MPRcz(jswgd, jswgs, "A/m", "Unit length reverse saturation current for gate-edge sidewall drain junction")
`MPRoz(njs, 1.0, "", "Source junction emission coefficient")
`MPRoz(njd, njs, "", "Drain junction emission coefficient")
`MPRnb(ijthsfwd, 0.1, "A", "Forward source diode breakdown limiting current")
`MPRnb(ijthdfwd, ijthsfwd, "A", "Forward drain diode breakdown limiting current")
`MPRnb(ijthsrev, 0.1, "A", "Reverse source diode breakdown limiting current")
`MPRnb(ijthdrev, ijthsrev, "A", "Reverse drain diode breakdown limiting current")
`MPRnb(bvs, 1.0e1, "V", "Source diode breakdown voltage")
`MPRnb(bvd, bvs, "V", "Drain diode breakdown voltage")
`MPRex(xjbvs, 1.0, "", 0.0, "Fitting parameter for source diode breakdown current")
`MPRex(xjbvd, xjbvs, "", 0.0, "Fitting parameter for drain diode breakdown current")

// Tunneling component of junction current
`MPRnb(jtss, 0.0, "A/m^2", "Bottom source junction trap-assisted saturation current density")
`MPRnb(jtsd, jtss, "A/m^2", "Bottom drain junction trap-assisted saturation current density")
`MPRnb(jtssws, 0.0, "A/m", "Unit length trap-assisted saturation current for sidewall source junction")
`MPRnb(jtsswd, jtssws, "A/m", "Unit length trap-assisted saturation current for sidewall drain junction")
`MPRnb(jtsswgs, 0.0, "A/m", "Unit length trap-assisted saturation current for gate-edge sidewall source junction")
`MPRnb(jtsswgd, jtsswgs, "A/m", "Unit length trap-assisted saturation current for gate-edge sidewall drain junction")
`MPRcz(jtweff, 0.0, "m", "Trap-assisted tunneling current width dependence")
`MPRnb(njts, 2.0e1, "", "Non-ideality factor for jtss")
`MPRnb(njtsd, njts, "", "Non-ideality factor for jtsd")
`MPRnb(njtssw, 2.0e1, "", "Non-ideality factor for jtssws")
`MPRnb(njtsswd, njtssw, "", "Non-ideality factor for jtsswd")
`MPRnb(njtsswg, 2.0e1, "", "Non-ideality factor for jtsswgs")
`MPRnb(njtsswgd, njtsswg, "", "Non-ideality factor for jtsswgd")
`MPRnb(vtss, 1.0e1, "V", "Bottom source junction trap-assisted current voltage dependent parameter")
`MPRnb(vtsd, vtss, "V", "Bottom drain junction trap-assisted current voltage dependent parameter")
`MPRnb(vtssws, 1.0e1, "V", "Unit length trap-assisted current voltage dependent parameter for sidewall source junction")
`MPRnb(vtsswd, vtssws, "V", "Unit length trap-assisted current voltage dependent parameter for sidewall drain junction")
`MPRnb(vtsswgs, 1.0e1, "V", "Unit length trap-assisted current voltage dependent parameter for gate-edge sidewall source junction")
`MPRnb(vtsswgd, vtsswgs, "V", "Unit length trap-assisted current voltage dependent parameter for gate-edge sidewall drain junction")

// Recombination-generation current
`MPRnb(lintigen, 0.0, "m", "Lint for thermal generation current")

`MPRnb(ntgen, 1.0, "", "Thermal generation current parameter")
`MPRnb(lntgen, 0.0, "m", "L-term of ntgen")
`MPRnb(nntgen, 0.0, "", "N-term of ntgen")
`MPRnb(pntgen, 0.0, "m", "P-term of ntgen")
`MPRnb(wntgen, 0.0, "m", "W-term of ntgen")
`MPRnb(p2ntgen, 0.0, "m^2", "WL-term of ntgen")

`MPRnb(aigen, 0.0, "/(m^3*V)", "Thermal generation current parameter")
`MPRnb(laigen, 0.0, "/(m^2*V)", "L-term of aigen")
`MPRnb(naigen, 0.0, "/(m^3*V)", "N-term of aigen")
`MPRnb(paigen, 0.0, "/(m^2*V)", "P-term of aigen")
`MPRnb(waigen, 0.0, "/(m^2*V)", "W-term of aigen")
`MPRnb(p2aigen, 0.0, "/(m^1*V)", "WL-term of aigen")

`MPRnb(bigen, 0.0, "m^2/(m^3*V^3)", "Thermal generation current parameter")
`MPRnb(lbigen, 0.0, "m^2/(m^2*V^3)", "L-term of bigen")
`MPRnb(nbigen, 0.0, "m^2/(m^3*V^3)", "N-term of bigen")
`MPRnb(pbigen, 0.0, "m^2/(m^2*V^3)", "P-term of bigen")
`MPRnb(wbigen, 0.0, "m^2/(m^2*V^3)", "W-term of bigen")
`MPRnb(p2bigen, 0.0, "m^2/(m^1*V^3)", "WL-term of bigen")

// NQS gate resistance model & charge deficit model
`MPRnb(xrcrg1, 12.0, "", "Parameter for non-quasistatic gate resistance nqsmod = 1, 2")
`MPRnb(lxrcrg1, 0.0, "m", "L-term of xrcrg1")
`MPRnb(nxrcrg1, 0.0, "", "N-term of xrcrg1")
`MPRnb(pxrcrg1, 0.0, "m", "P-term of xrcrg1")
`MPRnb(wxrcrg1, 0.0, "m", "W-term of xrcrg1")
`MPRnb(p2xrcrg1, 0.0, "m^2", "WL-term of xrcrg1")

`MPRnb(xrcrg2, 1.0, "", "Parameter for non-quasistatic gate resistance nqsmod = 1, 2")
`MPRnb(lxrcrg2, 0.0, "m", "L-term of xrcrg2")
`MPRnb(nxrcrg2, 0.0, "", "N-term of xrcrg2")
`MPRnb(pxrcrg2, 0.0, "m", "P-term of xrcrg2")
`MPRnb(wxrcrg2, 0.0, "m", "W-term of xrcrg2")
`MPRnb(p2xrcrg2, 0.0, "m^2", "WL-term of xrcrg2")

// Flicker noise
`MPRcz(ef, 1.0, "", "Flicker noise frequency exponent")
`MPRcz(em, 4.1e7, "V/m", "Flicker noise parameter")
`MPRoz(noia, 6.25e39, "s^(1-ef)/(eV*m^3)", "Flicker noise parameter")
`MPRcz(noib, 3.125e24, "s^(1-ef)/(eV*m)", "Flicker noise parameter")
`MPRcz(noic, 8.75e7, "m*s^(1-ef)/eV", "Flicker noise parameter")
`MPRcz(k0noi, 1, "", "Flicker noise coefficient for drain factor, fnmod=2")
`MPRoz(k1noi, 1, "", "Flicker noise exponent for drain factor, fnmod=2")
`MPRnb(lintnoi, 0.0, "m", "L offset for flicker noise calculation")
`MPRcz(smooth, 2, "", "Smoothing Parameter")

`MPRnb(noia2, noia, "s^(1-ef)/(eV*m^3)", "Flicker noise parameter for sub-threshold region")
`MPRnb(lnoia2, 0.0, "s^(1-ef)/(eV*m^2)", "L-term for noia2")
`MPRnb(nnoia2, 0.0, "s^(1-ef)/(eV*m^3)", "N-term for noia2")
`MPRnb(pnoia2, 0.0, "s^(1-ef)/(eV*m^2)", "P-term for noia2")
`MPRnb(wnoia2, 0.0, "s^(1-ef)/(eV*m^2)", "W-term for noia2")
`MPRnb(p2noia2, 0.0, "s^(1-ef)/(eV*m)", "WL-term for noia2")

`MPRnb(mpower, 1.2, "", "Sub-threshold to strong inversion transition slope Parameter")
`MPRnb(lmpower, 0.0, "m" ,"L-term for mpower")
`MPRnb(nmpower, 0.0, "" ,"N-term for mpower")
`MPRnb(pmpower, 0.0, "m" ,"P-term for mpower")
`MPRnb(wmpower, 0.0, "m", "W-term for mpower")
`MPRnb(p2mpower, 0.0, "m^2", "WL-term for mpower")

`MPRnb(qsref, 50e-3, "", "Charge at threshold condition")
`MPRnb(lqsref, 0.0, "m", "L-term for qsref")
`MPRnb(nqsref, 0.0, "", "N-term for qsref")
`MPRnb(pqsref, 0.0, "m", "P-term for qsref")
`MPRnb(wqsref, 0.0, "m", "W-term for qsref")
`MPRnb(p2qsref, 0.0, "m^2", "WL-term for qsref")

// Thermal noise
`MPRcz(ntnoi, 1.0, "", "Thermal noise parameter")

// Correlated thermal noise
`MPRcz(rnoia, 0.5774, "", "Empirical parameter for Sid level")
`MPRnb(tnoia, 0.0, "/m", "Empirical parameter for Leff trend of Sid")
`MPRcz(rnoib, 0.3652, "", "Empirical parameter for Sig level")
`MPRnb(tnoib, 0.0, "/m", "Empirical parameter for Leff trend of Sig")
`MPRcz(rnoic, 0.3953, "", "Empirical parameter for correlation coefficient")
`MPRnb(tnoic, 0.0, "/m", "Empirical parameter for Leff trend of correlation coefficient")
`MPRcz(rnoik, 0.0, "", "Empirical parameter for Sid level at low Ids")
`MPRnb(tnoik, 0.0, "/m", "Empirical parameter for Leff trend of Sid at low Ids")
`MPRcz(tnoik2, 0.1, "", "Empirical parameter for sensitivity of rnoik")

// Temperature effects
`MPRco(tnom, 27.0, "degC", -`P_CELSIUS0, inf, "Temperature at which the model is extracted")
`MPRnb(tbgasub, 7.02e-4, "eV/K", "Bandgap temperature coefficient")
`MPRnb(tbgbsub, 1.108e3, "K", "Bandgap temperature coefficient")
`MPRnb(kt1l, 0.0, "V*m", "Vth temperature l coefficient")
`MPRnb(tcj, 0.0, "/K", "Temperature coefficient for cjs/cjd")
`MPRnb(tcjsw, 0.0, "/K", "Temperature coefficient for cjsws/cjswd")
`MPRnb(tcjswg, 0.0, "/K", "Temperature coefficient for cjswgs/cjswgd")
`MPRnb(tpb, 0.0, "/K", "Temperature coefficient for pbs/pbd")
`MPRnb(tpbsw, 0.0, "/K", "Temperature coefficient for pbsws/pbswd")
`MPRnb(tpbswg, 0.0, "/K", "Temperature coefficient for pbswgs/pbswgd")
`MPRnb(xtis, 3.0, "", "Source junction current temperature exponent")
`MPRnb(xtid, xtis, "", "Drain junction current temperature exponent")
`MPRnb(xtss, 2.0e-2, "", "Power dependence of jtss on temperature")
`MPRnb(xtsd, xtss, "", "Power dependence of jtsd on temperature")
`MPRnb(xtssws, 2.0e-2, "", "Power dependence of jtssws on temperature")
`MPRnb(xtsswd, xtssws, "", "Power dependence of jtsswd on temperature")
`MPRnb(xtsswgs, 2.0e-2, "", "Power dependence of jtsswgs on temperature")
`MPRnb(xtsswgd, xtsswgs, "", "Power dependence of jtsswgd on temperature")
`MPRnb(tnjts, 0.0, "", "Temperature coefficient for njts")
`MPRnb(tnjtsd, tnjts, "", "Temperature coefficient for njtsd")
`MPRnb(tnjtssw, 0.0, "", "Temperature coefficient for njtssw")
`MPRnb(tnjtsswd, tnjtssw, "", "Temperature coefficient for njtsswd")
`MPRnb(tnjtsswg, 0.0, "", "Temperature coefficient for njtsswg")
`MPRnb(tnjtsswgd, tnjtsswg, "", "Temperature coefficient for njtsswgd")

`MPRnb(kt1, 0.0, "V", "Vth temperature coefficient")
`MPRnb(lkt1, 0.0, "m*V", "L-term of kt1")
`MPRnb(nkt1, 0.0, "V", "N-term of kt1")
`MPRnb(pkt1, 0.0, "m*V", "P-term of kt1")
`MPRnb(wkt1, 0.0, "m*V", "W-term of kt1")
`MPRnb(p2kt1, 0.0, "(m^2)*V", "WL-term of kt1")
`MPRnb(kt11, 0.01, "V", "cryomod != 0 Vth temperature coefficient")
`MPRnb(kt12, 0.1, "/K", "cryomod != 0 Vth temperature coefficient")
`MPRnb(tvth, 40.0, "K", "cryomod != 0 transition temperature for Vth temperature model")

`MPRnb(tss, 0.0, "/K", "Swing temperature coefficient")
`MPRnb(ltss, 0.0, "m/K", "L-term of tss")
`MPRnb(ntss, 0.0, "/K", "N-term of tss")
`MPRnb(ptss, 0.0, "m/K", "P-term of tss")
`MPRnb(wtss, 0.0, "m/K", "W-term of tss")
`MPRnb(p2tss, 0.0, "(m^2)/K", "WL-term of tss")

`MPRnb(iit, -0.5, "", "Impact ionization temperature dependence for iimod = 1")
`MPRnb(liit, 0.0, "m", "L-term of iit")
`MPRnb(niit, 0.0, "", "N-term of iit")
`MPRnb(piit, 0.0, "m", "P-term of iit")
`MPRnb(wiit, 0.0, "m", "W-term of iit")
`MPRnb(p2iit, 0.0, "m^2", "WL-term of iit")

`MPRnb(tii, 0.0, "", "Impact ionization temperature dependence for iimod = 2")
`MPRnb(ltii, 0.0, "m", "L-term of tii")
`MPRnb(ntii, 0.0, "", "N-term of tii")
`MPRnb(ptii, 0.0, "m", "P-term of tii")
`MPRnb(wtii, 0.0, "m", "W-term of tii")
`MPRnb(p2tii, 0.0, "m^2", "WL-term of tii")

`MPRnb(tgidl, -3.0e-3, "/K", "GIDL/GISL temperature dependence")
`MPRnb(ltgidl, 0.0, "m/K", "L-term of tgidl")
`MPRnb(ntgidl, 0.0, "/K", "N-term of tgidl")
`MPRnb(ptgidl, 0.0, "m/K", "P-term of tgidl")
`MPRnb(wtgidl, 0.0, "m/K", "W-term of tgidl")
`MPRnb(p2tgidl, 0.0, "(m^2)/K", "WL-term of tgidl")

`MPRnb(ttat, -1e-6, "/K", "GIDL/GISL temperature dependence")
`MPRnb(lttat, 0.0, "m/K", "L-term of tgidl")
`MPRnb(nttat, 0.0, "/K", "N-term of tgidl")
`MPRnb(pttat, 0.0, "m/K", "P-term of tgidl")
`MPRnb(wttat, 0.0, "m/K", "W-term of tgidl")
`MPRnb(p2ttat, 0.0, "(m^2)/K", "WL-term of tgidl")

`MPRnb(igt, 2.5, "", "Gate current temperature dependence")
`MPRnb(ligt, 0.0, "m", "L-term of igt")
`MPRnb(nigt, 0.0, "", "N-term of igt")
`MPRnb(pigt, 0.0, "m", "P-term of igt")
`MPRnb(wigt, 0.0, "m", "W-term of igt")
`MPRnb(p2igt, 0.0, "m^2", "WL-term of igt")

// Effective temperature
`MPRcz(tlow, 50.0, "K", "cryomod != 0 transition temperature of subthreshold swing at low temperatures")
`MPRcz(tlow1, 0.0, "K", "cryomod != 0 transition temperature of subthreshold swing at low temperatures")
`MPRoz(dtlow, 1.0, "K", "cryomod != 0 smoothing parameter for tlow")
`MPRoz(dtlow1, 1.0e-3, "K", "cryomod != 0 smoothing parameter for tlow1")
`MPRcz(klow1, 0.0, "", "cryomod != 0 slope magnitude of effective temperature below tlow1")

// Self-heating
`MPRcz(rth0, 1.0e-2, "ohm*m*K/W", "Thermal resistance")
`MPRcz(cth0, 1.0e-5, "W*s/(m*K)", "Thermal capacitance")
`MPRcz(wth0, 0.0, "m", "Width dependence coefficient for Rth and Cth")
`MPRcz(ashexp, 1.0, "", "Exponent to tune RTH dependence of NFINTOTAL")
`MPRcz(bshexp, 1.0, "", "Exponent to tune RTH dependence of nf")
`MPRcz(cshexp, 1.0, "", "Exponent to tune RTH dependence of ngaa")
`MPRcz(ash, 1.0, "", "Coefficient to tune RTH dependence of NFINTOTAL")
`MPRcz(csh, 1.0, "", "Coefficient to tune RTH dependence of ngaa")

// Unified model
`MPRoz(ach_ufcm, 1.0, "m^2", "Area of the channel for the unified model")
`MPRoz(cins_ufcm, 1.0, "F/m", "Insulator capacitance for the unified model")
`MPRoz(w_ufcm, 1.0, "m", "Effective channel width for the unified model")
`MPRcz(tfin_top, 0.0, "m", "If non-zero, top fin thickness for trapezoidal triple gate")
`MPRcz(tfin_base, 0.0, "m", "If non-zero, base fin thickness for trapezoidal triple gate")
`MPRcz(qmfactorcv, 0.0, "", "Charge dependence taking QM effects into account")
`MPRcz(alpha_ufcm, 0.5556, "", "Mobile charge scaling term taking QM effects into account")

// Gate-All-Around subband model
`MPRcc(dim1h, 3,"", 1, 3, "Max dimension for 1st subband (real number enables optimization)")

`MPRnb(dimension1, 2, "", "Dimension for 1st subband (real number enables optimization)")
`MPRnb(ldimension1, 0.0, "m", "L-term of dimension1")
`MPRnb(ndimension1, 0.0, "", "N-term of dimension1")
`MPRnb(pdimension1, 0.0, "m", "P-term of dimension1")
`MPRnb(wdimension1, 0.0, "m", "W-term of dimension1")
`MPRnb(p2dimension1, 0.0, "m^2", "WL-term of dimension1")

`MPRcc(dim2h, 3, "", 1, 3, "Max dimension for 2nd subband (real number enables optimization)")

`MPRnb(dimension2, 2.6, "", "Dimension for 2nd subband (real number enables optimization)")
`MPRnb(ldimension2, 0.0, "m", "L-term of dimension2")
`MPRnb(ndimension2, 0.0, "", "N-term of dimension2")
`MPRnb(pdimension2, 0.0, "m", "P-term of dimension2")
`MPRnb(wdimension2, 0.0, "m", "W-term of dimension2")
`MPRnb(p2dimension2, 0.0, "m^2", "WL-term of dimension2")

`MPRcc(dim3h, 3, "", 1, 3, "Max dimension for 3rd subband (real number enables optimization)")

`MPRnb(dimension3, 2.6, "", "Dimension for 3rd subband (real number enables optimization)")
`MPRnb(ldimension3, 0.0, "m", "L-term of dimension3")
`MPRnb(ndimension3, 0.0, "", "N-term of dimension3")
`MPRnb(pdimension3, 0.0, "m", "P-term of dimension3")
`MPRnb(wdimension3, 0.0, "m", "W-term of dimension3")
`MPRnb(p2dimension3, 0.0, "m^2", "WL-term of dimension3")

`MPRcz(wdim0, 9.5e-9, "m", "wgaa at which dimension change happens")
`MPRoz(wdimr, 0.1, "nm", "Rate of dimension change with wgaa scaling")

`MPRnb(ssp1, 14, "", "Subband smoothing parameter for 1st subband (wgaa<wssp0)")
`MPRnb(lssp1, 0.0, "m", "L-term of ssp1")
`MPRnb(nssp1, 0.0, "", "N-term of ssp1")
`MPRnb(pssp1, 0.0, "m", "P-term of ssp1")
`MPRnb(wssp1, 0.0, "m", "W-term of ssp1")
`MPRnb(p2ssp1, 0.0, "m^2", "WL-term of ssp1")

`MPRnb(ssp2, 24, "", "Subband smoothing parameter for 2nd subband (wgaa<wssp0)")
`MPRnb(lssp2, 0.0, "m", "L-term of ssp2")
`MPRnb(nssp2, 0.0, "", "N-term of ssp2")
`MPRnb(pssp2, 0.0, "m", "P-term of ssp2")
`MPRnb(wssp2, 0.0, "m", "W-term of ssp2")
`MPRnb(p2ssp2, 0.0, "m^2", "WL-term of ssp2")

`MPRnb(ssp3, 24, "", "Subband smoothing parameter for 3rd subband (wgaa<wssp0)")
`MPRnb(lssp3, 0.0, "m", "L-term of ssp3")
`MPRnb(nssp3, 0.0, "", "N-term of ssp3")
`MPRnb(pssp3, 0.0, "m", "P-term of ssp3")
`MPRnb(wssp3, 0.0, "m", "W-term of ssp3")
`MPRnb(p2ssp3, 0.0, "m^2", "WL-term of ssp3")

`MPRcz(dssp1, 2, "", "Change in ssp1 with wgaa scaling for large wgaa>wssp0")
`MPRcz(dssp2, 0,"m", "Change in ssp2 with wgaa scaling for large wgaa>wssp0")
`MPRcz(dssp3, 0,"", "Change in SPP3 with wgaa scaling for large wgaa>wssp0")
`MPRcz(wssp0, wdim0, "m", "wgaa around which SSP change happens")
`MPRoz(wsspr, wdimr, "nm", "Rate of SSP change with wgaa scaling")
`MPRoz(wgaanom, 8e-9, "m^2", "Nominal wgaa")

`MPRnb(e2nom, 0.139, "eV", "2nd subband energy for nominal wgaa")
`MPRnb(le2nom, 0.0, "m*eV", "L-term of e2nom")
`MPRnb(ne2nom, 0.0, "eV", "N-term of e2nom")
`MPRnb(pe2nom, 0.0, "m*eV", "P-term of e2nom")
`MPRnb(we2nom, 0.0, "m*eV", "W-term of e2nom")
`MPRnb(p2e2nom, 0.0, "(m^2)*eV", "WL-term of e2nom")

`MPRnb(e3nom, 2, "eV", "3rd subband energy for nominal wgaa")
`MPRnb(le3nom, 0.0, "m*eV", "L-term of e3nom")
`MPRnb(ne3nom, 0.0, "eV", "N-term of e3nom")
`MPRnb(pe3nom, 0.0, "m*eV", "P-term of e3nom")
`MPRnb(we3nom, 0.0, "m*eV", "W-term of e3nom")
`MPRnb(p2e3nom, 0.0, "(m^2)*eV", "WL-term of e3nom")

`MPRnb(mfe2, 1, "", "Rate of change in 2nd subband energy with wgaa and tgaa scaling")
`MPRnb(mfe3, 1, "", "Rate of change in 3rd subband energy with wgaa and tgaa scaling")
`MPRcz(wsfe2, 1, "", "wgaa scaling factor for 2nd subband energy")
`MPRcz(wsfe3, 1, "", "wgaa scaling factor for 3rd subband energy")

`MPRnb(mfq1nom, 11.2, "", "Sacling factor for 1st subband charge for nominal wgaa")
`MPRnb(lmfq1nom, 0.0, "m", "L-term of mfq1nom")
`MPRnb(nmfq1nom, 0.0, "", "N-term of mfq1nom")
`MPRnb(pmfq1nom, 0.0, "m", "P-term of mfq1nom")
`MPRnb(wmfq1nom, 0.0, "m", "W-term of mfq1nom")
`MPRnb(p2mfq1nom, 0.0, "m^2", "WL-term of mfq1nom")

`MPRnb(mfq2nom, 8.02, "", "Scaling factor for 2nd subband charge for nominal wgaa")
`MPRnb(lmfq2nom, 0.0, "m", "L-term of mfq2nom")
`MPRnb(nmfq2nom, 0.0, "", "N-term of mfq2nom")
`MPRnb(pmfq2nom, 0.0, "m", "P-term of mfq2nom")
`MPRnb(wmfq2nom, 0.0, "m", "W-term of mfq2nom")
`MPRnb(p2mfq2nom, 0.0, "m^2", "WL-term of mfq2nom")

`MPRnb(mfq3nom, 6.18,"","Scaling factor for 3rd subband charge for niminal WHSEET")
`MPRnb(lmfq3nom, 0.0, "m", "L-term of mfq3nom")
`MPRnb(nmfq3nom, 0.0, "", "N-term of mfq3nom")
`MPRnb(pmfq3nom, 0.0, "m", "P-term of mfq3nom")
`MPRnb(wmfq3nom, 0.0, "m", "W-term of mfq3nom")
`MPRnb(p2mfq3nom, 0.0, "m^2", "WL-term of mfq3nom")

`MPRnb(mfq1, 1, "", "Rate of change in 1st subband charge with wgaa and tgaa scaling")
`MPRnb(mfq2, 1, "", "Rate of change in 2nd subband charge with wgaa and tgaa scaling")
`MPRnb(mfq3, 1, "", "Rate of change in 3rd subband charge with wgaa and tgaa scaling")
`MPRcz(wsfq1, 1, "", "wgaa scaling factor for 1st subband charge")
`MPRcz(wsfq2, 1, "", "wgaa scaling factor for 2nd subband charge")
`MPRcz(wsfq3, 1, "", "wgaa scaling factor for 3rd subband charge")
`MPRcz(tsre2, 1.8, "", "tgaa scaling for 2nd subband energy")
`MPRcz(tdwse2, 1.0, "", "tgaa dependence of wgaa scaling for 2nd subband energy")
`MPRnb(tsre3, 0.67, "", "tgaa scaling for 3rd subband energy")
`MPRnb(tdwse3, 0.23, "", "tgaa dependence of wgaa scaling for 3rd subband energy")
`MPRcz(tsrq1, 1.1, "", "tgaa scaling for 1st subband charge")
`MPRcz(tdwsq1, 2.4, "", "tgaa dependence of wgaa scaling for 1st subband charge")
`MPRcz(tsrq2, 2.0, "", "tgaa scaling for 2nd subband charge")
`MPRcz(tdwsq2, 2.0, "", "tgaa dependence of wgaa scaling for 2nd subband charge")
`MPRnb(tsrq3, 6.0, "", "tgaa scaling for 3rd subband charge")
`MPRnb(tdwsq3, 2.4, "", "tgaa dependence of wgaa scaling for 3rd subband charge")

// S/D Velocity Saturation Model
`MPRoz(nvsrd, 5.0e16, "1/m^2", "Charge density in the drain region")
`MPRoz(vsatrsd, 1.0e5, "m/sec", "Saturation velocity in S/D region")
`MPRcz(ptwgvsrsd, 0.0, "1/V", "vsatrsd variation with gate bias")
`MPRnb(ptwg1vsrsd, 0.0, "V", "vsatrsd variation with gate bias")
`MPRoz(psatxvsrsd, 60.0, "V", "Fine tuning of ptwgvsrsd effect")
`MPRoo(mvsrsd, 1.0, "", 0, 4, "Non-linear resistance parameter")
`MPRoz(nvsrs, nvsrd, "1/m^2", "Charge density in the source region")
`MPRcz(rdlcw, 0.0, "Ohm*um^wr", "'R'esistance of the 'D'rain region at 'l'ow 'C'urrent")
`MPRcz(rslcw, 0.0, "Ohm*um^wr", "'R'esistance of the 'S'ource region at 'l'ow 'C'urrent")
`MPRnb(prtvsrsd, 0.0, "", "Temperature coefficient of resistance in S/D velocity saturation model")
`MPRnb(atvsrsd, 0.0, "m/s", "Temperature coefficient for S/D region saturation velocity")
`MPRcc(vsrdfactor, 1.0e-3, "", 1.0e-4, 1.0, "Parameter for delta_vsrd tuning")
`MPRcc(vsrsfactor, 1.0e-3, "", 1.0e-4, 1.0, "Parameter for delta_vsrs tuning")
`MPRnb(rdvds, 8.0, "V", "Parameter for Isat_rd variation with drain voltage")
`MPRcz(gavsrd, 0.0, "1/V", "Parameter for Isat_rd variation with drain voltage")

// Operating-point information
`OPP(weff, "m", "Effective width for I-V")
`OPP(leff, "m", "Effective length for I-V")
`OPP(weffcv, "m", "Effective width for C-V")
`OPP(leffcv, "m", "Effective length for C-V")
`OPM(ids, "A", "Intrinsic drain current")
`OPM(ideff, "A", "Total drain current")
`OPM(iseff, "A", "Total source current")
`OPM(igtot, "A", "Total gate current")
`OPM(idsgen, "A", "Generation-recombination current")
`OPM(iii, "A", "Impact ionization current")
`OPM(igidl, "A", "GIDL current")
`OPM(igisl, "A", "GISL current")
`OPM(ijsb, "A", "Source-to-substrate junction current")
`OPM(ijdb, "A", "Drain-to-substrate junction current")
`OPM(isub, "A", "Substrate current")
`OPM(beta, "A/V^2", "Drain current prefactor per fin per finger")
`OPP(vdssat, "V", "Drain-to-source saturation voltage")
`OPP(vdseff, "V", "Effective drain-to-source voltage")
`OPP(vfb, "V", "Flatband voltage")
`OPP(vth, "V", "Threshold voltage")
`OPM(gm, "A/V", "Transconductance")
`OPM(gds, "A/V", "Output conductance")
`OPM(gmbs, "A/V", "Substrate conductance")
`OPM(qgi, "C", "Intrinsic gate charge")
`OPM(qdi, "C", "Intrinsic drain charge")
`OPM(qsi, "C", "Intrinsic source charge")
`OPM(qbi, "C", "Intrinsic substrate charge")
`OPM(qg, "C", "Total gate charge")
`OPM(qd, "C", "Total drain charge")
`OPM(qs, "C", "Total source charge")
`OPM(qb, "C", "Total substrate charge")
`OPM(cggi, "F", "Intrinsic gate capacitance")
`OPM(cgsi, "F", "Intrinsic gate-to-source capacitance")
`OPM(cgdi, "F", "Intrinsic gate-to-drain capacitance")
`OPM(cgei, "F", "Intrinsic gate-to-substrate capacitance")
`OPM(cdgi, "F", "Intrinsic drain-to-gate capacitance")
`OPM(cddi, "F", "Intrinsic drain capacitance")
`OPM(cdsi, "F", "Intrinsic drain-to-source capacitance")
`OPM(cdei, "F", "Intrinsic drain-to-substrate capacitance")
`OPM(csgi, "F", "Intrinsic source-to-gate capacitance")
`OPM(csdi, "F", "Intrinsic source-to-drain capacitance")
`OPM(cssi, "F", "Intrinsic source capacitance")
`OPM(csei, "F", "Intrinsic source-to-substrate capacitance")
`OPM(cegi, "F", "Intrinsic substrate-to-gate capacitance")
`OPM(cedi, "F", "Intrinsic substrate-to-drain capacitance")
`OPM(cesi, "F", "Intrinsic substrate-to-source capacitance")
`OPM(ceei, "F", "Intrinsic substrate capacitance")
`OPM(cgg, "F", "Total gate capacitance")
`OPM(cgs, "F", "Total gate-to-source capacitance")
`OPM(cgd, "F", "Total gate-to-drain capacitance")
`OPM(cge, "F", "Total gate-to-substrate capacitance")
`OPM(cdg, "F", "Total drain-to-gate capacitance")
`OPM(cdd, "F", "Total drain capacitance")
`OPM(cds, "F", "Total drain-to-source capacitance")
`OPM(cde, "F", "Total drain-to-substrate capacitance")
`OPM(csg, "F", "Total source-to-gate capacitance")
`OPM(csd, "F", "Total source-to-drain capacitance")
`OPM(css, "F", "Total source capacitance")
`OPM(cse, "F", "Total source-to-substrate capacitance")
`OPM(ceg, "F", "Total substrate-to-gate capacitance")
`OPM(ced, "F", "Total substrate-to-drain capacitance")
`OPM(ces, "F", "Total substrate-to-source capacitance")
`OPM(cee, "F", "Total substrate capacitance")
`OPM(cgsext, "F", "External gate-to-source capacitance")
`OPM(cgdext, "F", "External gate-to-drain capacitance")
`OPM(cgbov, "F", "Gate-to-substrate overlap capacitance")
`OPM(cjst, "F", "Total junction and source-to-substrate capacitance")
`OPM(cjdt, "F", "Total junction and drain-to-substrate capacitance")
`OPD(rsgeo, "Ohm", "External bias-independent source resistance")
`OPD(rdgeo, "Ohm", "External bias-independent drain resistance")
`OPM(cfgeo, "F", "Geometric parasitic capacitance")
`OPP(t_total_k, "K", "Device temperature in Kelvin")
`OPP(t_total_c, "degC", "Device temperature in Celsius")
`OPP(t_delta_sh, "K or degC", "Delta temperature by self-heating")
`OPM(igs, "A", "Gate-to-source tunneling current")
`OPM(igd, "A", "Gate-to-drain tunneling current")
`OPM(igcs, "A", "Gate-to-channel tunneling current at source")
`OPM(igcd, "A", "Gate-to-channel tunneling current at drain")
`OPM(igbs, "A", "Gate-to-substrate tunneling current at source")
`OPM(igbd, "A", "Gate-to-substrate tunneling current at drain")
`OPM(igbacc, "A", "Gate-to-substrate tunneling current in accumulation")
`OPM(igbinv, "A", "Gate-to-substrate tunneling current in inversion")
`OPM(didsdvg, "A/V", "dIds / dVg")
`OPM(didsdvs, "A/V", "dIds / dVs")
`OPM(didsdvd, "A/V", "dIds / dVd")
`OPM(digsdvg, "A/V", "dIgs / dVg")
`OPM(digsdvs, "A/V", "dIgs / dVs")
`OPM(digsdvd, "A/V", "dIgs / dVd")
`OPM(digddvg, "A/V", "dIgd / dVg")
`OPM(digddvs, "A/V", "dIgd / dVs")
`OPM(digddvd, "A/V", "dIgd / dVd")
`OPM(diiidvg, "A/V", "dIii / dVg")
`OPM(diiidvs, "A/V", "dIii / dVs")
`OPM(diiidvd, "A/V", "dIii / dVd")
`OPM(digidldvg, "A/V", "dIgidl / dVg")
`OPM(digidldvs, "A/V", "dIgidl / dVs")
`OPM(digidldvd, "A/V", "dIgidl / dVd")
`OPM(digisldvg, "A/V", "dIgisl / dVg")
`OPM(digisldvs, "A/V", "dIgisl / dVs")
`OPM(digisldvd, "A/V", "dIgisl / dVd")
`OPM(cgt, "C/K", "dQg / dTemp")
`OPM(cst, "C/K", "dQs / dTemp")
`OPM(cdt, "C/K", "dQd / dTemp")
`OPM(didsdvth, "A/K", "dIds / dTemp")
`OPM(digsdvth, "A/K", "dIgs / dTemp")
`OPM(digddvth, "A/K", "dIgd / dTemp")
`OPM(diiidvth, "A/K", "dIii / dTemp")
`OPM(digidldvth, "A/K", "dIgidl / dTemp")
`OPM(digisldvth, "A/K", "dIgisl / dTemp")
`OPM(ith, "A*V", "Device power")
`OPM(dithdvth, "A*V/K", "dPower / dTemp")
`OPM(dithdvg, "A", "dPower / dVg")
`OPM(dithdvs, "A", "dPower / dVs")
`OPM(dithdvd, "A", "dPower / dVd")
// ---- end `include "bsimcmg_parameters.include" ----
// ---- begin `include "bsimcmg_variables.include" ----
// *  BSIM-CMG 112.1.0 released on 04/28/2026                            *
// *  BSIM Common Multi-Gate Model (Verilog-A)                                *
// ****************************************************************************

// ****************************************************************************
// *  Copyright © 2026 University of California                               *
// *                                                                          *
// *  Project director: Prof. Sayeef Salahuddin                               *
// *                    Prof. Chenming Hu                                     *
// *                                                                          *
// *  Developers: https://www.bsim.berkeley.edu/models/bsimcmg/auth_cmg/      *
// ****************************************************************************

// Variables
integer devsign;
real NFINtotal;
real DevTemp, DevTemp1, DevTempeff, DevTemplow0, DevTemplow1, Tlow;
real ids0, ids0_ov_dqi, ids_v, vgs, vds, vdsx, sigvds, vch, vch_cv, etaiv, vgdrift, vgdrift_s;
real vgs_noswap, vds_noswap, vgd_noswap;
real qd_v, qg_v, qs_v, qb_v;
real ni, niln, epssub, epssp, epsratio, Eg, Eg0, Nc;
real Lg, deltaL, deltaL1, deltaLCV, Leff, Leff_ln, Leff1, LeffCV, LeffCV_acc, Weff0, WeffCV0, WeffCV_acc, WGAAeff, WGAAeff1;
real cox, cdsc_v, cbox;
real phib, deltaPhi;
real T0, T1, T2, T3, T4, T4a, T5, T6, T7, T8, T9;
real Vtm, Vtm0, nVtm, Vtmeff;
real beta_v, beta0_v, beta0_cv;
real wf, wr_v;
real Dr, WeffWRFactor;
real RSourceGeo, RDrainGeo;
real Rdrain, Rsource;
real rdstemp, rdstemp0, rdstemp1, Rdsi, Rdss, Rdss_cv;
real DIBLfactor, PVAGfactor, diffVds, VaDIBL, Vgst2Vtm, Moc, Mclm;
real MclmCV, inv_MclmCV;
real Dvsat, Vdsat, Vdsat_cv, inv_MEXP, DvsatCV, Nsat, u0mult_v;
real Esat, EsatL, Esat1, Esat1L, EsatCV, EsatCVL, Esats_cv, EsatLs_cv;
real WVCox, Ta, Tb, Tc;

// Temperature effects
real Tnom, TRatio, TRatio_m1, dvth_temp, delTemp, delTemp1, delTRatio1, ThetaSS;
real K0_t, K0SI_t, K2SI_t, K1_t, K2SAT_t, A1_t, A2_t;
real AIGBINV_t, AIGBACC_t, AIGC_t, AIGS_t, AIGD_t;
real BETA0_t, SII0_t, BGISL_t, BGISLB_t, BGIDL_t, CTATS_t, CTATD_t, BGIDLB_t, igtemp, PTWG_t, PTWGR_t;
real ALPHA0_t, ALPHA1_t, ALPHAII0_t, ALPHAII1_t;
real CJS_t, CJSWS_t, CJSWGD_t, CJD_t, CJSWD_t, CJSWGS_t;
real PBS_t, PBSWS_t, PBSWGS_t, PBD_t, PBSWD_t, PBSWGD_t;
real JSS_t, JSWS_t, JSWGS_t, JSD_t, JSWD_t, JSWGD_t;
real JTSS_t, JTSD_t, JTSSWS_t, JTSSWD_t, JTSSWGS_t, JTSSWGD_t;
real NJTS_t, NJTSD_t, NJTSSW_t, NJTSSWD_t, NJTSSWG_t, NJTSSWGD_t;
real K2_t;
real K0SISAT_t, K2SISAT_t;
real ETA0_t, ETA0CV_t, ETA0R_t;
real RSDR_t, RSDRR_t, RDDR_t, RDDRR_t;
real UA_t, UACV_t, UAR_t, UA_tl, UA_th, UACV_tl, UACV_th, UAR_tl, UAR_th, wh, wl, UC_t, UCCV_t, UCR_t, UCS_t, UD_t, UDCV_t, UDR_t, U0R_t, ETAMOB_t, EU_t, UDS_t, UDS_i, UDS1_i, UDD_t, UDD_i, UDD1_i, UDSeff_t, UDDeff_t;
real VSAT_t, VSATR_t, VSAT1_t, VSAT1R_t, VSATCV_t, MEXP_t, MEXPR_t;

// Surface potential
real q0;
real T10, T11, T12, T12a;
real e0, e1, e2;

// Accumulation model
real vgsfb, vgsfbeff, vgsfb_cv, vgsfbeff_cv;

// Short channel effects
real scl, vbi, phist, dvth_vtroll, dvth_dibl, dvth_dibl_cv, dvth_rsce, dvth_all, dvth_all_cv;
real tmp, Theta_SCE, Theta_SW, Theta_DIBL, Theta_RSCE, Theta_DITS;

// Lateral non-uniform doping effect
real Mnud;

// Body effect for bulkmod = 1
real ves, vesx, vesmax, veseff;
real Mob;

// Quantum mechanical correction
real coxeff, Tcen0, Tcen, dvch_qm, MTcen;
real E0, E0prime, E1, E1prime, mx, mxprime, md, mdprime;
real gprime, gfactor, gam0, gam1, kT;

// Drain saturation voltage
real Vdseff, Vdseff_cv, qis, qid, qis_cv, qid_cv, qbs, Dmobs, Dmobs_cv;

// Midpoint potential and charge
real qia, qia2, qba, dqi, qia_cv, qia2_cv, dqi_cv;
real qb0;
real eta_mu, eta_mu_cv, Eeffm, Eeffm_cv, Dmob, Dmob_cv, u0_v, u0_cv, ueff, u0_a, u0r_v;
real Trat_ln, Eeffs, EeffFactor, Eeffs_cv;

// Asymmetry model
real VSAT1_a, MEXP_a, PTWG_a, RSDR_a, RDDR_a, PDIBL1_a, VSAT_a;

// Geometry-dependent S/D resistance
real mu_max, mu_rsd, rhorsd_v, afin, thetarsp;
real Rsp, lt, arsd_total, prsd_total, alpha;
real eta, RrsdTML, Rrsdside, Rrsd;
real Rdsgeo, Arsd, Prsd, deltaprsd_v;

// Geometry-dependent fringe capacitance
real Hg, Wg, Trsd, Hrsd, Cgg_top, Cgg_side, Cfr_geo, Acorner, Ccorner;

// Gate resistance
real ggeltd, Rgeltd, ggint, ggp;

// Gate current
real Vaux_Igbinv, igbinv_v, igsd_mult, igsd_mult0, igbs_v, igbd_v;
real Voxacc, Vaux_Igbacc, vfbzb, igbacc_v;
real igcs_v, igcd_v, igc0, Vdseffx, T1_exp;
real igisl_v, igidl_v, igislb, igidlb, vfbsd_v, igs_v, igd_v, vgs_eff, vgd_eff;
real Aechvb, Bechvb, Toxratio, Toxratioedge;

// Impact ionization current
real Iii, Vdiff, Vdsatii, VgsStep, Ratio, ALPHAII;

// Accumulation capacitance
real cox_acc;
real qg_acc, qb_acc;
real vge;

// Parasitic capacitance
real qgs_ov, qgd_ov, qgs_fr, qgd_fr, qds_fr, qbov, qbov_s;
real qgs_parasitic, qgd_parasitic, Qes, Qed, Qeg;
real vgs_overlap, vgd_overlap, vge_overlap;
real cgsp_v, cgdp_v, csbox, cdbox, cgbox, vfbsdcv_v;

// Junction current and capacitance
real Ies, Ied, ves_jct, ved_jct;
real Czbs, Czbssw, Czbsswg, Czbd, Czbdsw, Czbdswg;
real Qesj, Qesj1, Qesj2, Qesj3, Qedj, Qedj1, Qedj2, Qedj3;
real Isbs, Isbd, Nvtms, Nvtmd;
real SslpRev, IVjsmRev, VjsmRev, SslpFwd, IVjsmFwd, VjsmFwd, XExpBVS;
real DslpRev, IVjdmRev, VjdmRev, DslpFwd, IVjdmFwd, VjdmFwd, XExpBVD;
real igentemp, idsgen_v;
real vec1s, pb21s, vec2s, pb22s, vec3s, pb23s, vec1d, pb21d, vec2d, pb22d, vec3d, pb23d;

// NQS gate resistance
real gcrg, gtau, xdpart, IdovVds;

// Flicker noise
real NOIAeff, NOIA2_i, MPOWER_i, QSREF_i, ef_v;
real litl, Esatnoi, Leffnoi, Leffnoisq, DelClm;
real N0, Nl, Nstar, Ssi, Swi, FNPowerAt1Hz, lambdac_fn2, DrainFac, NeffT;

// Thermal noise
real qinv, Gtnoi, sid;
real gspr, gdpr;

// Correlated thermal noise
real noiBeta, noiTheta, noiCorr, noiLowId, noiEta, noiWI, noiGd0, Dvsat3;
real T5_2, T5_3, T5_4, T7_2, T7_3, T7_4, T7_5;
real etaiv0, ids0_ov_dqi0, Rdsi0, Eeffm0;
real Mnud0, Mob0, Dmob0, Dvsat0, Dr0;
real gamma1, gamma2, gamma;
real delta1, delta2, delta3, delta;
real epsilon1, epsilon2, epsilon;
real ctnoi, sigrat;

// Self-heating
real gth, cth;

// Binning variables
real Inv_L, Inv_NFIN, Inv_LNFIN, Inv_W, Inv_WL;
real NBODY_i, PHIG_i, CFD_i, CFS_i, COVS_i, COVD_i, CGSO_i, CGDO_i;
real CGSL_i, CGDL_i, CGBL_i, CKAPPAS_i, CKAPPAD_i, CKAPPAB_i;
real QMFACTOR_i, QMTCENCV_i, QMTCENCVA_i, KSATIV_i, KSATIVR_i, KSATIV_a, KSATIV_t, PQM_i;
real CDSC_i, CDSCD_i, CDSCD_a, CDSCDR_i, CIT_i, DVT0_i, CITR_i, CIT_a;
real DVT1_i, DVT1SS_i, PHIN_i, ETA0_i, ETA1_i, ETA0CV_i, ETA0_a, ETA0R_i, DSUB_i, VSAT_i, VSATR_i;
real DVTP0_i, DVTP1_i;
real K0_i, K01_i, K0SI_i, K0SI1_i, K2SI_i, K2SI1_i, PHIBE_i, K1_i, K11_i, K2SAT_i, K2SAT1_i;
real DELTAVSAT_i, PSAT_i, DELTAVSATCV_i, PSATCV_i, VSAT1_i, VSAT1R_i, PTWG_i, PTWGR_i, VSATCV_i;
real UP_i, U0_i, U0CV_i, U0R_i, ETAMOB_i, NGATE_i, RDSW_i, UPR_i;
real PRWGS_i, PRWGD_i, WR_i, PDIBL1_i, PDIBL1R_i, PDIBL2_i, PDIBL2R_i, PDIBL2_a;
real DROUT_i, PVAG_i;
real AIGBINV_i, AIGBINV1_i, BIGBINV_i, CIGBINV_i, EIGBINV_i, NIGBINV_i;
real AIGBACC_i, AIGBACC1_i, BIGBACC_i, CIGBACC_i, NIGBACC_i;
real AIGC_i, AIGC1_i, BIGC_i, CIGC_i, PIGCD_i;
real AIGS_i, AIGS1_i, BIGS_i, CIGS_i, NTOX_i, POXEDGE_i;
real AIGD_i, AIGD1_i, BIGD_i, CIGD_i;
real AGIDL_i, BGIDL_i, CGIDL_i, EGIDL_i, PGIDL_i;
real ATATD_i, BTATD_i, CTATD_i, DTATD_i;
real AGIDLB_i, BGIDLB_i, CGIDLB_i, EGIDLB_i, PGIDLB_i;
real AGISL_i, BGISL_i, CGISL_i, EGISL_i, PGISL_i;
real ATATS_i, BTATS_i, CTATS_i, DTATS_i;
real AGISLB_i, BGISLB_i, CGISLB_i, EGISLB_i, PGISLB_i;
real ALPHA0_i, ALPHA1_i, ALPHAII0_i, ALPHAII1_i, BETA0_i;
real BETAII0_i, BETAII1_i, BETAII2_i, ESATII_i;
real LII_i, SII0_i, SII1_i, SII2_i, SIID_i, TII_i;
real MEXP_i, MEXPR_i;
real PCLM_i, PCLMG_i, PCLMCV_i, PCLM_a, PCLMR_i, PCLM_t;
real A1_i, A2_i, A11_i, A21_i;
real K1RSCE_i, LPE0_i, DVTSHIFT_i, DVTSHIFT_a, DVTSHIFTR_i;
real UA_i, UACV_i, UC_i, UCCV_i, EU_i, UD_i, UDCV_i, UCS_i, UAR_i, EUR_i, UCR_i, UDR_i, UA_a, UD_a, UC_a, EU_a;
real UA1_i, UA2_i, UA1R_i, UA1CV_i, UA2CV_i, UC1_i, UC1CV_i, UD1_i, UD2_i, UD1CV_i, UD2CV_i, UCSTE_i, UCSTE1_i, UTE_i, UTE1_i, UTL_i, UTECV_i, UTE1CV_i, UTLCV_i, EMOBT_i, UC1R_i, UD1R_i, UTER_i, UTLR_i, EU1_i;
real PTWGT_i;
real AT_i, ATCV_i, ATR_i;
real RDW_i, RSW_i;
real PRT_i, PRT1_i, TR0_i, SPRT_i, KT1_i, TSS_i, IIT_i, IGT_i, TGIDL_i, TTAT_i;
real NTGEN_i, AIGEN_i, BIGEN_i;
real K0SISAT_i, K0SISAT1_i;
real K2SISAT_i, K2SISAT1_i;
real K2_i, K21_i;
real XRCRG1_i, XRCRG2_i;
real LINTIGEN_i;
real XL_i, LINT_i, DLBIN_i, XW_i, DWBIN_i;
real ASAT_i;

//quantum subband binning
real DIMENSION1_i, DIMENSION2_i, DIMENSION3_i, SSP1_i, SSP2_i, SSP3_i, E2NOM_i, E3NOM_i, MFQ1NOM_i, MFQ2NOM_i, MFQ3NOM_i;

// Unified FinFET compact model
real Cins, Ach, Weff_UFCM, WeffB, qdep, rc, vth_fixed_factor_Sub, vth_fixed_factor_SI, qm, qm_ln, Qdep_ov_Cins, qi_acc_for_QM, qdrift, qdrift_s, qdrift_d, qdrift_S, qdrift_D, qdrift_a, qdrift_diff;
real fieldnormalizationfactor, auxQMfact, QMFACTORCVfinal;
real vdr_ov, Esat_ov, EsatL_ov, Vdsat_ov, Vdseff_ov, inv_mexpdr;
real psipclamp, sqrtpsip, nq, F0;

// Fringe capacitance
real Hr, Lr, Hgdelta, Lmax, y, x, Cnon, CcgSat, TT1, Ccg1, r1cf, Rcf, Ccg2;
real Ccg, C1, C2, C3, Cfglog, dcf, TT0, TT2, Cfgsat, Cfg;

// Variables for Nanosheet model
real Ach1, Ach2, Ach3, Ach4, Ach5, Ach6, Weff1, Weff2, Weff3, Weff4, Weff5, Weff6;

//quantum subband model
real d1, d2, d3, p1, p2, p3, Wp1, Wp2, Wp3, Tp1, Tp2, Tp3, ne3h, pe3h, ne2h, pe2h;
real VnD1, VnD2, VnD3, qndnf1, qndnf2, qndnf3, nc3d0, nc3d, ncq, qe2, qe3, qe2n, qe3n, nc1l0, pnc1l, nc2l0, pnc2l, nc3l0, pnc3l;
real nc1l, nc1ln, nc1, nc2l, nc2ln, nc2, nc3l, nc3ln, nc3, qnds1, qnds2, qnds3, qndd1, qndd2, qndd3, qnd10, qnd20, qnd30;
real QT0, QT1, QT2, QT3, QT4, QT5, QT6, QT7, QT8, QT9, QT10;

//geometry dependent mobility
real mut0, mut1, mut2, mut3, mut4, mut5, mut6;

//Nanosheet parasitic capcitance model (cgeomod=3)
real Hrsd2, Acorner_topm, Acorner_tb, Cgg_topm, Cgg_tb, Cgg_sidetopm, Cgg_sidetb, Cgg_sidepff;

// S/D velocity saturation
real rdstempvs, Rvs_s, Rvs_d, gvs_d, gvs_s;
real VSATRSD_t, vsatrsd_eff;
real isat_rs, isat_rd, vsat_rd, vsat_rs;
real delta_vsrd, delta_vsrs;

//gmin implementation
real gmin;

//vdssat OP
real Lterm0, Lterm;
// ---- end `include "bsimcmg_variables.include" ----
// ---- begin `include "bsimcmg_body.include" ----
// *  BSIM-CMG 112.1.0 released on 04/28/2026                            *
// *  BSIM Common Multi-Gate Model (Verilog-A)                                *
// ****************************************************************************

// ****************************************************************************
// *  Copyright © 2026 University of California                               *
// *                                                                          *
// *  Project director: Prof. Sayeef Salahuddin                               *
// *                    Prof. Chenming Hu                                     *
// *                                                                          *
// *  Developers: https://www.bsim.berkeley.edu/models/bsimcmg/auth_cmg/      *
// ****************************************************************************

// Clamped exponential function
analog function real lexp;
    input x; real x;
    begin
        if (x > `EXPL_THRESHOLD) begin
            lexp = `MAX_EXPL * (1.0 + x - `EXPL_THRESHOLD);
        end else if (x < -`EXPL_THRESHOLD) begin
            lexp = `MIN_EXPL;
        end else begin
            lexp = exp(x);
        end
    end
endfunction

// Clamped logarithm function
analog function real llnf;
    input x; real x;
    begin
        if (x > `N_MINLOG) begin
            llnf = ln(x);
        end else begin
            llnf = `LN_N_MINLOG;
        end
    end
endfunction

// Hyperbolic smoothing function
analog function real hypsmooth;
    input x, c; real x, c;
    begin
        if (x < -1e4 * c) begin
            hypsmooth = -c * c / x;
        end else begin
            hypsmooth = 0.5 * (x + sqrt(x * x + 4.0 * c * c));
        end
    end
endfunction

// Hyperbolic smoothing function with a maximum value
analog function real hypmax;
    input x, xmin, c; real x, xmin, c;
    begin
        hypmax = (xmin + 0.5 * (x - xmin - c + sqrt((x - xmin - c) * (x - xmin - c) - 4.0 * xmin * c)));
    end
endfunction

// Smoothing function with a minimum value
analog function real smoothminx;
    input x, x0, deltax; real x, x0, deltax;
    begin
        smoothminx = (0.5 * (x + x0 + sqrt((x - x0) * (x - x0) + 0.25 * deltax * deltax)));
    end
endfunction

// Smoothing function with a maximum value
analog function real smoothmaxx;
    input x, x0, deltax; real x, x0, deltax;
    begin
        smoothmaxx = (0.5 * (x + x0 - sqrt((x - (x0)) * (x - (x0)) + 0.25 * deltax * deltax)) + 0.25 * deltax);
    end
endfunction

// Smoothing function with a maximum value
analog function real smoothmaxx2;
    input x, x0, deltax; real x, x0, deltax;
    begin
        smoothmaxx2 = (0.5 * (x + x0 - sqrt((x - (x0)) * (x - (x0)) + 0.25 * deltax * deltax)));
    end
endfunction

//Gamma function
analog function real gammafunc;
    input x; real x;
    begin
        gammafunc = (0.0385 * exp(-4.6 * (x-1)) + 7.5893e-7 * pow(2*(x) - 3, 8) + 6.9583e-5 * pow(2*(x-1), 6) - 6.583e-4 * pow(2*(x-1), 5) + 0.0065 * pow(2*(x-1), 4) - 0.026 * pow(2*(x-1), 3) + 0.1371 * pow(2*(x-1), 2) - 0.194 * 2*(x-1) + 0.959);
    end
endfunction

// ln(1 + exp(x)) function
analog function real ln_one_plus_exp;
    input x; real x;
    begin
        if (x > 37) begin
            ln_one_plus_exp = x;
        end else if (x < -37) begin
            ln_one_plus_exp = exp(x);
        end else begin
            ln_one_plus_exp = ln(1.0 + exp(x));
        end
    end
endfunction

// exp(x) - 1 function
analog function real expm1;
    input x; real x;
    begin
        if (abs(x) < 1e-7) begin
            expm1 = x + 0.5 * x * x;
        end else begin
            expm1 = lexp(x) - 1.0;
        end
    end
endfunction

analog begin
    // Bias-independent calculations
    // Initialize variables for periodic steady state analysis
// ---- begin `include "bsimcmg_initialization.include" ----
// *  BSIM-CMG 112.1.0 released on 04/28/2026                            *
// *  BSIM Common Multi-Gate Model (Verilog-A)                                *
// ****************************************************************************

// ****************************************************************************
// *  Copyright © 2026 University of California                               *
// *                                                                          *
// *  Project director: Prof. Sayeef Salahuddin                               *
// *                    Prof. Chenming Hu                                     *
// *                                                                          *
// *  Developers: https://www.bsim.berkeley.edu/models/bsimcmg/auth_cmg/      *
// ****************************************************************************

// Source/drain resistances
Dr = 0.0; Rdrain = 0.0; Rsource = 0.0; Rdsi = 0.0;

// Temperature effects
CJS_t = 0.0; CJSWS_t = 0.0; CJSWGD_t = 0.0;
CJD_t = 0.0; CJSWD_t = 0.0; CJSWGS_t = 0.0;
PBS_t = 0.0; PBSWS_t = 0.0; PBSWGS_t = 0.0;
PBD_t = 0.0; PBSWD_t = 0.0; PBSWGD_t = 0.0;
JSS_t = 0.0; JSWS_t = 0.0; JSWGS_t = 0.0;
JSD_t = 0.0; JSWD_t = 0.0; JSWGD_t = 0.0;
JTSS_t = 0.0; JTSD_t = 0.0;
JTSSWS_t = 0.0; JTSSWD_t = 0.0;
JTSSWGS_t = 0.0; JTSSWGD_t = 0.0;
NJTS_t = 0.0; NJTSD_t = 0.0;
NJTSSW_t = 0.0; NJTSSWD_t = 0.0;
NJTSSWG_t = 0.0; NJTSSWGD_t = 0.0;
RSDRR_t = 0.0; RDDRR_t = 0.0;
UAR_t = 0.0; UC_t = 0.0; UCCV_t = 0.0; UCR_t = 0.0; UDR_t = 0.0;
VSATR_t = 0.0; VSAT1R_t = 0.0; MEXPR_t = 0.0; PTWGR_t = 0.0; SPRT_i = 0.0;

// Quantum mechanical correction
Tcen0 = 0.0;

// Midpoint potential and charge
qba = 0.0; u0r_v = 0.0;

// Geometry-dependent fringe capacitance
Cfr_geo = 0.0;

// Gate resistance
ggeltd = 0.0; ggint = 0.0; ggp = 0.0;

// Gate current
igbinv_v = 0.0; igbacc_v = 0.0;
igbs_v = 0.0; igbd_v = 0.0;
igcs_v = 0.0; igcd_v = 0.0;
igs_v = 0.0; igd_v = 0.0;

// GIDL/GISL
igisl_v = 0.0; igidl_v = 0.0; igislb = 0; igidlb = 0;
AGIDLB_i = 0; BGIDLB_i = 0; BGIDLB_t = 0; CGIDLB_i = 0; EGIDLB_i = 0; PGIDLB_i = 0;
AGISLB_i = 0; BGISLB_i = 0; BGISLB_t = 0; CGISLB_i = 0; EGISLB_i = 0; PGISLB_i = 0;

// Impact ionization current
Iii = 0.0;

// Accumulation capacitance
cox_acc = 0.0; qg_acc = 0.0; qb_acc = 0.0;

// Parasitic capacitance
qgs_ov = 0.0; qgd_ov = 0.0;

// Junction current and capacitance
Ies = 0.0; Ied = 0.0;
Czbs = 0.0; Czbssw = 0.0; Czbsswg = 0.0;
Czbd = 0.0; Czbdsw = 0.0; Czbdswg = 0.0;
Qesj = 0.0; Qedj = 0.0;
Isbs = 0.0; Isbd = 0.0;
Nvtms = 0.0; Nvtmd = 0.0;
SslpFwd = 0.0; IVjsmFwd = 0.0; VjsmFwd = 0.0; XExpBVS = 0.0;
SslpRev = 0.0; IVjsmRev = 0.0; VjsmRev = 0.0;
DslpFwd = 0.0; IVjdmFwd = 0.0; VjdmFwd = 0.0; XExpBVD = 0.0;
DslpRev = 0.0; IVjdmRev = 0.0; VjdmRev = 0.0;
vec1s = 0.0; pb21s = 0.0;
vec2s = 0.0; pb22s = 0.0;
vec3s = 0.0; pb23s = 0.0;
vec1d = 0.0; pb21d = 0.0;
vec2d = 0.0; pb22d = 0.0;
vec3d = 0.0; pb23d = 0.0;

// NQS gate resistance
gcrg = 0.0; gtau = 0.0;

// Thermal noise
sid = 0.0;

//Flicker noise
lambdac_fn2 = 0.0; ef_v = 0.0; DrainFac = 0.0; NeffT = 0.0; NOIA2_i = 0.0; MPOWER_i = 0.0; FNPowerAt1Hz = 0.0;

// Correlated thermal noise
Dr0 = 0.0; ctnoi = 0.0; sigrat = 0.0;

// Self-heating
gth = 0.0; cth = 0.0;

// Short channel effects
CITR_i = 0.0; CDSCDR_i = 0.0; ETA0R_i = 0.0; DVTSHIFTR_i = 0.0;

// Body effect
veseff = 0.0;
PHIBE_i = 0.0; K1_i = 0.0; K11_i = 0.0; K2SAT_i = 0.0; K2SAT1_i = 0.0;
K2_i = 0.0; K21_i = 0.0;

// Velocity satuation
VSATR_i = 0.0; VSAT1R_i = 0.0; KSATIVR_i = 0.0; MEXPR_i = 0.0;
PTWGR_i = 0.0; ATR_i = 0.0;

// Mobility
U0R_i = 0.0; UPR_i = 0.0; UAR_i = 0.0; UC_i = 0.0; UCR_i = 0.0; EUR_i = 0.0;
UDR_i = 0.0; UTER_i = 0.0; UTLR_i = 0.0;
UA1R_i = 0.0; UC1_i = 0.0; UC1R_i = 0.0; UD1R_i = 0.0;

// DIBL
PDIBL1R_i = 0.0; PDIBL2R_i = 0.0;

// Channel length modulation
PCLMR_i = 0.0;

// Overlap capacitance
CGSO_i = 0.0; CGDO_i = 0.0; COVD_i = 0.0; COVS_i = 0.0;

// NQS gate resistance model & charge deficit model
XRCRG1_i = 0.0; XRCRG2_i = 0.0;

// Unified FinFET compact model
Cins = 0.0; Ach = 0.0; Weff_UFCM = 0.0; WeffB = 0.0; rc = 0.0; Qdep_ov_Cins = 0.0;
qi_acc_for_QM = 0.0; nq = 0.0; qis = 0; qid = 0; qbov = 0.0; qbov_s = 0.0;

// GAAFET model
Ach2 = 0.0; Ach3 = 0.0; Ach4 = 0.0; Ach5 = 0.0; Ach6 = 0.0; Weff2 = 0.0; Weff3 = 0.0; Weff4 = 0.0; Weff5 = 0.0; Weff6 = 0.0;
qnds1 = 0.0; qnds2 = 0.0; qnds3 = 0.0; qndd1 = 0.0;
qndd2 = 0.0; qndd3 = 0.0; nc3d = 1.0;
d1 = 0.0; d2 = 0.0; d3 = 0.0;
p1 = 0.0; p2 = 0.0; p3 = 0.0;
ncq = 0.0; qe2 = 0.0; qe3 = 0.0;
qnd10 = 0.0; qnd20 = 0.0; qnd30 = 0.0;
DIMENSION1_i = 0.0; DIMENSION2_i = 0.0; DIMENSION3_i = 0.0; SSP1_i = 0.0; SSP2_i = 0.0; SSP3_i = 0.0;
E2NOM_i = 0.0; E3NOM_i = 0.0; MFQ1NOM_i = 0.0; MFQ2NOM_i = 0.0; MFQ3NOM_i = 0.0;

// Cryogenic model
DevTemplow0 = 0.0; DevTemplow1 = 0.0; DevTempeff = 0.0; DevTemp1 = 0.0; delTemp1 = 0.0; delTRatio1 = 0.0; Vtmeff = 0.0;
niln = 0.0;
UDS_t = 0.0; UDD_t = 0.0; UA_tl = 0.0; UA_th = 0.0; UAR_tl = 0.0; UAR_th = 0.0; wl = 0.0; wh = 0.0; UDDeff_t = 0.0; UDSeff_t = 0.0;

// S/D velocity saturation model
Rvs_d = 0.0; Rvs_s = 0.0; rdstempvs = 0.0;
gvs_s = 0.0; gvs_d = 0.0; deltaprsd_v = 0.0;

//Others
gspr = 0.0; QSREF_i = 0.0;
gdpr = 0.0;
// ---- end `include "bsimcmg_initialization.include" ----

    gmin=$simparam("gmin",0);

    if ($port_connected(t) == 1) begin
        if ((shmod == 0 || rth0 == 0.0) && sh_warn == 1) begin
            $strobe("The optional 5th terminal is present in instance %m but not active because shmod = 0 or rth0 = 0.0");
        end
    end

    // N or p-type
    if (type == `ntype) begin
        devsign = 1;
    end else begin
        devsign = -1;
    end

    // Constants
    epssub = epsrsub * `EPS0;
    epssp = epsrsp * `EPS0;
    cbox = epsrox * `EPS0 / eotbox;
    epsratio = epsrsub / epsrox;

    // Constants for quantum mechanical effects
    mx = 0.916 * `MEL;
    mxprime = 0.190 * `MEL;
    md = 0.190 * `MEL;
    mdprime = 0.417 * `MEL;
    gprime = 4.0;
    gfactor = 2.0;

    XL_i    = xl + 1.0e-6 * lxl / l + nxl / nfin  + pxl * 1.0e-6 / (l * nfin);
    DLBIN_i = dlbin + 1.0e-6 * ldlbin / l + ndlbin / nfin  + pdlbin * 1.0e-6 / (l * nfin);
    LINT_i  = lint + 1.0e-6 * llint / l + nlint / nfin  + plint * 1.0e-6 / (l * nfin);

    // Effective channel length for I-V and C-V
    Lg = l + XL_i;
    if (Lg <= 0.0) begin
        $error("Fatal: Lg = %g is not positive.", Lg);
        Lg = l;
    end
    T0 = pow(Lg, -lln);
    deltaL = LINT_i + ll * T0;
    deltaL1 = LINT_i + ll * pow((Lg + DLBIN_i), -lln);
    deltaLCV = dlc + llc * T0;
    Leff = Lg - 2.0 * deltaL;
    Leff1 = Lg + DLBIN_i - 2.0 * deltaL1;
    LeffCV = Lg - 2.0 * deltaLCV;
    LeffCV_acc = LeffCV - dlcacc;
    if (Leff <= 0.0) begin
        $error("Fatal: Leff = %g is not positive.", Leff);
        Leff = Lg;
    end else if (Leff <= 1.0e-9) begin
        $strobe("Warning: Leff = %g <= 1.0e-9.", Leff);
    end

    if (Leff1 <= 0.0) begin
        $error("Fatal: Leff1 = %g is not positive.", Leff1);
        Leff1 = Lg;
    end else if (Leff1 <= 1.0e-9) begin
        $strobe("Warning: Leff1 = %g <= 1.0e-9.", Leff1);
    end
    if (LeffCV <= 0.0) begin
        $error("Fatal: LeffCV = %g is not positive.", LeffCV);
        LeffCV = Lg;
    end else if (LeffCV <= 1.0e-9) begin
        $strobe("Warning: LeffCV = %g <= 1.0e-9.", LeffCV);
    end
    if (bulkmod != 0) begin
        if (LeffCV_acc <= 0.0) begin
            $error("Fatal: LeffCV_acc = %g is not positive.", LeffCV_acc);
            LeffCV_acc = Lg;
        end else if (LeffCV_acc <= 1.0e-9) begin
            $strobe("Warning: LeffCV_acc = %g <= 1.0e-9.", LeffCV_acc);
        end
    end

    // Effective GAA channel width for I-V and C-V
    if (geomod == 5) begin
        XW_i = xw + 1.0e-6 * lxw / l + nxw / nfin  + pxw * 1.0e-6 / (l * nfin) + 1.0e-6 * wxw / wgaa + p2xw * 1.0e-12 / (l * wgaa);
        DWBIN_i = dwbin + 1.0e-6 * ldwbin / l + ndwbin / nfin  + pdwbin * 1.0e-6 / (l * nfin) +  1.0e-6 * wdwbin / wgaa + p2dwbin * 1.0e-12 / (l * wgaa);
    end else begin
        XW_i = 0;
        DWBIN_i = 0;
    end
    WGAAeff = wgaa + XW_i;
    WGAAeff1 = WGAAeff + DWBIN_i;

    if (geomod == 5) begin
        if (WGAAeff1 <= 0.0) begin
            $error("Fatal: WGAAeff1 = %g is not positive.", WGAAeff1);
            WGAAeff1 = wgaa;
        end else if (WGAAeff1 <= 1.0e-9) begin
            $strobe("Warning: WGAAeff1 = %g <= 1.0e-9.", WGAAeff1);
        end
    end

    // Total Fins
    NFINtotal = nfin * nf;

    // Binning
    Inv_L = 1.0e-6 / Leff1;
    Inv_NFIN = 1.0 / nfin;
    Inv_LNFIN = 1.0e-6 / (Leff1 * nfin);
    if (geomod == 5) begin
        Inv_W = 1.0e-6 / WGAAeff1;
        Inv_WL = 1.0e-12 / (WGAAeff1 * Leff1);
    end else begin
        Inv_W = 0.0;
        Inv_WL = 0.0;
    end

    // Nbody binning equation
    `binning(NBODY_i, nbody, lnbody, nnbody, pnbody, 0.0, 0.0)
    if (nbodyn1 != 0.0) begin
        NBODY_i = NBODY_i * (1.0 + nbodyn1 / nfin * llnf(1.0 + nfin / nbodyn2));
    end

    if (NBODY_i <= 0.0) begin
        $error("Fatal: Effective  nbody = %g is not positive.", NBODY_i);
        NBODY_i = 1.0e22;
    end else if (NBODY_i <= 1.0e18) begin
        $strobe("Warning: NBODY_i = %g m^-3 may be too small.", NBODY_i);
    end

    // Unified FinFET compact model
    case (geomod)
        // Double gate
        0: begin
            if (tfin_top == 0.0 || tfin_base == 0.0) begin
                Weff_UFCM = 2.0 * hfin;
                Cins = Weff_UFCM * epsrox * `EPS0 / eot;
                Ach = hfin * tfin;
            end else begin
                Weff_UFCM = 2.0 * sqrt(hfin * hfin + (tfin_top - tfin_base) * (tfin_top - tfin_base) / 4.0);
                Cins = Weff_UFCM * epsrox * `EPS0 / eot;
                Ach = hfin * (tfin_top + tfin_base) / 2.0;
            end
        end
        // Triple gate
        1: begin
            if (tfin_top == 0.0 || tfin_base == 0.0) begin
                Weff_UFCM = 2.0 * hfin + tfin;
                Cins = Weff_UFCM * epsrox * `EPS0 / eot;
                Ach = hfin * tfin;
            end else begin
                Weff_UFCM = 2.0 * sqrt(hfin * hfin + (tfin_top - tfin_base) * (tfin_top - tfin_base) / 4.0) + tfin_top;
                Cins = Weff_UFCM * epsrox * `EPS0 / eot;
                Ach = hfin * (tfin_top + tfin_base) / 2.0;
            end
        end
        // Quadruple gate
        2: begin
            if (tfin_top == 0.0 || tfin_base == 0.0) begin
                Weff_UFCM = 2.0 * hfin + 2.0 * tfin;
                Cins = Weff_UFCM * epsrox * `EPS0 / eot;
                Ach = hfin * tfin;
            end else begin
                Weff_UFCM = 2.0 * sqrt(hfin * hfin + (tfin_top - tfin_base) * (tfin_top - tfin_base) / 4.0) + tfin_top + tfin_base;
                Cins = Weff_UFCM * epsrox * `EPS0 / eot;
                Ach = hfin * (tfin_top + tfin_base) / 2.0;
            end
            WeffB = tfin_base;
        end
        // Cylindrical gate
        3: begin
            Weff_UFCM = `M_PI * dia;
            Cins = 2.0 * `M_PI * epsrox * `EPS0 / llnf(1.0 + 2.0 * eot / dia);
            Ach = `M_PI * dia * dia / 4.0;
            WeffB = dia;
        end
        // Unified model
        4: begin
            Weff_UFCM = w_ufcm;
            Cins = cins_ufcm;
            Ach = ach_ufcm;
        end
        // Gate-All-Around FET model
        5: begin
            Weff1 = 2 * (WGAAeff + tgaa) + dws1;
            Ach1 = WGAAeff * tgaa + dach1;
            Weff_UFCM = Weff1;
            Ach = Ach1;
            if (ngaa > 1) begin
                Weff2 = 2 * (WGAAeff + tgaa) + dws2;
                Ach2 = WGAAeff * tgaa + dach2;
                Weff_UFCM = Weff1 + Weff2;
                Ach = Ach1 + Ach2;
            end
            if (ngaa > 2) begin
                Weff3 = 2 * (WGAAeff + tgaa) + dws3;
                Ach3 = WGAAeff * tgaa + dach3;
                Weff_UFCM = Weff1 + Weff2 + Weff3;
                Ach = Ach1 + Ach2 + Ach3;
            end
            if (ngaa > 3) begin
                Weff4 = 2 * (WGAAeff + tgaa) + dws4;
                Ach4 = WGAAeff * tgaa + dach4;
                Weff_UFCM = Weff1 + Weff2 + Weff3 + Weff4;
                Ach = Ach1 + Ach2 + Ach3 + Ach4;
            end
            if (ngaa > 4) begin
                Weff5 = 2 * (WGAAeff + tgaa) + dws5;
                Ach5 = WGAAeff * tgaa + dach5;
                Weff_UFCM = Weff1 + Weff2 + Weff3 + Weff4 + Weff5;
                Ach = Ach1 + Ach2 + Ach3 + Ach4 + Ach5;
            end
            if (ngaa > 5) begin
                Weff6 = 2 * (WGAAeff + tgaa) + dws6;
                Ach6 = WGAAeff * tgaa + dach6;
                Weff_UFCM = Weff1 + Weff2 + Weff3 + Weff4 + Weff5 + Weff6;
                Ach = Ach1 + Ach2 + Ach3 + Ach4 + Ach5 + Ach6;
            end
            WeffB = wgaa;
            Cins = Weff_UFCM * epsrox * `EPS0 / eot;
        end
    endcase
    rc = 2.0 * Cins / (Weff_UFCM * Weff_UFCM * epssub / Ach);
    Qdep_ov_Cins = -`q * NBODY_i * Ach / Cins;

    // Cox definition
    cox = Cins / Weff_UFCM;
    if (bulkmod != 0) begin
        cox_acc = cox * eot / eotacc;
    end

    // Effective width calculation
    Weff0 = Weff_UFCM - deltaw;
    WeffCV0 = Weff_UFCM - deltawcv;
    if (geomod == 5) begin
        WeffCV_acc = Weff0 - 2 * ngaa * dwcacc;
    end else begin
        WeffCV_acc = Weff0;
    end
    if (geomod == 5) begin
        if (bulkmod != 0) begin
            if (WeffCV_acc <= 0.0) begin
                $error("Fatal: WeffCV_acc = %g is not positive.", WeffCV_acc);
                WeffCV_acc = Weff_UFCM;
            end else if (WGAAeff1 <= 1.0e-9) begin
                $strobe("Warning: WeffCV_acc = %g <= 1.0e-9.", WeffCV_acc);
            end
        end
    end

    // Redefining model parameters with limits set by instance parameters
    deltaprsd_v = deltaprsd;
    ef_v = ef;

    // Binning equations
    `binning(PHIG_i, phig, lphig, nphig, pphig, wphig, p2phig)
    `binning(NGATE_i, ngate, lngate, nngate, pngate, wngate, p2ngate)
    `binning(CIT_i, cit, lcit, ncit, pcit, wcit, p2cit)
    `binning(CDSC_i, cdsc, lcdsc, ncdsc, pcdsc, wcdsc, p2cdsc)
    `binning(CDSCD_i, cdscd, lcdscd, ncdscd, pcdscd, wcdscd, p2cdscd)
    `binning(DVT0_i, dvt0, ldvt0, ndvt0, pdvt0, wdvt0, p2dvt0)
    `binning(DVT1_i, dvt1, ldvt1, ndvt1, pdvt1, wdvt1, p2dvt1)
    `binning(DVT1SS_i, dvt1ss, ldvt1ss, ndvt1ss, pdvt1ss, wdvt1ss, p2dvt1ss)
    `binning(PHIN_i, phin, lphin, nphin, pphin, wphin, p2phin)
    `binning(ETA0_i, eta0, leta0, neta0, peta0, weta0, p2eta0)
    `binning(ETA1_i, eta1, leta1, neta1, peta1, weta1, p2eta1)
    `binning(DSUB_i, dsub, ldsub, ndsub, pdsub, wdsub, p2dsub)
    `binning(K1RSCE_i, k1rsce, lk1rsce, nk1rsce, pk1rsce, wk1rsce, p2k1rsce)
    `binning(LPE0_i, lpe0, llpe0, nlpe0, plpe0, wlpe0, p2lpe0)
    `binning(DVTSHIFT_i, dvtshift, ldvtshift, ndvtshift, pdvtshift, wdvtshift, p2dvtshift)
    `binning(K0_i, k0, lk0, nk0, pk0, wk0, p2k0)
    `binning(K01_i, k01, lk01, nk01, pk01, wk01, p2k01)
    `binning(K0SI_i, k0si, lk0si, nk0si, pk0si, wk0si, p2k0si)
    `binning(K0SI1_i, k0si1, lk0si1, nk0si1, pk0si1, wk0si1, p2k0si1)
    `binning(K2SI_i, k2si, lk2si, nk2si, pk2si, wk2si, p2k2si)
    `binning(K2SI1_i, k2si1, lk2si1, nk2si1, pk2si1, wk2si1, p2k2si1)
    `binning(K0SISAT_i, k0sisat, lk0sisat, nk0sisat, pk0sisat, wk0sisat, p2k0sisat)
    `binning(K0SISAT1_i, k0sisat1, lk0sisat1, nk0sisat1, pk0sisat1, wk0sisat1, p2k0sisat1)
    `binning(K2SISAT_i, k2sisat, lk2sisat, nk2sisat, pk2sisat, wk2sisat, p2k2sisat )
    `binning(K2SISAT1_i, k2sisat1, lk2sisat1, nk2sisat1, pk2sisat1, wk2sisat1, p2k2sisat1)
    `binning(QMFACTOR_i, qmfactor, lqmfactor, nqmfactor, pqmfactor, wqmfactor, p2qmfactor)
    `binning(QMTCENCV_i, qmtcencv, lqmtcencv, nqmtcencv, pqmtcencv, wqmtcencv, p2qmtcencv)
    `binning(QMTCENCVA_i, qmtcencva, lqmtcencva, nqmtcencva, pqmtcencva, wqmtcencva, p2qmtcencva)
    `binning(PQM_i, pqm, lpqm, npqm, ppqm, wpqm, p2pqm)
    `binning(VSAT_i, vsat, lvsat, nvsat, pvsat, wvsat, p2vsat)
    `binning(VSAT1_i, vsat1, lvsat1, nvsat1, pvsat1, wvsat1, p2vsat1)
    `binning(VSATCV_i, vsatcv, lvsatcv, nvsatcv, pvsatcv, wvsatcv, p2vsatcv)
    `binning(ASAT_i, asat, lasat, nasat, pasat, wasat, p2asat)
    `binning(DELTAVSAT_i, deltavsat, ldeltavsat, ndeltavsat, pdeltavsat, wdeltavsat, p2deltavsat)
    `binning(PSAT_i, psat, lpsat, npsat, ppsat, wpsat, p2psat)
    `binning(DELTAVSATCV_i, deltavsatcv, ldeltavsatcv, ndeltavsatcv, pdeltavsatcv, wdeltavsatcv, p2deltavsatcv)
    `binning(PSATCV_i, psatcv, lpsatcv, npsatcv, ppsatcv, wpsatcv, p2psatcv)
    `binning(KSATIV_i, ksativ, lksativ, nksativ, pksativ, wksativ, p2ksativ)
    `binning(MEXP_i, mexp, lmexp, nmexp, pmexp, wmexp, p2mexp)
    `binning(PTWG_i, ptwg, lptwg, nptwg, pptwg, wptwg, p2ptwg)
    `binning(U0_i, u0, lu0, nu0, pu0, wu0, p2u0)
    `binning(ETAMOB_i, etamob, letamob, netamob, petamob, wetamob, p2etamob)
    `binning(UP_i, up, lup, nup, pup, wup, p2up)
    `binning(UA_i, ua, lua, nua, pua, wua, p2ua)
    `binning(EU_i, eu, leu, neu, peu, weu, p2eu)
    `binning(UD_i, ud, lud, nud, pud, wud, p2ud)
    `binning(UCS_i, ucs, lucs, nucs, pucs, wucs, p2ucs)
    `binning(UDS_i, uds, luds, nuds, puds, wuds, p2uds)
    `binning(UDS1_i, uds1, luds1, nuds1, puds1, wuds1, p2uds1)
    `binning(UDD_i, udd, ludd, nudd, pudd, wudd, p2udd)
    `binning(UDD1_i, udd1, ludd1, nudd1, pudd1, wudd1, p2udd1)
    `binning(PCLM_i, pclm, lpclm, npclm, ppclm, wpclm, p2pclm)
    `binning(PCLMG_i, pclmg, lpclmg, npclmg, ppclmg, wpclmg, p2pclmg)
    `binning(PCLMCV_i, pclmcv, lpclmcv, npclmcv, ppclmcv, wpclmcv, p2pclmcv)
    `binning(A1_i, a1, la1, na1, pa1, wa1, p2a1)
    `binning(A11_i, a11, la11, na11, pa11, wa11, p2a11)
    `binning(A2_i, a2, la2, na2, pa2, wa2, p2a2)
    `binning(A21_i, a21, la21, na21, pa21, wa21, p2a21)
    `binning(RDSW_i, rdsw, lrdsw, nrdsw, prdsw, wrdsw, p2rdsw)
    `binning(RSW_i, rsw, lrsw, nrsw, prsw, wrsw, p2rsw)
    `binning(RDW_i, rdw, lrdw, nrdw, prdw, wrdw, p2rdw)
    `binning(PRWGD_i, prwgd, lprwgd, nprwgd, pprwgd, wprwgd, p2prwgd)
    `binning(PRWGS_i, prwgs, lprwgs, nprwgs, pprwgs, wprwgs, p2prwgs)
    `binning(WR_i, wr, lwr, nwr, pwr, wwr, p2wr)
    `binning(PDIBL1_i, pdibl1, lpdibl1, npdibl1, ppdibl1, wpdibl1, p2pdibl1)
    `binning(PDIBL2_i, pdibl2, lpdibl2, npdibl2, ppdibl2, wpdibl2, p2pdibl2)
    `binning(DROUT_i, drout, ldrout, ndrout, pdrout, wdrout, p2drout)
    `binning(PVAG_i, pvag, lpvag, npvag, ppvag, wpvag, p2pvag)
    `binning(AIGBINV_i, aigbinv, laigbinv, naigbinv, paigbinv, waigbinv, p2aigbinv)
    `binning(AIGBINV1_i, aigbinv1, laigbinv1, naigbinv1, paigbinv1, waigbinv1, p2aigbinv1)
    `binning(BIGBINV_i, bigbinv, lbigbinv, nbigbinv, pbigbinv, wbigbinv, p2bigbinv)
    `binning(CIGBINV_i, cigbinv, lcigbinv, ncigbinv, pcigbinv, wcigbinv, p2cigbinv)
    `binning(EIGBINV_i, eigbinv, leigbinv, neigbinv, peigbinv, weigbinv, p2eigbinv)
    `binning(NIGBINV_i, nigbinv, lnigbinv, nnigbinv, pnigbinv, wnigbinv, p2nigbinv)
    `binning(AIGBACC_i, aigbacc, laigbacc, naigbacc, paigbacc, waigbacc, p2aigbacc)
    `binning(AIGBACC1_i, aigbacc1, laigbacc1, naigbacc1, paigbacc1, waigbacc1, p2aigbacc1)
    `binning(BIGBACC_i, bigbacc, lbigbacc, nbigbacc, pbigbacc, wbigbacc, p2bigbacc)
    `binning(CIGBACC_i, cigbacc, lcigbacc, ncigbacc, pcigbacc, wcigbacc, p2cigbacc)
    `binning(NIGBACC_i, nigbacc, lnigbacc, nnigbacc, pnigbacc, wnigbacc, p2nigbacc)
    `binning(AIGC_i, aigc, laigc, naigc, paigc, waigc, p2aigc)
    `binning(AIGC1_i, aigc1, laigc1, naigc1, paigc1, waigc1, p2aigc1)
    `binning(BIGC_i, bigc, lbigc, nbigc, pbigc, wbigc, p2bigc)
    `binning(CIGC_i, cigc, lcigc, ncigc, pcigc, wcigc, p2cigc)
    `binning(PIGCD_i, pigcd, lpigcd, npigcd, ppigcd, wpigcd, p2pigcd)
    `binning(AIGS_i, aigs, laigs, naigs, paigs, waigs, p2aigs)
    `binning(AIGS1_i, aigs1, laigs1, naigs1, paigs1, waigs1, p2aigs1)
    `binning(BIGS_i, bigs, lbigs, nbigs, pbigs, wbigs, p2bigs)
    `binning(CIGS_i, cigs, lcigs, ncigs, pcigs, wcigs, p2cigs)
    `binning(AIGD_i, aigd, laigd, naigd, paigd, waigd, p2aigd)
    `binning(AIGD1_i, aigd1, laigd1, naigd1, paigd1, waigd1, p2aigd1)
    `binning(BIGD_i, bigd, lbigd, nbigd, pbigd, wbigd, p2bigd)
    `binning(CIGD_i, cigd, lcigd, ncigd, pcigd, wcigd, p2cigd)
    `binning(NTOX_i, ntox, lntox, nntox, pntox, wntox, p2ntox)
    `binning(POXEDGE_i, poxedge, lpoxedge, npoxedge, ppoxedge, wpoxedge, p2poxedge)
    `binning(AGIDL_i, agidl, lagidl, nagidl, pagidl, wagidl, p2agidl)
    `binning(BGIDL_i, bgidl, lbgidl, nbgidl, pbgidl, wbgidl, p2bgidl)
    `binning(CGIDL_i, cgidl, lcgidl, ncgidl, pcgidl, wcgidl, p2cgidl)
    `binning(EGIDL_i, egidl, legidl, negidl, pegidl, wegidl, p2egidl)
    `binning(PGIDL_i, pgidl, lpgidl, npgidl, ppgidl, wpgidl, p2pgidl)
    `binning(ATATD_i, atatd, latatd, natatd, patatd, watatd, p2atatd)
    `binning(BTATD_i, btatd, lbtatd, nbtatd, pbtatd, wbtatd, p2btatd)
    `binning(CTATD_i, ctatd, lctatd, nctatd, pctatd, wctatd, p2ctatd)
    `binning(DTATD_i, dtatd, ldtatd, ndtatd, pdtatd, wdtatd, p2dtatd)
    `binning(AGISL_i, agisl, lagisl, nagisl, pagisl, wagisl, p2agisl)
    `binning(BGISL_i, bgisl, lbgisl, nbgisl, pbgisl, wbgisl, p2bgisl)
    `binning(CGISL_i, cgisl, lcgisl, ncgisl, pcgisl, wcgisl, p2cgisl)
    `binning(EGISL_i, egisl, legisl, negisl, pegisl, wegisl, p2egisl)
    `binning(PGISL_i, pgisl, lpgisl, npgisl, ppgisl, wpgisl, p2pgisl)
    `binning(ATATS_i, atats, latats, natats, patats, watats, p2atats)
    `binning(BTATS_i, btats, lbtats, nbtats, pbtats, wbtats, p2btats)
    `binning(CTATS_i, ctats, lctats, nctats, pctats, wctats, p2ctats)
    `binning(DTATS_i, dtats, ldtats, ndtats, pdtats, wdtats, p2dtats)
    `binning(ALPHA0_i, alpha0, lalpha0, nalpha0, palpha0, walpha0, p2alpha0)
    `binning(ALPHA1_i, alpha1, lalpha1, nalpha1, palpha1, walpha1, p2alpha1)
    `binning(ALPHAII0_i, alphaii0, lalphaii0, nalphaii0, palphaii0, walphaii0, p2alphaii0)
    `binning(ALPHAII1_i, alphaii1, lalphaii1, nalphaii1, palphaii1, walphaii1, p2alphaii1)
    `binning(BETA0_i, beta0, lbeta0, nbeta0, pbeta0, wbeta0, p2beta0)
    `binning(BETAII0_i, betaii0, lbetaii0, nbetaii0, pbetaii0, wbetaii0, p2betaii0)
    `binning(BETAII1_i, betaii1, lbetaii1, nbetaii1, pbetaii1, wbetaii1, p2betaii1)
    `binning(BETAII2_i, betaii2, lbetaii2, nbetaii2, pbetaii2, wbetaii2, p2betaii2)
    `binning(ESATII_i, esatii, lesatii, nesatii, pesatii, wesatii, p2esatii)
    `binning(LII_i, lii, llii, nlii, plii, wlii, p2lii)
    `binning(SII0_i, sii0, lsii0, nsii0, psii0, wsii0, p2sii0)
    `binning(SII1_i, sii1, lsii1, nsii1, psii1, wsii1, p2sii1)
    `binning(SII2_i, sii2, lsii2, nsii2, psii2, wsii2, p2sii2)
    `binning(SIID_i, siid, lsiid, nsiid, psiid, wsiid, p2siid)
    `binning(TII_i, tii, ltii, ntii, ptii, wtii, p2tii)
    `binning(CFS_i, cfs, lcfs, ncfs, pcfs, wcfs, p2cfs)
    `binning(CFD_i, cfd, lcfd, ncfd, pcfd, wcfd, p2cfd)
    `binning(COVS_i, covs, lcovs, ncovs, pcovs, wcovs, p2covs)
    `binning(COVD_i, covd, lcovd, ncovd, pcovd, wcovd, p2covd)
    `binning(CGSL_i, cgsl, lcgsl, ncgsl, pcgsl, wcgsl, p2cgsl)
    `binning(CGDL_i, cgdl, lcgdl, ncgdl, pcgdl, wcgdl, p2cgdl)
    `binning(CGBL_i, cgbl, lcgbl, ncgbl, pcgbl, wcgbl, p2cgbl)
    `binning(CKAPPAS_i, ckappas, lckappas, nckappas, pckappas, wckappas, p2ckappas)
    `binning(CKAPPAD_i, ckappad, lckappad, nckappad, pckappad, wckappad, p2ckappad)
    `binning(CKAPPAB_i, ckappab, lckappab, nckappab, pckappab, wckappab, p2ckappab)
    `binning(NTGEN_i, ntgen, lntgen, nntgen, pntgen, wntgen, p2ntgen)
    `binning(AIGEN_i, aigen, laigen, naigen, paigen, waigen, p2aigen)
    `binning(BIGEN_i, bigen, lbigen, nbigen, pbigen, wbigen, p2bigen)
    `binning(UTE_i, ute, lute, nute, pute, wute, p2ute)
    `binning(UTE1_i, ute1, lute1, nute1, pute1, wute1, p2ute1)
    `binning(UTL_i, utl, lutl, nutl, putl, wutl, p2utl)
    `binning(EMOBT_i, emobt, lemobt, nemobt, pemobt, wemobt, p2emobt)
    `binning(UA1_i, ua1, lua1, nua1, pua1, wua1, p2ua1)
    `binning(UA2_i, ua2, lua2, nua2, pua2, wua2, p2ua2)
    `binning(EU1_i, eu1, leu1, neu1, peu1, weu1, p2eu1)
    `binning(UD1_i, ud1, lud1, nud1, pud1, wud1, p2ud1)
    `binning(UD2_i, ud2, lud2, nud2, pud2, wud2, p2ud2)
    `binning(UCSTE_i, ucste, lucste, nucste, pucste, wucste, p2ucste)
    `binning(UCSTE1_i, ucste1, lucste1, nucste1, pucste1, wucste1, p2ucste1)
    `binning(PTWGT_i, ptwgt, lptwgt, nptwgt, pptwgt, wptwgt, p2ptwgt)
    `binning(AT_i, at, lat, nat, pat, wat, p2at)
    `binning(ATCV_i, atcv, latcv, natcv, patcv, watcv, p2atcv)
    `binning(PRT_i, prt, lprt, nprt, pprt, wprt, p2prt)
    `binning(PRT1_i, prt1, lprt1, nprt1, pprt1, wprt1, p2prt1)
    `binning(TR0_i, tr0, ltr0, ntr0, ptr0, wtr0, p2tr0)
    `binning(SPRT_i, sprt, lsprt, nsprt, psprt, wsprt, p2sprt)
    `binning(KT1_i, kt1, lkt1, nkt1, pkt1, wkt1, p2kt1)
    `binning(TSS_i, tss, ltss, ntss, ptss, wtss, p2tss)
    `binning(IIT_i, iit, liit, niit, piit, wiit, p2iit)
    `binning(TGIDL_i, tgidl, ltgidl, ntgidl, ptgidl, wtgidl, p2tgidl)
    `binning(TTAT_i, ttat, lttat, nttat, pttat, wttat, p2ttat)
    `binning(IGT_i, igt, ligt, nigt, pigt, wigt, p2igt)
    `binning(DVTP0_i, dvtp0, ldvtp0, ndvtp0, pdvtp0, wdvtp0, p2dvtp0)
    `binning(DVTP1_i, dvtp1, ldvtp1, ndvtp1, pdvtp1, wdvtp1, p2dvtp1)
    `binning(NOIA2_i, noia2, lnoia2, nnoia2, pnoia2, wnoia2, p2noia2)
    `binning(QSREF_i, qsref, lqsref, nqsref, pqsref, wqsref, p2qsref)
    `binning(MPOWER_i, mpower, lmpower, nmpower, pmpower, wmpower, p2mpower)
    if (bulkmod != 0) begin
        `binning(PHIBE_i, phibe, lphibe, nphibe, pphibe, wphibe, p2phibe)
        `binning(K1_i, k1, lk1, nk1, pk1, wk1, p2k1)
        `binning(K11_i, k11, lk11, nk11, pk11, wk11, p2k11)
        `binning(UC_i, uc, luc, nuc, puc, wuc, p2uc)
        `binning(UC1_i, uc1, luc1, nuc1, puc1, wuc1, p2uc1)
        if (bulkmod == 2) begin
            `binning(K2_i, k2, lk2, nk2, pk2, wk2, p2k2)
            `binning(K21_i, k21, lk21, nk21, pk21, wk21, p2k21)
            `binning(K2SAT_i, k2sat, lk2sat, nk2sat, pk2sat, wk2sat, p2k2sat)
            `binning(K2SAT1_i, k2sat1, lk2sat1, nk2sat1, pk2sat1, wk2sat1, p2k2sat1)
        end
        if ((gidlmod == 2 || gidlmod == 3) && (geomod == 2 || geomod == 3 || geomod == 5)) begin
            `binning(AGIDLB_i, agidlb, lagidlb, nagidlb, pagidlb, wagidlb, p2agidlb)
            `binning(BGIDLB_i, bgidlb, lbgidlb, nbgidlb, pbgidlb, wbgidlb, p2bgidlb)
            `binning(CGIDLB_i, cgidlb, lcgidlb, ncgidlb, pcgidlb, wcgidlb, p2cgidlb)
            `binning(EGIDLB_i, egidlb, legidlb, negidlb, pegidlb, wegidlb, p2egidlb)
            `binning(PGIDLB_i, pgidlb, lpgidlb, npgidlb, ppgidlb, wpgidlb, p2pgidlb)
            `binning(AGISLB_i, agislb, lagislb, nagislb, pagislb, wagislb, p2agislb)
            `binning(BGISLB_i, bgislb, lbgislb, nbgislb, pbgislb, wbgislb, p2bgislb)
            `binning(CGISLB_i, cgislb, lcgislb, ncgislb, pcgislb, wcgislb, p2cgislb)
            `binning(EGISLB_i, egislb, legislb, negislb, pegislb, wegislb, p2egislb)
            `binning(PGISLB_i, pgislb, lpgislb, npgislb, ppgislb, wpgislb, p2pgislb)
        end
    end
    if (asymmod != 0) begin
        `binning(CDSCDR_i, cdscdr, lcdscdr, ncdscdr, pcdscdr, wcdscdr, p2cdscdr)
        `binning(CITR_i, citr, lcitr, ncitr, pcitr, wcitr, p2citr)
        `binning(ETA0R_i, eta0r, leta0r, neta0r, peta0r, weta0r, p2eta0r)
        `binning(VSAT1R_i, vsat1r, lvsat1r, nvsat1r, pvsat1r, wvsat1r, p2vsat1r)
        `binning(MEXPR_i, mexpr, lmexpr, nmexpr, pmexpr, wmexpr, p2mexpr)
        `binning(PTWGR_i, ptwgr, lptwgr, nptwgr, pptwgr, wptwgr, p2ptwgr)
        `binning(PDIBL1R_i, pdibl1r, lpdibl1r, npdibl1r, ppdibl1r, wpdibl1r, p2pdibl1r)
        `binning(PDIBL2R_i, pdibl2r, lpdibl2r, npdibl2r, ppdibl2r, wpdibl2r, p2pdibl2r)
        `binning(PCLMR_i, pclmr, lpclmr, npclmr, ppclmr, wpclmr, p2pclmr)
        `binning(DVTSHIFTR_i, dvtshiftr, ldvtshiftr, ndvtshiftr, pdvtshiftr, wdvtshiftr, p2dvtshiftr)
        `binning(VSATR_i, vsatr, lvsatr, nvsatr, pvsatr, wvsatr, p2vsatr)
        `binning(KSATIVR_i, ksativr, lksativr, nksativr, pksativr, wksativr, p2ksativr)
        `binning(U0R_i, u0r, lu0r, nu0r, pu0r, wu0r, p2u0r)
        `binning(UAR_i, uar, luar, nuar, puar, wuar, p2uar)
        `binning(UPR_i, upr, lupr, nupr, pupr, wupr, p2upr)
        `binning(EUR_i, eur, leur, neur, peur, weur, p2eur)
        `binning(UDR_i, udr, ludr, nudr, pudr, wudr, p2udr)
        `binning(UTER_i, uter, luter, nuter, puter, wuter, p2uter)
        `binning(UTLR_i, utlr, lutlr, nutlr, putlr, wutlr, p2utlr)
        `binning(UA1R_i, ua1r, lua1r, nua1r, pua1r, wua1r, p2ua1r)
        `binning(UD1R_i, ud1r, lud1r, nud1r, pud1r, wud1r, p2ud1r)
        `binning(ATR_i, atr, latr, natr, patr, watr, p2atr)
        if (bulkmod != 0) begin
            `binning(UCR_i, ucr, lucr, nucr, pucr, wucr, p2ucr)
            `binning(UC1R_i, uc1r, luc1r, nuc1r, puc1r, wuc1r, p2uc1r)
        end
    end
    if (cvmod == 1) begin
        `binning(U0CV_i, u0cv, lu0cv, nu0cv, pu0cv, wu0cv, p2u0cv)
        `nfin_scaling(U0CV_i, u0n1cv, u0n2cv)
        `binning(UACV_i, uacv, luacv, nuacv, puacv, wuacv, p2uacv)
        `binning(UDCV_i, udcv, ludcv, nudcv, pudcv, wudcv, p2udcv)
        `binning(UTECV_i, utecv, lutecv, nutecv, putecv, wutecv, p2utecv)
        `binning(UTE1CV_i, ute1cv, lute1cv, nute1cv, pute1cv, wute1cv, p2ute1cv)
        `binning(UTLCV_i, utlcv, lutlcv, nutlcv, putlcv, wutlcv, p2utlcv)
        `binning(UA1CV_i, ua1cv, lua1cv, nua1cv, pua1cv, wua1cv, p2ua1cv)
        `binning(UA2CV_i, ua2cv, lua2cv, nua2cv, pua2cv, wua2cv, p2ua2cv)
        `binning(UD1CV_i, ud1cv, lud1cv, nud1cv, pud1cv, wud1cv, p2ud1cv)
        `binning(UD2CV_i, ud2cv, lud2cv, nud2cv, pud2cv, wud2cv, p2ud2cv)
        if (bulkmod != 0) begin
            `binning(UCCV_i, uccv, luccv, nuccv, puccv, wuccv, p2uccv)
            `binning(UC1CV_i, uc1cv, luc1cv, nuc1cv, puc1cv, wuc1cv, p2uc1cv)
        end
        `binning(ETA0CV_i, eta0cv, leta0cv, neta0cv, peta0cv, weta0cv, p2eta0cv)
        `nfin_scaling(ETA0CV_i, eta0n1cv, eta0n2cv)
        if (nfinnom != 0.0) begin
            `nfinnom_scaling(U0CV_i, u0ltcv)
            `nfinnom_scaling(ETA0CV_i, eta0ltcv)
        end
    end
    if (nqsmod != 0 && xrcrg1 != 0.0) begin
        `binning(XRCRG1_i, xrcrg1, lxrcrg1, nxrcrg1, pxrcrg1, wxrcrg1, p2xrcrg1)
        `binning(XRCRG2_i, xrcrg2, lxrcrg2, nxrcrg2, pxrcrg2, wxrcrg2, p2xrcrg2)
    end
    if (subbandmod == 1) begin
        `binning(DIMENSION1_i, dimension1, ldimension1, ndimension1, pdimension1, wdimension1, p2dimension1)
        `binning(DIMENSION2_i, dimension2, ldimension2, ndimension2, pdimension2, wdimension2, p2dimension2)
        `binning(DIMENSION3_i, dimension3, ldimension3, ndimension3, pdimension3, wdimension3, p2dimension3)
        `binning(SSP1_i, ssp1, lssp1, nssp1, pssp1, wssp1, p2ssp1)
        `binning(SSP2_i, ssp2, lssp2, nssp2, pssp2, wssp2, p2ssp2)
        `binning(SSP3_i, ssp3, lssp3, nssp3, pssp3, wssp3, p2ssp3)
        `binning(E2NOM_i, e2nom, le2nom, ne2nom, pe2nom, we2nom, p2e2nom)
        `binning(E3NOM_i, e3nom, le3nom, ne3nom, pe3nom, we3nom, p2e3nom)
        `binning(MFQ1NOM_i, mfq1nom, lmfq1nom, nmfq1nom, pmfq1nom, wmfq1nom, p2mfq1nom)
        `binning(MFQ2NOM_i, mfq2nom, lmfq2nom, nmfq2nom, pmfq2nom, wmfq2nom, p2mfq2nom)
        `binning(MFQ3NOM_i, mfq3nom, lmfq3nom, nmfq3nom, pmfq3nom, wmfq3nom, p2mfq3nom)
    end

    // nfin scaling
    `nfin_scaling(PHIG_i, phign1, phign2)
    `nfin_scaling(ETA0_i, eta0n1, eta0n2)
    `nfin_scaling(CDSC_i, cdscn1, cdscn2)
    `nfin_scaling(CDSCD_i, cdscdn1, cdscdn2)
    `nfin_scaling(CDSCDR_i, cdscdrn1, cdscdrn2)
    `nfin_scaling(VSAT_i, vsatn1, vsatn2)
    `nfin_scaling(VSAT1_i, vsat1n1, vsat1n2)
    `nfin_scaling(VSAT1R_i, vsat1rn1, vsat1rn2)
    `nfin_scaling(U0_i, u0n1, u0n2)
    `nfin_scaling(U0R_i, u0n1r, u0n2r)
    if (nfinnom != 0.0) begin
        `nfinnom_scaling(PHIG_i, phiglt)
        `nfinnom_scaling(ETA0_i, eta0lt)
        `nfinnom_scaling(U0_i, u0lt)
    end

    // Length scaling
    Leff_ln = ln(Leff);
    PHIG_i = PHIG_i + phigl * Leff;
    PQM_i= PQM_i + pqml * Leff;
    if (lpa > 0.0) begin
        U0_i = U0_i * (1.0 - UP_i * exp(-lpa * Leff_ln));
    end else begin
        U0_i = U0_i * (1.0 - UP_i);
    end
    `length_scaling(UA_i, aua, bua)
    `length_scaling(UD_i, aud, bud)
    `length_scaling(EU_i, aeu, beu)
    if (asymmod != 0) begin
        `length_scaling(UAR_i, auar, buar)
        `length_scaling(UDR_i, audr, budr)
        `length_scaling(EUR_i, aeur, beur)
        if (lpar > 0.0) begin
            U0R_i = U0R_i * (1.0 - UPR_i * exp(-lpar * Leff_ln));
        end else begin
            U0R_i = U0R_i * (1.0 - UPR_i);
        end
    end
    if (rdsmod == 1) begin
        `length_scaling(RSW_i, arsw, brsw)
        `length_scaling(RDW_i, ardw, brdw)
    end else begin
        `length_scaling(RDSW_i, ardsw, brdsw)
    end
    `length_scaling(PCLM_i, apclm, bpclm)
    if (asymmod != 0) begin
        PCLMR_i = PCLMR_i + apclmr * exp(-bpclmr * Leff_ln);
    end
    MEXP_i = MEXP_i + amexp * exp(-bmexp * Leff_ln);
    if (asymmod != 0) begin
        MEXPR_i = MEXPR_i + amexpr * exp(-bmexpr * Leff_ln);
    end
    `length_scaling(PTWG_i, aptwg, bptwg)
    if (asymmod != 0) begin
        `length_scaling(PTWGR_i, aptwg, bptwg)
    end
    `length_scaling(VSAT_i, avsat, bvsat)
    `length_scaling(VSAT1_i, avsat1, bvsat1)
    if (asymmod != 0) begin
        `length_scaling(VSAT1R_i, avsat1, bvsat1)
    end
    `length_scaling(PSAT_i, apsat, bpsat)
    `length_scaling_CV(PSATCV_i, apsatcv, bpsatcv)
    `length_scaling_CV(VSATCV_i, avsatcv, bvsatcv)
    DVTP0_i = DVTP0_i + advtp0 * lexp(-Leff / bdvtp0);
    DVTP1_i = DVTP1_i + advtp1 * lexp(-Leff / bdvtp1);
    // Geometric scaling for Toxeff / charge centroid Tcen
    if (QMTCENCV_i > 0.0 || QMTCENCVA_i > 0.0) begin
        MTcen = 1.0 + aqmtcen * lexp(-(2.0 * Ach / Weff_UFCM) / bqmtcen);
        Tcen0 = (2.0 * Ach / Weff_UFCM) * MTcen;
    end

    // Parameter checking
// ---- begin `include "bsimcmg_checking.include" ----
// *  BSIM-CMG 112.1.0 released on 04/28/2026                            *
// *  BSIM Common Multi-Gate Model (Verilog-A)                                *
// ****************************************************************************

// ****************************************************************************
// *  Copyright © 2026 University of California                               *
// *                                                                          *
// *  Project director: Prof. Sayeef Salahuddin                               *
// *                    Prof. Chenming Hu                                     *
// *                                                                          *
// *  Developers: https://www.bsim.berkeley.edu/models/bsimcmg/auth_cmg/      *
// ****************************************************************************

// Parameter checking

if (Weff0 <= 1.0e-9) begin
    $strobe("Warning: Weff0 = %g <= 1.0e-9.", Weff0);
end

if (WeffCV0 <= 1.0e-9) begin
    $strobe("Warning: WeffCV0 = %g <= 1.0e-9.", WeffCV0);
end

if (QSREF_i <= 0.0) begin
    $error("Fatal: Effective  qsref = %g is not positive.", QSREF_i);
    QSREF_i = 50e-3;
end

if (NGATE_i < 0.0) begin
    $error("Fatal: Effective  ngate = %g is negative.", NGATE_i);
    NGATE_i = 0.0;
end else if (NGATE_i != 0.0 && NGATE_i <= 1.0e24) begin
    $strobe("Warning: Effective  ngate = %g may be too small.", NGATE_i);
end else if (NGATE_i > 1.0e31) begin
    $error("Fatal: Effective  ngate = %g is too high.", NGATE_i);
    NGATE_i = 0.0;
end

if (DVT0_i < 0.0) begin
    $strobe("Warning: Effective  dvt0 = %g is negative.", DVT0_i);
end

if (PHIG_i <= 0.0) begin
    $error("Fatal: Effective phig = %g is not positive.", PHIG_i);
    PHIG_i = 4.61;
end

if (bulkmod != 0) begin
    if (K1_i < 1.0e-6) begin
        $error("Fatal: Effective K1 = %g is less than 1.0e-6.", K1_i);
        K1_i = 1.0e-6;
    end
end

if (SPRT_i < 0.0) begin
    $error("Fatal: Effective SPRT = %g is less than 1.0e-2.", SPRT_i);
    SPRT_i = 1.0e-2;
end

if (QSREF_i < 0.0) begin
    $error("Fatal: Effective QSREF = %g is negative.", QSREF_i);
    QSREF_i = 50e-3;
end

if (NOIA2_i < 0.0) begin
    $error("Fatal: Effective NOIA2 = %g is negative.", NOIA2_i);
    NOIA2_i = noia;
end

if (MPOWER_i < 0.0) begin
    $error("Fatal: Effective MPOWER = %g is negative.", MPOWER_i);
    MPOWER_i = 1.2;
end

if (COVS_i < 0.0) begin
    $error("Fatal: Effective covs = %g is negative.", COVS_i);
    COVS_i = 0.0;
end

if (COVD_i < 0.0) begin
    $error("Fatal: Effective covd = %g is negative.", COVD_i);
    COVD_i = 0.0;
end

if (VSAT_i <= 0.0) begin
    $error("Fatal: Effective vsat = %g is not positive.", VSAT_i);
    VSAT_i = 8.5e4;
end

if (VSAT1_i <= 0.0) begin
    $error("Fatal: Effective vsat1 = %g is not positive.", VSAT1_i);
    VSAT1_i = 8.5e4;
end

if (asymmod != 0 && VSAT1R_i <= 0.0) begin
    $error("Fatal: Effective vsat1r = %g is not positive.", VSAT1R_i);
    VSAT1R_i = 8.5e4;
end

if (DVT1_i <= 0.0) begin
    $error("Fatal: Effective dvt1 = %g is not positive.", DVT1_i);
    DVT1_i = 0.6;
end

if (DVT1SS_i <= 0.0) begin
    $error("Fatal: Effective dvt1ss = %g is not positive.", DVT1SS_i);
    DVT1SS_i = 0.6;
end

if (CDSC_i < 0.0) begin
    $strobe("Warning: Effective cdsc = %g is negative.", CDSC_i);
end

if (CDSCD_i < 0.0) begin
    $strobe("Warning: Effective cdscd = %g is negative.", CDSCD_i);
end

if (asymmod != 0 && CDSCDR_i < 0.0) begin
    $strobe("Warning: Effective cdscdr = %g is negative.", CDSCDR_i);
end

if (DSUB_i <= 0.0) begin
    $error("Fatal: Effective dsub = %g is not positive.", DSUB_i);
    DSUB_i = 1.06;
end

if (ETA0_i < 0.0) begin
    $strobe("Warning: Effective eta0 = %g is negative, setting it to 0", ETA0_i);
    ETA0_i = 0.0;
end

if (ETA0R_i < 0.0) begin
    $strobe("Warning: Effective eta0r = %g is negative, setting it to 0", ETA0R_i);
    ETA0R_i = 0.0;
end

if (LPE0_i < -Leff) begin
    $strobe("Warning: Effective lpe0 = %g is less than -Leff. Clipping LPE0_i to 0", LPE0_i);
    LPE0_i = 0.0;
end

if (K0SI_i < 0.0) begin
    $strobe("Warning: Effective k0si = %g is negative, setting it to 0.", K0SI_i);
    K0SI_i = 0.0;
end

if (K2SI_i < 0.0) begin
    $strobe("Warning: Effective k2si = %g is negative, setting it to 0.", K2SI_i);
    K2SI_i = 0.0;
end

if (bulkmod != 0 && PHIBE_i < 0.2) begin
    $strobe("Warning: Effective phibe = %g is less than 0.2, setting it to 0.2.", PHIBE_i);
    PHIBE_i = 0.2;
end

if (bulkmod != 0 && PHIBE_i > 1.2) begin
    $strobe("Warning: Effective phibe = %g is larger than 1.2, setting it to 1.2.", PHIBE_i);
    PHIBE_i = 1.2;
end

if (PSAT_i < 2.0) begin
    $strobe("Warning: Effective psat = %g is less than 2.0, setting it to 2.0.", PSAT_i);
    PSAT_i = 2.0;
end

if (PSATCV_i < 2.0) begin
    $strobe("Warning: Effective psatcv = %g is less than 2.0, setting it to 2.0.", PSATCV_i);
    PSATCV_i = 2.0;
end

if (U0_i < 0.0) begin
    $strobe("Warning: Effective u0 = %g is negative, setting it to the default value.", U0_i);
    U0_i = 0.03;
end

if (UA_i < 0.0) begin
    $strobe("Warning: Effective ua = %g is negative, setting it to 0.", UA_i);
    UA_i = 0.0;
end

if (EU_i < 0.0) begin
    $strobe("Warning: Effective eu = %g is negative, setting it to 0.", EU_i);
    EU_i = 0.0;
end

if (UD_i < 0.0) begin
    $strobe("Warning: Effective ud = %g is negative, setting it to 0.", UD_i);
    UD_i = 0.0;
end

if (UCS_i < 0.0) begin
    $strobe("Warning: Effective ucs = %g is negative, setting it to 0.", UCS_i);
    UCS_i = 0.0;
end

if (ETAMOB_i < 0.0) begin
    $strobe("Warning: Effective etamob = %g is negative, setting it to 0", ETAMOB_i);
    ETAMOB_i = 0.0;
end

if (RDSW_i < 0.0) begin
    $strobe("Warning: Effective rdsw = %g is negative, setting it to 0", RDSW_i);
    RDSW_i = 0.0;
end

if (RSW_i < 0.0) begin
    $strobe("Warning: Effective rsw = %g is negative, setting it to 0", RSW_i);
    RSW_i = 0.0;
end

if (RDW_i < 0.0) begin
    $strobe("Warning: Effective rdw = %g is negative, setting it to 0", RDW_i);
    RDW_i = 0.0;
end

if (PRWGD_i < 0.0) begin
    $strobe("Warning: Effective prwgd = %g is negative, setting it to 0", PRWGD_i);
    PRWGD_i = 0.0;
end

if (PRWGS_i < 0.0) begin
    $strobe("Warning: Effective prwgs = %g is negative, setting it to 0", PRWGS_i);
    PRWGS_i = 0.0;
end

if (PCLM_i < 0.0) begin
    $strobe("Warning: Effective pclm = %g is negative.", PCLM_i);
end

if (PDIBL1_i < 0.0) begin
    $strobe("Warning: Effective pdibl1 = %g is negative.", PDIBL1_i);
end

if (asymmod != 0) begin
    if (PDIBL1R_i < 0.0) begin
        $strobe("Warning: Effective pdibl1r = %g is negative.", PDIBL1R_i);
    end
    if (PDIBL2R_i < 0.0) begin
        $strobe("Warning: Effective pdibl2r = %g is negative.", PDIBL2R_i);
    end
    if (U0R_i < 0) begin
        $strobe("Warning: Effective u0r = %g is negative, setting it to 0.", U0R_i);
        U0R_i = 0.0;
    end
    if (UAR_i < 0.0) begin
        $strobe("Warning: Effective uar = %g is negative, setting it to 0.", UAR_i);
        UAR_i = 0.0;
    end
    if (EUR_i < 0.0) begin
        $strobe("Warning: Effective eur = %g is negative, setting it to 0.", EUR_i);
        EUR_i = 0.0;
    end
    if (UDR_i < 0.0) begin
        $strobe("Warning: Effective udr = %g is negative, setting it to 0.", UDR_i);
        UDR_i = 0.0;
    end
end

if (PDIBL2_i < 0.0) begin
    $strobe("Warning: Effective pdibl2 = %g is negative.", PDIBL2_i);
end

if (DROUT_i <= 0.0) begin
    $error("Fatal: Effective drout = %g is non-positive.", DROUT_i);
    DROUT_i = 1.06;
end

if (MEXP_i < 2.0) begin
    $strobe("Warning: Effective mexp = %g < 2. Setting MEXP_i = 2.", MEXP_i);
    MEXP_i = 2.0;
end

if (asymmod != 0) begin
    if (MEXPR_i < 2.0) begin
        $strobe("Warning: Effective mexpr = %g < 2. Setting MEXPR_i = 2.", MEXPR_i);
        MEXPR_i = 2.0;
    end
end

if (PTWG_i < 0.0) begin
    $strobe("Warning: Effective ptwg = %g is negative, setting it to 0.", PTWG_i);
    PTWG_i = 0.0;
end

if (CGIDL_i < 0.0) begin
    $strobe("Warning: Effective cgidl = %g < 0. Setting CGIDL_i = 0.", CGIDL_i);
    CGIDL_i = 0.0;
end

if (CGISL_i < 0.0) begin
    $strobe("Warning: Effective cgisl = %g < 0. Setting CGISL_i = 0.", CGISL_i);
    CGISL_i = 0.0;
end

if (igbmod != 0) begin
    if (NIGBINV_i <= 0.0) begin
        $error("Fatal: Effective nigbinv = %g is non-positive.", NIGBINV_i);
        NIGBINV_i = 3.0;
    end
    if (NIGBACC_i <= 0.0) begin
        $error("Fatal: Effective nigbacc = %g is non-positive.", NIGBACC_i);
        NIGBACC_i = 1.0;
    end
end

if (igcmod != 0) begin
    if (POXEDGE_i <= 0.0) begin
        $error("Fatal: Effective poxedge = %g is non-positive.", POXEDGE_i);
        POXEDGE_i = 1.0;
    end
    if (PIGCD_i <= 0.0) begin
        $error("Fatal: Effective pigcd = %g is non-positive.", PIGCD_i);
        PIGCD_i = 1.0;
    end
end

if (igcmod != 0 || igbmod != 0) begin
    if (toxref <= 0.0) begin
        $error("Fatal: toxref = %g is non-positive.", toxref);
    end
end

if (lintigen >= (Leff / 2.0)) begin
    $strobe("Warning: lintigen = %g is too large - Leff for r/g current is negative. Re-setting lintigen = 0.", lintigen);
    LINTIGEN_i = 0.0;
end else begin
    LINTIGEN_i = lintigen;
end

if (NTGEN_i <= 0.0) begin
    $error("Fatal: Effective ntgen = %g is non-positive.", NTGEN_i);
    NTGEN_i = 1.0;
end

if (nqsmod == 1 && XRCRG1_i != 0.0) begin
    if (XRCRG1_i < 1.0e-3) begin
        $strobe("Warning: Effective xrcrg1 = %g. Gate resistance may be too large. Disabling NQS Gate Resistance.", XRCRG1_i);
        XRCRG1_i = 0.0;
    end
end

if (iimod == 2) begin
    if (BETAII0_i < 0.0) begin
        $strobe("Warning: Effective betaii0 = %g is negative.", BETAII0_i);
    end
    if (BETAII1_i < 0.0) begin
        $strobe("Warning: Effective betaii1 = %g is negative.", BETAII1_i);
    end
    if (BETAII2_i < 0.0) begin
        $strobe("Warning: Effective betaii2 = %g is negative.", BETAII2_i);
    end
    if (ESATII_i < 0.0) begin
        $strobe("Warning: Effective esatii = %g is negative.", ESATII_i);
    end
    if (LII_i < 0.0) begin
        $strobe("Warning: Effective lii = %g is negative.", LII_i);
    end
    if (SII1_i < 0.0) begin
        $strobe("Warning: Effective sii1 = %g is negative.", sii1);
    end
    if (SII2_i < 0.0) begin
        $strobe("Warning: Effective sii2 = %g is negative.", SII2_i);
    end
    if (SIID_i < 0.0) begin
        $strobe("Warning: Effective siid = %g is negative.", SIID_i);
    end
end

if (ef <= 0.0) begin
    $error("Fatal: ef = %g is non-positive.", ef);
    ef_v = 1.0;
end else if (ef > 2.0) begin
    $error("Fatal: ef = %g > 2.0.", ef);
    ef_v = 1.0;
end

if (CGSL_i < 0.0) begin
    $strobe("Warning: Effective cgsl = %g is negative. Setting it to 0 ", CGSL_i);
    CGSL_i = 0.0;
end

if (CGDL_i < 0.0) begin
    $strobe("Warning: Effective cgdl = %g is negative. Setting it to 0 ", CGDL_i);
    CGDL_i = 0.0;
end

if (CFS_i < 0.0) begin
    $strobe("Warning: Effective cfs = %g is negative. Setting it to 0 ", CFS_i);
    CFS_i = 0.0;
end

if (CFD_i < 0.0) begin
    $strobe("Warning: Effective cfd = %g is negative. Setting it to 0 ", CFD_i);
    CFD_i = 0.0;
end

if (CGBL_i < 0.0) begin
    $strobe("Warning: Effective cgbl = %g is negative. Setting it to 0 ", CGBL_i);
    CGBL_i = 0.0;
end

if (CKAPPAS_i <= 0.02) begin
    $strobe("Warning: Effective ckappas = %g is too small. Setting it to 0.02 ", CKAPPAS_i);
    CKAPPAS_i = 0.02;
end

if (CKAPPAD_i <= 0.02) begin
    $strobe("Warning: Effective ckappad = %g is too small. Setting it to 0.02 ", CKAPPAD_i);
    CKAPPAD_i = 0.02;
end

if (CKAPPAB_i <= 0.02) begin
    $strobe("Warning: Effective ckappab = %g is too small. Setting it to 0.02 ", CKAPPAB_i);
    CKAPPAB_i = 0.02;
end

if (deltaprsd_v < -fpitch) begin
    $error("Fatal: The value of deltaprsd = %g is less than - %g (-fpitch).", deltaprsd , fpitch);
    deltaprsd_v = 0.0;
end

if (subbandmod == 1) begin
    if (DIMENSION1_i < 1.0 || DIMENSION1_i > 3.0) begin
        $error("Fatal: The effective value assigned to DIMENSION1 = %g does not lie between 1 and 3.", DIMENSION1_i);
        DIMENSION1_i = 2.0;
    end
    if (DIMENSION2_i < 1.0 || DIMENSION2_i > 3.0) begin
        $error("Fatal: The effective value assigned to DIMENSION2 = %g does not lie between 1 and 3.", DIMENSION2_i);
        DIMENSION2_i = 2.6;
    end
    if (DIMENSION3_i < 1.0 || DIMENSION3_i > 3.0) begin
        $error("Fatal: The effective value assigned to DIMENSION3 = %g does not lie between 1 and 3.", DIMENSION3_i);
        DIMENSION3_i = 2.6;
    end
    if (SSP1_i < 0.0) begin
        $error("Fatal: Effective SSP1 = %g is non-positive.", SSP1_i);
        SSP1_i = 14;
    end
    if (SSP2_i < 0.0) begin
        $error("Fatal: Effective SSP2 = %g is non-positive.", SSP2_i);
        SSP2_i = 24;
    end
    if (SSP3_i < 0.0) begin
        $error("Fatal: Effective SSP3 = %g is non-positive.", SSP3_i);
        SSP3_i = 24;
    end
    if (E2NOM_i < 0.0) begin
        $error("Fatal: Effective E2NOM = %g is non-positive.", E2NOM_i);
        E2NOM_i = 0.139;
    end
    if (E3NOM_i < 0.0) begin
        $error("Fatal: Effective E3NOM = %g is non-positive.", E3NOM_i);
        E3NOM_i = 2;
    end
    if (MFQ1NOM_i < 0.0) begin
        $error("Fatal: Effective MFQ1NOM = %g is non-positive.", MFQ1NOM_i);
        MFQ1NOM_i = 11.2;
    end
    if (MFQ2NOM_i < 0.0) begin
        $error("Fatal: Effective MFQ2NOM = %g is non-positive.", MFQ2NOM_i);
        MFQ2NOM_i = 8.02;
    end
    if (MFQ3NOM_i < 0.0) begin
        $error("Fatal: Effective MFQ3NOM = %g is non-positive.", MFQ3NOM_i);
        MFQ3NOM_i = 6.18;
    end
end
// ---- end `include "bsimcmg_checking.include" ----

    // Self-heating
    if (shmod != 0 && rth0 > 0.0) begin
        if (bshexp != 0.0) begin
            T1 = wth0 * pow(nf, bshexp);
        end else begin
            T1 = wth0;
        end
        if (ashexp != 0.0) begin
            T2 = ash * fpitch * pow(NFINtotal, ashexp);
        end else begin
            T2 = ash * fpitch;
        end
        if (geomod == 5) begin
            if (cshexp != 0.0) begin
                T3 = csh * nf * wgaa * pow(ngaa, cshexp);
            end else begin
                T3 = csh * nf * wgaa;
            end
        end else begin
            T3 = 0;
        end
        gth = (T1 + T2 + T3) / rth0;
        cth = cth0 * (T1 + T2 + T3);
    end

    // Gate electrode resistance
    if (rgatemod != 0) begin
        Rgeltd = (rgext / ngcon + (rgfin * nfin) / (ngcon == 2 ? 12.0 : 3.0)) / nf;
        ggeltd = 1.0 / max(1.0e-3, Rgeltd);
        if (rgatemod == 2) begin
            ggint = 1.0 / max(1.0e-3, rgint);
            ggp = 1.0 / max(1.0e-3, rgp);
        end
    end

    // Geometry-dependent source/drain resistances
    if (rgeomod == 0) begin
        RSourceGeo = rshs * nrs;
        RDrainGeo = rshd * nrd;
    end else begin
        // Area and perimeter calculation
        if (hepi > 0.0) begin
            Arsd = fpitch * hfin + (tfin + (fpitch - tfin) * cratio) * hepi;
        end else begin
            Arsd = fpitch * max(1.0e-9, hfin + hepi);
        end
        Prsd = fpitch + deltaprsd_v;
        // Resistivity calculation
        if ($param_given(rhorsd)) begin
            rhorsd_v = rhorsd;
        end else begin
            mu_max = (type == `ntype) ? 1417.0 : 470.5;
            if (type == `ntype) begin
                T0 = pow((nsd / 9.68e22), 0.68);
                T1 = 3.43e26 / nsd;
                mu_rsd = (52.2 + (mu_max - 52.2) / (1.0 + T0) - 43.4 / (1.0 + T1 * T1)) * 1.0e-4;
            end else begin
                T0 = pow((nsd / 2.23e22), 0.719);
                T1 = 6.10e26 / nsd;
                mu_rsd = (44.9 + (mu_max - 44.9) / (1.0 + T0) - 29.0 / (1.0 + T1 * T1)) * 1.0e-4;
            end
            rhorsd_v = 1.0 / (`q * nsd * mu_rsd);
        end
        // Component: spreading resistance
        thetarsp = 55.0 * `M_PI / 180.0;
        afin = min(Arsd, max(1.0e-18, tfin * (hfin + min(0.0, hepi))));
        Rsp = rhorsd_v / tan(thetarsp) / (sqrt(`M_PI) * nfin) * (1.0 / sqrt(afin) - 2.0 / sqrt(Arsd) + sqrt(afin / (Arsd * Arsd)));
        // Component: contact resistance
        arsd_total = Arsd * nfin + arsdend;
        prsd_total = Prsd * nfin + prsdend;
        lt = sqrt(rhoc * arsd_total / (rhorsd_v * prsd_total));
        alpha = lrsd / lt;
        T0 = lexp(2.0 * alpha);
        if (sdterm == 1.0) begin
            eta = rhorsd_v * lt / rhoc;
            T1 = T0 * (1.0 + eta);
            T2 = T1 + 1.0 - eta;
            T3 = T1 - 1.0 + eta;
        end else begin
            T2 = T0 + 1.0;
            T3 = T0 - 1.0;
        end
        RrsdTML = rhorsd_v * lt * T2 / (arsd_total * T3);
        if (hepi < -1.0e-10) begin
            Rrsdside = rhoc / (-hepi * tfin * nfin);
            Rrsd = (RrsdTML + Rsp) * Rrsdside / ((RrsdTML + Rsp) + Rrsdside);
        end else begin
            Rrsd = RrsdTML + Rsp;
        end
        Rdsgeo = Rrsd / nf * max(0.0, rgeoa + rgeob * tfin + rgeoc * fpitch + rgeod * lrsd + rgeoe * hepi);
        RSourceGeo = Rdsgeo;
        RDrainGeo = Rdsgeo;
    end

    // Clamping of source/drain resistances
    if (rdsmod == 0) begin
        if (RSourceGeo < minr) begin
            RSourceGeo = 0;
        end
        if (RDrainGeo < minr) begin
            RDrainGeo = 0;
        end
    end else begin
        if (RSourceGeo <= minr) begin
            RSourceGeo = minr;
        end
        if (RDrainGeo <= minr) begin
            RDrainGeo = minr;
        end
    end
    if (cgeomod != 1) begin
        if ($param_given(cgso)) begin
            CGSO_i = cgso;
        end else begin
            if ($param_given(dlc) && dlc > 0.0) begin
                CGSO_i = max(0.0, dlc * cox - CGSL_i);
            end else begin
                if (cgeomod == 3) begin
                    CGSO_i = 0.3 * wgaa * cox;
                end else begin
                    CGSO_i = 0.3 * tfin * cox;
                end
            end
        end
        if ($param_given(cgdo)) begin
            CGDO_i = cgdo;
        end else begin
            if ($param_given(dlc) && dlc > 0.0) begin
                CGDO_i = max(0.0, dlc * cox - CGDL_i);
            end else begin
                if (cgeomod == 3) begin
                    CGDO_i = 0.3 * wgaa * cox;
                end else begin
                    CGDO_i = 0.3 * tfin * cox;
                end
            end
        end
    end

    // Parasitic source/drain-to-gate fringe capacitance
    if (cgeomod == 2) begin
        Hg = tgate + tmask;
        Trsd = 0.5 * (fpitch - tfin);
        Wg = max(0.0, Trsd - toxp);
        Hrsd = max(0.0, hepi + tsili);
        // Top component
        if (tmask > 0.0) begin
            T0 = 3.467e-11 * llnf(1.0e-7 * epsrsp / (3.9 * lsp));
            T1 = 0.942 * Hrsd * epssp / lsp;
            Cgg_top = (T0 + T1) * (tfin + (fpitch - tfin) * cratio);
        end else begin
            `cfringe_2d(Hg, Hrsd, tfin, 0.85, Cgg_top)
        end
        // Side component
        if (tmask > 0.0) begin
            `cfringe_2d(Wg, Trsd, hfin, 0.70, Cgg_side)
        end else begin
            `cfringe_2d(Wg, Trsd, hfin, 0.85, Cgg_side)
        end
        // Corner component
        if (tmask > 0.0) begin
            Acorner = 0.0;
        end else begin
            if (hepi > 0.0) begin
                Acorner = (fpitch - tfin) * (hepi * cratio + tsili);
            end else begin
                Acorner = (fpitch - tfin) * Hrsd;
            end
        end
        Ccorner = (nfin * Acorner + arsdend + asiliend) * epssp / lsp;
        Cfr_geo = (Ccorner + Cgg_top * nfin + cgeoe * Cgg_side * nfin * 2.0) * nf;
        Cfr_geo = Cfr_geo * max(0.0, cgeoa + cgeob * tfin + cgeoc * fpitch + cgeod * lrsd);
    end
    //Gate-All-Around FET fringe capacitance model
    if (cgeomod == 3) begin
        Hg = tgate + tmask;
        Trsd = 0.5 * (fpitch - wgaa);
        Wg = max(0.0, Trsd - toxp);
        Hrsd = max(0.0, hepi + tsili);
        Hrsd2 = 0.5 * tsus;
        // Topmost component: topmost GAA body
        if (tmask > 0.0) begin
            T0 = 3.467e-11 * llnf(1.0e-7 * epsrsp / (3.9 * lsp));
            T1 = 0.942 * Hrsd * epssp / lsp;
            Cgg_topm = (T0 + T1) * (wgaa + (fpitch - wgaa) * cratio);
        end else begin
            `cfringe_2d(Hg, Hrsd, wgaa, 0.85, Cgg_topm)
        end
        // Top or bottom component: intermeditate GAA bodies
        `cfringe_2d(tgate, Hrsd2, wgaa, 0.85, Cgg_tb)
        // Topmost side component
        if (tmask > 0.0) begin
            `cfringe_2d(Wg, Trsd, tgaa, 0.70, Cgg_sidetopm)
        end else begin
            `cfringe_2d(Wg, Trsd, tgaa, 0.85, Cgg_sidetopm)
        end
        // Intermediate side component
        `cfringe_2d(Wg, Trsd, tgaa, 0.85, Cgg_sidetb)
        // Parasitic FinFET side component
        `cfringe_2d(Wg, Trsd, hpff, 0.85, Cgg_sidepff)
        // Topmost corner component
        if (tmask > 0.0) begin
            Acorner_topm  =  0.0;
        end else begin
            if (hepi > 0.0) begin
                Acorner_topm = (fpitch - wgaa) * (hepi * cratio + tsili);
            end else begin
                Acorner_topm = (fpitch - wgaa) * Hrsd;
            end
        end
        // Intermediate corner component
        Acorner_tb = (fpitch - wgaa) * Hrsd2;
        Ccorner = (nfin * (Acorner_topm + 2 * ngaa * Acorner_tb) + arsdend + asiliend) * epssp / lsp;
        Cfr_geo = (Ccorner + (Cgg_topm + 2 * ngaa * Cgg_tb) * nfin + cgeoe * (Cgg_sidetopm + Cgg_sidetb * (ngaa - 1) + Cgg_sidepff) * nfin * 2.0) * nf;
        Cfr_geo = Cfr_geo * max(0.0, cgeoa + cgeob * wgaa + cgeoc * fpitch + cgeod * lrsd);
    end
    // Source/gate/drain-to-substrate parasitic capacitances
    T0 = csdesw * llnf(1.0 + hfin / eotbox);
    csbox = cbox * aseo + T0 * max(0.0, pseo - fpitch * NFINtotal);
    cdbox = cbox * adeo + T0 * max(0.0, pdeo - fpitch * NFINtotal);
    if (geomod != 5) begin
        cgbox = (cgbo * nf * ngcon + cgbn * NFINtotal) * Lg;
    end else begin
        cgbox = (cgbo * nf * ngcon + (cgbn + cgbw * WGAAeff) * NFINtotal) * Lg;
    end

    // Mobility degradation
    EeffFactor = 1.0e-8 / (epsratio * eot);
    WeffWRFactor = 1.0 / (NFINtotal * pow((Weff0 * 1.0e6), WR_i));
    litl = sqrt(epsratio * eot * 0.5 * tfin);
    scl = sqrt((epssub * Ach / Cins) * (1.0 + Ach * Cins / (2.0 * epssub * Weff_UFCM * Weff_UFCM)));
    if (!$param_given(thetasce)) begin
        tmp = DVT1_i * Leff / scl + 1.0e-6;
        if (tmp < 40.0) begin
            Theta_SCE = 0.5 / (cosh(tmp) - 1.0);
        end else begin
            Theta_SCE = lexp(-tmp);
        end
    end else begin
        Theta_SCE = thetasce;
    end
    if (!$param_given(thetasw)) begin
        tmp = DVT1SS_i * Leff / scl + 1.0e-6;
        if (tmp < 40.0) begin
            Theta_SW = 0.5 / (cosh(tmp) - 1.0);
        end else begin
            Theta_SW = lexp(-tmp);
        end
    end else begin
        Theta_SW = thetasw;
    end
    if (!$param_given(thetadibl)) begin
        tmp = DSUB_i * Leff / scl + 1.0e-6;
        if (tmp < 40.0) begin
            Theta_DIBL = 0.5 / (cosh(tmp) - 1.0);
        end else begin
            Theta_DIBL = lexp(-tmp);
        end
    end else begin
        Theta_DIBL = thetadibl;
    end
    Theta_RSCE = sqrt(1.0 + LPE0_i / Leff) - 1.0;
    tmp = DSUB_i * Leff / scl + 1.0e-6;
    if (tmp < 40.0) begin
        Theta_DITS = 1.0 / max((1.0 + dvtp2 * (cosh(tmp) - 2.0)), 1.0e-6);
    end else begin
        Theta_DITS = lexp(-tmp) / max((dvtp2 + lexp(-tmp)), 1.0e-6);
    end
    qbs = `q * NBODY_i * Ach / Cins;

    // Gate current
    if (type == `ntype) begin
        Aechvb = 4.97232e-7;
        Bechvb = 7.45669e11;
    end else begin
        Aechvb = 3.42537e-7;
        Bechvb = 1.16645e12;
    end
    T0 = toxg * toxg;
    T1 = toxg * POXEDGE_i;
    T2 = T1 * T1;
    Toxratio = pow((toxref / toxg), NTOX_i) / T0;
    Toxratioedge = pow((toxref / T1), NTOX_i) / T2;
    igsd_mult0 = Weff0 * Aechvb * Toxratioedge;
    if (tnom < -`P_CELSIUS0) begin
        $strobe("Warning: (tnom = %g) < -`P_CELSIUS0. Set to 27 C.", tnom);
        Tnom = `REFTEMP;
    end else begin
        Tnom = tnom + `CONSTCtoK;
    end

    //Gate-All-Around (GAA) FET quantum subband model: Geometry dependent calculations
    // (Ref: A. Dasgupta et.al., IEEE TED, vol. 67, no. 2, 2020.)
    if (subbandmod == 1) begin
        //Dimension scaling
        d1 = (dim1h - DIMENSION1_i) / (1 + lexp((wdim0 * 1e9 - wgaa * 1e9) / wdimr)) + DIMENSION1_i;
        d2 = (dim2h - DIMENSION2_i) / (1 + lexp((wdim0 * 1e9 - wgaa * 1e9) / wdimr)) + DIMENSION2_i;
        d3 = (dim3h - DIMENSION3_i) / (1 + lexp((wdim0 * 1e9 - wgaa * 1e9) / wdimr)) + DIMENSION3_i;
        p1 = smoothminx(-dssp1 / (1 + lexp((wssp0 * 1e9 - wgaa * 1e9) / wsspr)) + SSP1_i, 0.0, 0.001);
        p2 = smoothminx(-dssp2 / (1 + lexp((wssp0 * 1e9 - wgaa * 1e9) / wsspr)) + SSP2_i, 0.0, 0.001);
        p3 = smoothminx(-dssp3 / (1 + lexp((wssp0 * 1e9 - wgaa * 1e9) / wsspr)) + SSP3_i, 0.0, 0.001);

        //Effect of dimension on capacitance normalizations
        Wp1 = smoothmaxx(smoothminx(1.001 * (d1 - 1.001), 0, 0.001), 1, 0.001);
        Tp1 = smoothmaxx(smoothminx(1.001 * (d1 - 2.001), 0, 0.001), 1, 0.001);
        Wp2 = smoothmaxx(smoothminx(1.001 * (d2 - 1.001), 0, 0.001), 1, 0.001);
        Tp2 = smoothmaxx(smoothminx(1.001 * (d2 - 2.001), 0, 0.001), 1, 0.001);
        Wp3 = smoothmaxx(smoothminx(1.001 * (d3 - 1.001), 0, 0.001), 1, 0.001);
        Tp3 = smoothmaxx(smoothminx(1.001 * (d3 - 2.001), 0, 0.001), 1, 0.001);
        VnD1 = pow(Weff0, Wp1) * pow(Ach / Weff0, Tp1);
        qndnf1 = VnD1 / Cins;
        VnD2 = pow(Weff0, Wp2) * pow(Ach / Weff0, Tp2);
        qndnf2 = VnD2 / Cins;
        VnD3 = pow(Weff0, Wp3) * pow(Ach / Weff0, Tp3);
        qndnf3 = VnD3 / Cins;

        nc3d0 = smoothminx(1 / (1 + lexp((2.75 - tgaa * 1e9) / 0.78)), 0.5, 0.003);
        nc3d = (1 - nc3d0) * (d1 - DIMENSION1_i) / (dim1h - DIMENSION1_i) + nc3d0;
        ncq = 1 / (1 + lexp((nc3d - 0.999) / 1e-4));
        //tgaa scaling model for subband energies
        QT0= 0.5 * tgaa * tgaa * 1e18 - 1.5 * tgaa * 1e9 + 2;
        QT1= smoothmaxx(QT0, 4, 0.01);
        ne2h = smoothmaxx(smoothminx(T0 + pow(tgaa * 1e9 - QT1, tsre2) * (9.24e5 - 1.81e4) / pow(2, tsre2) , 1.81e4, 0.01), 9.24e5, 9.24e3);
        pe2h = smoothmaxx(smoothminx(5.5 + pow(tgaa * 1e9 - QT1, tdwse2) * (8 - 5.5) / pow(2, tdwse2), 0, 0.01), 8, 0.01);
        ne3h = (120.66 * pow(4, tsre3)) / pow(tgaa * 1e9, tsre3);
        pe3h = 2 * pow(4, tdwse3) / pow(tgaa * 1e9, tdwse3);
        //tgaa scaling model for subband contributions
        nc1l0 = 107 * pow(4, tsrq1) / pow(tgaa * 1e9, tsrq1);
        pnc1l = smoothmaxx(smoothminx(0.7 + pow(tgaa * 1e9 - QT1, tdwsq1) * 0.1, 0.5, 0.01), 1, 0.01);
        nc2l0 = 103 * pow(4, tsrq2) / pow(tgaa * 1e9, tsrq2);
        pnc2l = 1.5 * pow(4, tdwsq2) / pow(tgaa * 1e9, tdwsq2);
        nc3l0 = 833 * pow(4, tsrq3) / pow(tgaa * 1e9, tsrq3);
        pnc3l = 3.4 * pow(4, tdwsq3) / pow(tgaa * 1e9, tdwsq3);
        //wgaa scaling model for subband energies
        qe2n = ne2h / pow(wgaanom * 1e9, wsfe2 * pe2h);
        qe3n = ne3h / pow(wgaanom * 1e9, wsfe3 * pe3h);
        qe2 = smoothminx(E2NOM_i + mfe2 * (ne2h / pow(wgaa * 1e9, wsfe2 * pe2h)-qe2n), 0, 0.01);
        qe3 = smoothminx(E3NOM_i + mfe3 * (ne3h / pow(wgaa * 1e9, wsfe3 * pe3h)-qe3n), 0, 0.01);
        //wgaa scaling model for subband contributions
        nc1l = smoothminx(nc1l0 / pow(1 + 5 * pow(wgaa * 1e9, wsfq1 * pnc1l), 0.5), 0, 0.1);
        nc1ln = smoothminx(nc1l0 / pow(1 + 5 * pow(wgaanom * 1e9, wsfq1 * pnc1l), 0.5), 0, 0.1);
        nc1 = MFQ1NOM_i + mfq1 * (nc1l-nc1ln);
        nc2l = smoothminx(nc2l0 / pow(1 + 5 * pow(wgaa * 1e9, wsfq2 * pnc2l), 0.5), 0, 0.1);
        nc2ln = smoothminx(nc2l0 / pow(1 + 5 * pow(wgaanom * 1e9, wsfq2 * pnc2l), 0.5), 0, 0.1);
        nc2 = MFQ2NOM_i + mfq2 * (nc2l-nc2ln);
        nc3l = smoothminx(nc3l0 / pow(1 + 5 * pow(wgaa * 1e9, wsfq3 * pnc3l), 0.5), 0, 0.1);
        nc3ln = smoothminx(nc3l0 / pow(1 + 5 * pow(wgaanom * 1e9, wsfq3 * pnc3l), 0.5), 0, 0.1);
        nc3 = MFQ3NOM_i + mfq3 * (nc3l-nc3ln);
        //Pre-factors for charge
        qnd10 = `q * (d1 / 2) * (pow(3.14, d1 / 2) / gammafunc(1 + d1 / 2)) * pow(nc1 * 1e6, d1) * qndnf1;
        qnd20 = `q * (d2 / 2) * (pow(3.14, d2 / 2) / gammafunc(1 + d2 / 2)) * pow(nc2 * 1e6, d2) * qndnf2;
        qnd30 = `q * (d3 / 2) * (pow(3.14, d3 / 2) / gammafunc(1 + d3 / 2)) * pow(nc3 * 1e6, d3) * qndnf3;
    end

    // Geometry dependent mobility scaling
    // (Ref: A. Dasgupta et.al., IEEE EDL, vol. 41, no. 3, 2020.)
    if (mobscmod == 1) begin
        ETAMOB_i=etamobthin + (ETAMOB_i-etamobthin) / (lexp((etamobtni*1e9 - tgaa*1e9) / etamobir) + 1);

        mut0 =UA_i - uathin - uatsat*1e9*uartsc;
        mut1 = (mut0 + tgaa*1e9*uartsc )/ (1+lexp((uatni*1e9 - tgaa*1e9)/uair));
        UA_i = smoothmaxx2(mut1 + uathin, UA_i + 0.2, 0.6);

        mut2 = (euthin-EU_i)*370/pow(tgaa*1e9,euptsc) + (euthin-EU_i)/(1+lexp((tgaa*1e9-eutni*1e9)/euir)) + EU_i;
        EU_i = smoothmaxx2(mut2, euthin, 0.2);

        mut3 = wgaa/(wgaa + tgaa);
        mut4 = egbulk*tgaa*tgaa*1e18 - u0emsm1*1e-3;
        mut5 = (mut4 + pow(mut4*mut4 + 4*u0emsm1*1e-3*(egbulk+0.24)*tgaa*tgaa*1e18, 0.5))/(2*(egbulk+0.24)*tgaa*tgaa*1e18);
        mut6 = smoothmaxx2(1e-4/(mut5 - 0.8208 - u0emsm2*1e-5), 1, 0.06);
        U0_i = U0_i * (mut3 + u0etawsc * (1 - mut3)) * mut6;

        UD_i = (udthin-UD_i) * pow(smoothminx(udtsat*1e9-tgaa*1e9,0,1),udptsc) + UD_i;
    end

    // Temperature dependence calculations
    if (shmod != 0 && rth0 > 0.0) begin
        DevTemp = $temperature + Temp(t) + dtemp;
    end else begin
        DevTemp = $temperature + dtemp;
    end
    TRatio = DevTemp / Tnom;
    TRatio_m1 = TRatio - 1.0;
    delTemp = DevTemp - Tnom;
    Vtm = `KboQ * DevTemp;
    Vtm0 = `KboQ * Tnom;
    Tlow = tlow;
    if (cryomod != 0) begin
        // Effective temperature for core model charge calculation at low temperatures
        DevTemplow0 = smoothminx(DevTemp, Tlow, dtlow);
        DevTemplow1 = smoothminx((-klow1 * (DevTemp - tlow1)), 0.0, dtlow1);
        if (cryomod == 1) begin
            T1 = smoothminx(Tnom, Tlow, dtlow);
            T2 = smoothminx((-klow1 * (Tnom - tlow1)), 0.0, dtlow1);
            if (Tnom > Tlow) begin
                T3 = DevTemplow0 + DevTemplow1 - T1 - T2 + Tnom;
            end else begin
                T3 = DevTemplow0 + DevTemplow1 - T1 - T2 + Tlow;
            end
            DevTempeff = smoothminx(DevTemp, T3, 0.2);
        end else begin
            if (Tlow > 210) begin
                $strobe("Warning: tlow = %e is greater than 210 K. Set to 210 K", tlow);
                Tlow = 210;
            end
            wh = 0.5 + 0.5 * tanh(0.5 * (DevTemp - 210));
            wl = 1.0 - wh;
            if (Tnom > 210) begin
                T1 = smoothminx(210, Tlow, dtlow);
                T2 = smoothminx((-klow1 * (210 - tlow1)), 0.0, dtlow1);
                T3 = DevTemplow0 + DevTemplow1 - T1 - T2 + 210;
                DevTempeff = smoothminx(DevTemp, T3, 0.2);
            end else begin
                T1 = smoothminx(Tnom, Tlow, dtlow);
                T2 = smoothminx((-klow1 * (Tnom - tlow1)), 0.0, dtlow1);
                if (Tnom > Tlow) begin
                    T3 = DevTemplow0 + DevTemplow1 - T1 - T2 + Tnom;
                end else begin
                    T3 = DevTemplow0 + DevTemplow1 - T1 - T2 + Tlow;
                end
                T4 = smoothminx(DevTemp, T3, 0.2);
                DevTempeff = wl * T4 + wh * DevTemp;
            end
            DevTemp1 = smoothmaxx2(DevTemp, 210, 0.2);
            delTemp1 = DevTemp1 - smoothmaxx2(Tnom, 210, 0.2);
            delTRatio1 = (DevTemp1 - 210) / Tnom;
        end
        Vtmeff = `KboQ * DevTempeff;
    end
    Eg = bg0sub - tbgasub * DevTemp * DevTemp / (DevTemp + tbgbsub);
    Eg0 = bg0sub - tbgasub * Tnom * Tnom / (Tnom + tbgbsub);
    T1 = (DevTemp / 300.15) * sqrt(DevTemp / 300.15);
    ni = ni0sub * T1 * lexp(bg0sub / (2.0 * `KboQ * 300.15) - Eg / (2.0 * Vtm));
    if (cryomod == 0) begin
        Nc = nc0sub * T1;
    end else begin
        Nc = nc0sub * (DevTempeff / 300.15) * sqrt(DevTempeff / 300.15);
        niln = llnf(ni0sub * T1) + bg0sub / (2.0 * `KboQ * 300.15) - Eg / (2.0 * Vtm);
    end
    ThetaSS = hypsmooth((1.0 + TSS_i * delTemp - 1.0e-6), 1.0e-3);

    // Quantum mechanical Vth correction
    kT = Vtm * `q;
    T0 = `HBAR * `M_PI / (2.0 * Ach / Weff_UFCM);
    E0 = T0 * T0 / (2.0 * mx);
    E0prime = T0 * T0 / (2.0 * mxprime);
    E1 = 4.0 * E0;
    E1prime = 4.0 * E0prime;
    T1 = gprime * mdprime / (gfactor * md);
    gam0 = 1.0 + T1 * lexp((E0 - E0prime) / kT);
    gam1 = gam0 + lexp((E0 - E1) / kT) + T1 * lexp((E0 - E1prime) / kT);
    T2 = -Vtm * llnf(gfactor * md / (`M_PI * `HBAR * `HBAR * Nc) * kT / (2.0 * Ach / Weff_UFCM) * gam1);
    dvch_qm = QMFACTOR_i * (E0 / `q + T2);

    // Temperature dependence
    Trat_ln = ln(TRatio);
    if (cryomod == 0) begin
        T1 = U0_i * exp(UTE_i * Trat_ln);
        u0_v = T1 + hypmax(UTL_i * delTemp, -0.9 * T1, 1.0e-4);
        if (asymmod == 1) begin
            T1 = U0R_i * exp(UTER_i * Trat_ln);
            U0R_t = T1 + hypmax(UTLR_i * delTemp, -0.9 * T1, 1.0e-4);
            u0r_v = U0R_t;
        end
        UA_t = UA_i + hypmax(UA1_i * delTemp, -UA_i, 1.0e-6);
        EU_t = EU_i;
        if (asymmod != 0) begin
            UAR_t = UAR_i + hypmax(UA1R_i * delTemp, -UAR_i, 1.0e-6);
        end
        UD_t = UD_i * exp(UD1_i * Trat_ln);
        if (asymmod != 0) begin
            UDR_t = UDR_i * exp(UD1R_i * Trat_ln);
        end
        UCS_t = UCS_i * exp(UCSTE_i * Trat_ln);
        rdstemp = hypsmooth((1.0 + PRT_i * delTemp - 1.0e-6), 1.0e-3);
        `tempdep(VSAT_t, VSAT_i, -AT_i)
        if (asymmod != 0) begin
            `tempdep(VSATR_t, VSATR_i, -ATR_i)
            if (VSATR_t < 1000) begin
                VSATR_t = 1000;
            end
        end
        if (cvmod == 1) begin
            T1 = U0CV_i * exp(UTECV_i * Trat_ln);
            u0_cv = T1 + hypmax(UTLCV_i * delTemp, -0.9 * T1, 1.0e-4);
            UACV_t = UACV_i + hypmax(UA1CV_i * delTemp, -UACV_i, 1.0e-6);
            UDCV_t = UDCV_i * exp(UD1CV_i * Trat_ln);
        end
        `tempdep(VSAT1_t, VSAT1_i, -AT_i)
        if (asymmod != 0) begin
            `tempdep(VSAT1R_t, VSAT1R_i, -AT_i)
            if (VSAT1R_t < 1000) begin
                VSAT1R_t = 1000;
            end
        end
        `tempdep(VSATCV_t, VSATCV_i, -ATCV_i)
        MEXP_t = hypsmooth((MEXP_i * (1.0 + tmexp * delTemp) - 2.0), 1.0e-3) + 2.0;
        if (asymmod != 0) begin
            MEXPR_t = hypsmooth((MEXPR_i * (1.0 + tmexpr * delTemp) - 2.0), 1.0e-3) + 2.0;
        end
        KSATIV_t = KSATIV_i;
        PCLM_t = PCLM_i;
        dvth_temp = (KT1_i + kt1l / Leff) * TRatio_m1;
    end else if (cryomod == 1) begin
        T1 = U0_i * exp((UTE_i + UTE1_i * TRatio) * Trat_ln);
        u0_v = T1 + hypmax(UTL_i * delTemp, -0.9 * T1, 1.0e-4);
        if (asymmod == 1) begin
            T1 = U0R_i * exp((UTER_i + UTE1_i * TRatio) * Trat_ln);
            U0R_t = T1 + hypmax(UTLR_i * delTemp, -0.9 * T1, 1.0e-4);
            u0r_v = U0R_t;
        end
        UA_t = UA_i * exp((UA1_i + UA2_i * TRatio) * Trat_ln);
        if (asymmod != 0) begin
            UAR_t = UAR_i * exp((UA1R_i + UA2_i * TRatio) * Trat_ln);
        end
        UD_t = UD_i * exp((UD1_i + UD2_i * TRatio) * Trat_ln);
        if (asymmod != 0) begin
            UDR_t = UDR_i * exp((UD1R_i + UD2_i * TRatio) * Trat_ln);
        end
        UCS_t = UCS_i * exp((UCSTE_i + ucste1 * TRatio) * Trat_ln);
        UDS_t = UDS_i * (lexp(UDS1_i * TRatio_m1) - 1);
        UDD_t = UDD_i * (lexp(UDD1_i * TRatio_m1) - 1);
        UDSeff_t = 0.5 + UDS_t;
        UDDeff_t = 0.5 + UDD_t;
        `tempdep(EU_t, EU_i, EU1_i)
        if (cvmod == 1) begin
            T1 = U0CV_i * exp((UTECV_i + UTE1CV_i * TRatio) * Trat_ln);
            u0_cv = T1 + hypmax(UTLCV_i * delTemp, -0.9 * T1, 1.0e-4);
            UACV_t = UACV_i * exp((UA1CV_i + UA2CV_i * TRatio) * Trat_ln);
            UDCV_t = UDCV_i * exp((UD1CV_i + UD2CV_i * TRatio) * Trat_ln);
        end
        if (PRT_i == PRT1_i) begin
            T2 = 1.0 + PRT_i * delTemp;
        end else if (TR0_i < Tnom) begin
            rdstemp0 = 1 + PRT_i * delTemp;
            rdstemp1 = 1 + PRT1_i * (DevTemp - TR0_i) + PRT_i * (TR0_i - Tnom);
            T3 = (PRT_i - PRT1_i) * (TR0_i - Tnom);
            if (PRT1_i < PRT_i) begin
                T2 = smoothminx(rdstemp0, rdstemp1, SPRT_i) - smoothminx(T3, 0, SPRT_i);
            end else begin
                T2 = smoothmaxx2(rdstemp0, rdstemp1, SPRT_i) - smoothmaxx2(T3, 0, SPRT_i);
            end
        end else begin
            rdstemp1 = 1 + PRT1_i * (DevTemp - Tnom);
            rdstemp0 = 1 + PRT_i * (DevTemp - TR0_i) + PRT1_i * (TR0_i - Tnom);
            T3 = (PRT1_i - PRT_i) * (TR0_i - Tnom);
            if (PRT1_i < PRT_i) begin
                T2 = smoothminx(rdstemp1, rdstemp0, SPRT_i) - smoothminx(T3, 0, SPRT_i);
            end else begin
                T2 = smoothmaxx2(rdstemp1, rdstemp0, SPRT_i) - smoothmaxx2(T3, 0, SPRT_i);
            end
        end
        rdstemp = hypsmooth((T2 - 1.0e-6), 1.0e-3);
        `tempdep2(VSAT_t, VSAT_i, -AT_i, at2)
        if (asymmod != 0) begin
            `tempdep2(VSATR_t, VSATR_i, -ATR_i, at2)
            if (VSATR_t < 1000) begin
                VSATR_t = 1000;
            end
        end
        `tempdep2(VSAT1_t, VSAT1_i, -AT_i, at2)
        if (asymmod != 0) begin
            `tempdep2(VSAT1R_t, VSAT1R_i, -AT_i, at2)
            if (VSAT1R_t < 1000) begin
                VSAT1R_t = 1000;
            end
        end
        `tempdep2(VSATCV_t, VSATCV_i, -ATCV_i, at2cv)
        MEXP_t = hypsmooth((MEXP_i * (1.0 + tmexp * delTemp + tmexp2 * delTemp * delTemp) - 2.0), 1.0e-3) + 2.0;
        if (asymmod != 0) begin
            MEXPR_t = hypsmooth((MEXPR_i * (1.0 + tmexpr * delTemp + tmexp2 * delTemp * delTemp) - 2.0), 1.0e-3) + 2.0;
        end
        `tempdep2(KSATIV_t, KSATIV_i, ksativt1, ksativt2)
        `tempdep(PCLM_t, PCLM_i, pclmt)
        dvth_temp = (KT1_i + kt1l / Leff) * TRatio_m1 + kt11 / (1 + lexp(kt12 * (DevTemp - tvth))) - kt11 / (1 + lexp(kt12 * (Tnom - tvth)));
    end else begin
        T1 = U0_i * exp((UTE_i + UTE1_i * delTRatio1) * Trat_ln);
        u0_v = T1 + hypmax(UTL_i * delTemp, -0.9 * T1, 1.0e-4);
        if (asymmod == 1) begin
            T1 = U0R_i * exp((UTER_i + UTE1_i * delTRatio1) * Trat_ln);
            U0R_t = T1 + hypmax(UTLR_i * delTemp, -0.9 * T1, 1.0e-4);
            u0r_v = U0R_t;
        end
        if (Tnom > 210) begin
            T2 = 210 * (UA1_i / (UA_i + UA1_i * (210 - Tnom)) - UA2_i * (llnf(210 / Tnom) + 1) / Tnom);
            T1 = (UA_i + UA1_i * (210 - Tnom)) / pow(210 / Tnom, T2 + UA2_i * (210 / Tnom));
            UA_tl = T1 * pow(TRatio, T2 + UA2_i * TRatio);
            UA_th = UA_i + UA1_i * delTemp;
        end else begin
            T2 = UA_i * pow(210 / Tnom, UA1_i + UA2_i * (210 / Tnom)) * (UA1_i / 210 + UA2_i * (llnf(210 / Tnom) + 1) / Tnom);
            T1 = UA_i * pow(210 / Tnom, UA1_i + UA2_i * (210 / Tnom)) - T2 * (210 - Tnom);
            UA_tl = UA_i * pow(TRatio, UA1_i + UA2_i * TRatio);
            UA_th = T1 + T2 * delTemp;
        end
        T0 = wl * UA_tl + wh * UA_th;
        UA_t = hypsmooth(T0, 1.0e-6);
        if (asymmod != 0) begin
            if (Tnom > 210) begin
                T2 = 210 * (UA1R_i / (UAR_i + UA1R_i * (210 - Tnom)) - UA2_i * (llnf(210 / Tnom) + 1) / Tnom);
                T1 = (UAR_i + UA1R_i * (210 - Tnom)) / pow(210 / Tnom, T2 + UA2_i * (210 / Tnom));
                UAR_tl = T1 * pow(TRatio, T2 + UA2_i * TRatio);
                UAR_th = UAR_i + UA1R_i * delTemp;
            end else begin
                T2 = UAR_i * pow(210 / Tnom, UA1R_i + UA2_i * (210 / Tnom)) * (UA1R_i / 210 + UA2_i * (llnf(210 / Tnom) + 1) / Tnom);
                T1 = UAR_i * pow(210 / Tnom, UA1R_i + UA2_i * (210 / Tnom)) - T2 * (210 - Tnom);
                UAR_tl = UAR_i * pow(TRatio, UA1R_i + UA2_i * TRatio);
                UAR_th = T1 + T2 * delTemp;
            end
            T0 = wl * UAR_tl + wh * UAR_th;
            UAR_t = hypsmooth(T0, 1.0e-6);
        end
        UD_t = UD_i * exp((UD1_i + UD2_i * delTRatio1) * Trat_ln);
        if (asymmod != 0) begin
            UDR_t = UDR_i * exp((UD1R_i + UD2_i * delTRatio1) * Trat_ln);
        end
        UCS_t = UCS_i * exp((UCSTE_i + UCSTE1_i * delTRatio1) * Trat_ln);
        if (abs(UDS1_i * (Tnom - 210) / Tnom) < 1.0e-6) begin
            UDS_t = UDS_i * (lexp(UDS1_i * delTRatio1) - 1);
        end else begin
            UDS_t = UDS_i * (lexp(UDS1_i * delTRatio1) - 1) / abs(lexp(UDS1_i * (Tnom - 210) / Tnom) - 1);
        end
        if (abs(UDD1_i * (Tnom - 210) / Tnom) < 1.0e-6) begin
            UDD_t = UDD_i * (lexp(UDD1_i * delTRatio1) - 1);
        end else begin
            UDD_t = UDD_i * (lexp(UDD1_i * delTRatio1) - 1) / abs(lexp(UDD1_i * (Tnom - 210) / Tnom) - 1);
        end
        UDSeff_t = 0.5 + UDS_t;
        UDDeff_t = 0.5 + UDD_t;
        if (tempmod != 0) begin
            EU_t = EU_i + hypmax((EU1_i * delTemp1), -EU_i, 1.0e-6);
            VSAT_t = VSAT_i + hypmax((-AT_i * delTemp + at2 * delTemp1* delTemp1), -VSAT_i, 1.0e-6);
            if (asymmod != 0) begin
                VSATR_t = VSATR_i + hypmax((-ATR_i * delTemp + at2 * delTemp1* delTemp1), -VSATR_i, 1.0e-6);
                if (VSATR_t < 1000) begin
                    VSATR_t = 1000;
                end
            end
            VSAT1_t = VSAT1_i + hypmax((-AT_i * delTemp + at2 * delTemp1 * delTemp1), -VSAT1_i, 1.0e-6);
            if (asymmod != 0) begin
                VSAT1R_t = VSAT1R_i + hypmax((-AT_i * delTemp + at2 * delTemp1 * delTemp1), -VSAT1R_i, 1.0e-6);
                if (VSAT1R_t < 1000) begin
                    VSAT1R_t = 1000;
                end
            end
            VSATCV_t = VSATCV_i + hypmax((-ATCV_i * delTemp + at2cv * delTemp1 * delTemp1), -VSATCV_i, 1.0e-6);
            KSATIV_t = KSATIV_i + hypmax((ksativt1 * delTemp1 + ksativt2 * delTemp1 * delTemp1), -KSATIV_i, 1.0e-6);
            PCLM_t = PCLM_i + hypmax((pclmt * delTemp1), -PCLM_i, 1.0e-6);
        end else begin
            EU_t = EU_i * hypsmooth((1.0 + EU1_i * delTemp1 - 1.0e-6), 1.0e-3);
            VSAT_t = VSAT_i * hypsmooth((1.0 - AT_i * delTemp + at2 * delTemp1 * delTemp1 - 1.0e-6), 1.0e-3);
            if (asymmod != 0) begin
                VSATR_t = VSATR_i * hypsmooth((1.0 - ATR_i * delTemp + at2 * delTemp1 * delTemp1 - 1.0e-6), 1.0e-3);
                if (VSATR_t < 1000) begin
                    VSATR_t = 1000;
                end
            end
            VSAT1_t = VSAT1_i * hypsmooth((1.0 - AT_i * delTemp + at2 * delTemp1 * delTemp1 - 1.0e-6), 1.0e-3);
            if (asymmod != 0) begin
                VSAT1R_t = VSAT1R_i * hypsmooth((1.0 - AT_i * delTemp + at2 * delTemp1 * delTemp1 - 1.0e-6), 1.0e-3);
                if (VSAT1R_t < 1000) begin
                    VSAT1R_t = 1000;
                end
            end
            VSATCV_t = VSATCV_i * hypsmooth((1.0 - ATCV_i * delTemp + at2cv * delTemp1 * delTemp1 - 1.0e-6), 1.0e-3);
            KSATIV_t = KSATIV_i * hypsmooth((1.0 + ksativt1 * delTemp1 + ksativt2 * delTemp1 * delTemp1 - 1.0e-6), 1.0e-3);
            PCLM_t = PCLM_i * hypsmooth((1.0 + pclmt * delTemp1 - 1.0e-6), 1.0e-3);
        end
        MEXP_t = hypsmooth((MEXP_i * (1.0 + tmexp * delTemp + tmexp2 * delTemp1 * delTemp1) - 2.0), 1.0e-3) + 2.0;
        if (asymmod != 0) begin
            MEXPR_t = hypsmooth((MEXPR_i * (1.0 + tmexpr * delTemp + tmexp2 * delTemp1 * delTemp1) - 2.0), 1.0e-3) + 2.0;
        end
        if (cvmod == 1) begin
            T1 = U0CV_i * exp((UTECV_i + UTE1CV_i * delTRatio1) * Trat_ln);
            u0_cv = T1 + hypmax(UTLCV_i * delTemp, -0.9 * T1, 1.0e-4);
            if (Tnom > 210) begin
                T2 = 210 * (UA1CV_i / (UACV_i + UA1CV_i * (210 - Tnom)) - UA2CV_i * (llnf(210 / Tnom) + 1) / Tnom);
                T1 = (UACV_i + UA1CV_i * (210 - Tnom)) / pow(210 / Tnom, T2 + UA2CV_i * (210 / Tnom));
                UACV_tl = T1 * pow(TRatio, T2 + UA2CV_i * TRatio);
                UACV_th = UACV_i + UA1CV_i * delTemp;
            end else begin
                T2 = UACV_i * pow(210 / Tnom, UA1CV_i + UA2CV_i * (210 / Tnom)) * (UA1CV_i / 210 + UA2CV_i * (llnf(210 / Tnom) + 1) / Tnom);
                T1 = UACV_i * pow(210 / Tnom, UA1CV_i + UA2CV_i * (210 / Tnom)) - T2 * (210 - Tnom);
                UACV_tl = UACV_i * pow(TRatio, UA1CV_i + UA2CV_i * TRatio);
                UACV_th = T1 + T2 * delTemp;
            end
            T0 = wl * UACV_tl + wh * UACV_th;
            UACV_t = hypsmooth(T0, 1.0e-6);
            UDCV_t = UDCV_i * exp((UD1CV_i + UD2CV_i * delTRatio1) * Trat_ln);
        end
        if (PRT_i == PRT1_i) begin
            T2 = 1.0 + PRT_i * delTemp;
        end else if (TR0_i < 210) begin
            if (Tnom > 210) begin
                rdstemp0 = 1 + PRT_i * delTemp;
                rdstemp1 = 1 + PRT1_i * (DevTemp - TR0_i) + PRT_i * (TR0_i - Tnom);
                T3 = 1 + PRT_i * (210 - Tnom);
                T4 = 1 + PRT1_i * (210 - TR0_i) + PRT_i * (TR0_i - Tnom);
                if (PRT1_i < PRT_i) begin
                    T5 = smoothminx(rdstemp0, rdstemp1, SPRT_i) - smoothminx(T3, T4, SPRT_i) + T3;
                    T2 = smoothminx(T5, rdstemp0, 1.0e-3);
                end else begin
                    T5 = smoothmaxx2(rdstemp0, rdstemp1, SPRT_i) - smoothmaxx2(T3, T4, SPRT_i) + T3;
                    T2 = smoothmaxx2(T5, rdstemp0, 1.0e-3);
                end
            end else if (Tnom > TR0_i) begin
                rdstemp0 = 1 + PRT_i * delTemp;
                rdstemp1 = 1 + PRT1_i * (DevTemp - TR0_i) + PRT_i * (TR0_i - Tnom);
                T3 = (PRT_i - PRT1_i) * (TR0_i - Tnom);
                T4 = 1 + PRT_i * (210 - Tnom);
                T5 = 1 + PRT1_i * (210 - TR0_i) + PRT_i * (TR0_i - Tnom);
                if (PRT1_i < PRT_i) begin
                    T6 = smoothminx(rdstemp0, rdstemp1, SPRT_i) - smoothminx(T3, 0, SPRT_i);
                    T7 = smoothminx(T4, T5, SPRT_i) - smoothminx(T3, 0, SPRT_i);
                    T8 = T7 + PRT_i * (DevTemp - 210);
                    T2 = smoothminx(T6, T8, 1.0e-3);
                end else begin
                    T6 = smoothmaxx2(rdstemp0, rdstemp1, SPRT_i) - smoothmaxx2(T3, 0, SPRT_i);
                    T7 = smoothmaxx2(T4, T5, SPRT_i) - smoothmaxx2(T3, 0, SPRT_i);
                    T8 = T7 + PRT_i * (DevTemp - 210);
                    T2 = smoothmaxx2(T6, T8, 1.0e-3);
                end
            end else begin
                rdstemp1 = 1 + PRT1_i * delTemp;
                rdstemp0 = 1 + PRT_i * (DevTemp - TR0_i) + PRT1_i * (TR0_i - Tnom);
                T3 = (PRT1_i - PRT_i) * (TR0_i - Tnom);
                T4 = 1 + PRT1_i * (210 - Tnom);
                T5 = 1 + PRT_i * (210 - TR0_i) + PRT1_i * (TR0_i - Tnom);
                if (PRT1_i < PRT_i) begin
                    T6 = smoothminx(rdstemp0, rdstemp1, SPRT_i) - smoothminx(T3, 0, SPRT_i);
                    T7 = smoothminx(T4, T5, SPRT_i) - smoothminx(T3, 0, SPRT_i);
                    T8 = T7 + PRT_i * (DevTemp - 210);
                    T2 = smoothminx(T6, T8, 1.0e-3);
                end else begin
                    T6 = smoothmaxx2(rdstemp0, rdstemp1, SPRT_i) - smoothmaxx2(T3, 0, SPRT_i);
                    T7 = smoothmaxx2(T4, T5, SPRT_i) - smoothmaxx2(T3, 0, SPRT_i);
                    T8 = T7 + PRT_i * (DevTemp - 210);
                    T2 = smoothmaxx2(T6, T8, 1.0e-3);
                end
            end
        end else begin
            if (Tnom > 210) begin
                rdstemp0 = 1 + PRT_i * delTemp;
                rdstemp1 = 1 + PRT1_i * (DevTemp - 210) + PRT_i * (210 - Tnom);
                if (PRT1_i < PRT_i) begin
                    T2 = smoothminx(rdstemp0, rdstemp1, 1.0e-2);
                end else begin
                    T2 = smoothmaxx2(rdstemp0, rdstemp1, 1.0e-2);
                end
            end else begin
                rdstemp1 = 1 + PRT1_i * delTemp;
                rdstemp0 = 1 + PRT_i * (DevTemp - 210) + PRT1_i * (210 - Tnom);
                if (PRT1_i < PRT_i) begin
                    T2 = smoothminx(rdstemp0, rdstemp1, 1.0e-2);
                end else begin
                    T2 = smoothmaxx2(rdstemp0, rdstemp1, 1.0e-2);
                end
            end
        end
        rdstemp = hypsmooth((T2 - 1.0e-6), 1.0e-3);
        T4 = smoothmaxx2(Tnom, 210, 0.2);
        dvth_temp = (KT1_i + kt1l / Leff) * TRatio_m1 + kt11 / (1 + lexp(kt12 * (DevTemp1 - tvth))) - kt11 / (1 + lexp(kt12 * (T4 - tvth)));
    end
    if (VSAT_t < 1000) begin
        VSAT_t = 1000;
    end
    if (VSAT1_t < 1000) begin
        VSAT1_t = 1000;
    end
    if (VSATCV_t < 1000) begin
        VSATCV_t = 1000;
    end
    if (bulkmod != 0) begin
        if (tempmod == 0) begin
            `tempdep(UC_t, UC_i, UC1_i)
            if (cvmod == 1) begin
                `tempdep(UCCV_t, UCCV_i, UC1CV_i)
            end
            if (asymmod != 0) begin
                `tempdep(UCR_t, UCR_i, UC1R_i)
            end
        end else begin
            UC_t = UC_i + UC1_i * delTemp;
            if (cvmod == 1) begin
                UCCV_t = UCCV_i + UC1CV_i * delTemp;
            end
            if (asymmod != 0) begin
                UCR_t = UCR_i + UC1R_i * delTemp;
            end
        end
    end
    `tempdep(ETA0_t, ETA0_i, teta0)
    if (cvmod == 1) begin
        `tempdep(ETA0CV_t, ETA0CV_i, teta0cv)
    end
    `tempdep(ETA0R_t, ETA0R_i, teta0r)
    `tempdep(ETAMOB_t, ETAMOB_i, EMOBT_i)
    `tempdep(RSDR_t, rsdr, trsdr)
    if (asymmod != 0) begin
        `tempdep(RSDRR_t, rsdrr, trsdr)
    end
    `tempdep(RDDR_t, rddr, trddr)
    if (asymmod != 0) begin
        `tempdep(RDDRR_t, rddrr, trddr)
    end
    `tempdep(PTWG_t, PTWG_i, -PTWGT_i)
    if (asymmod != 0) begin
        `tempdep(PTWGR_t, PTWGR_i, -PTWGT_i)
    end
    BETA0_t = BETA0_i * exp(IIT_i * Trat_ln);
    SII0_t = SII0_i * (hypsmooth((1.0 + TII_i * TRatio_m1 - 0.01), 1.0e-3) + 0.01);
    K0_t = K0_i + K01_i * delTemp;
    K0SI_t = K0SI_i + hypmax(K0SI1_i * delTemp, -K0SI_i, 1.0e-6);
    K2SI_t = K2SI_i + hypmax(K2SI1_i * delTemp, -K2SI_i, 1.0e-6);
    K1_t = K1_i + hypmax(K11_i * delTemp, -K1_i, 1.0e-6);
    K2SAT_t = K2SAT_i + K2SAT1_i * delTemp;
    A1_t = A1_i + A11_i * delTemp;
    A2_t = A2_i + A21_i * delTemp;
    K2_t = K2_i + hypmax(K21_i * delTemp, -K2_i, 1.0e-6);
    K0SISAT_t = K0SISAT_i + K0SISAT1_i * delTemp;
    K2SISAT_t = K2SISAT_i + K2SISAT1_i * delTemp;
    AIGBINV_t = AIGBINV_i + hypmax(AIGBINV1_i * delTemp, -AIGBINV_i, 1.0e-6);
    AIGBACC_t = AIGBACC_i + hypmax(AIGBACC1_i * delTemp, -AIGBACC_i, 1.0e-6);
    AIGC_t = AIGC_i + hypmax(AIGC1_i * delTemp, -AIGC_i, 1.0e-6);
    AIGS_t = AIGS_i + hypmax(AIGS1_i * delTemp, -AIGS_i, 1.0e-6);
    AIGD_t = AIGD_i + hypmax(AIGD1_i * delTemp, -AIGD_i, 1.0e-6);
    BGIDL_t = BGIDL_i * hypsmooth((1.0 + TGIDL_i * delTemp - 1.0e-6), 1.0e-3);
    BGISL_t = BGISL_i * hypsmooth((1.0 + TGIDL_i * delTemp - 1.0e-6), 1.0e-3);
    ALPHA0_t = ALPHA0_i + hypmax(alpha01 * delTemp, -ALPHA0_i, 1.0e-6);
    ALPHA1_t = ALPHA1_i + hypmax(alpha11 * delTemp, -ALPHA1_i, 1.0e-6);
    ALPHAII0_t = ALPHAII0_i + hypmax(alphaii01 * delTemp, -ALPHAII0_i, 1.0e-25);
    ALPHAII1_t = ALPHAII1_i + hypmax(alphaii11 * delTemp, -ALPHAII1_i, 1.0e-20);
    igtemp = exp(IGT_i * Trat_ln);
    igsd_mult = igsd_mult0 * igtemp;
    if (bulkmod != 0) begin
        `tempdep(CJS_t, cjs, tcj)
        `tempdep(CJD_t, cjd, tcj)
        `tempdep(CJSWS_t, cjsws, tcjsw)
        `tempdep(CJSWD_t, cjswd, tcjsw)
        `tempdep(CJSWGS_t, cjswgs, tcjswg)
        `tempdep(CJSWGD_t, cjswgd, tcjswg)
        PBS_t = hypsmooth((pbs - tpb * delTemp - 0.01), 1.0e-3) + 0.01;
        PBD_t = hypsmooth((pbd - tpb * delTemp - 0.01), 1.0e-3) + 0.01;
        PBSWS_t = hypsmooth((pbsws - tpbsw * delTemp - 0.01), 1.0e-3) + 0.01;
        PBSWD_t = hypsmooth((pbswd - tpbsw * delTemp - 0.01), 1.0e-3) + 0.01;
        PBSWGS_t = hypsmooth((pbswgs - tpbswg * delTemp - 0.01), 1.0e-3) + 0.01;
        PBSWGD_t = hypsmooth((pbswgd - tpbswg * delTemp - 0.01), 1.0e-3) + 0.01;
        T0 = Eg0 / Vtm0 - Eg / Vtm;
        T3 = lexp((T0 + xtis * Trat_ln) / njs);
        JSS_t = jss * T3;
        JSWS_t = jsws * T3;
        JSWGS_t = jswgs * T3;
        T3 = lexp((T0 + xtid * Trat_ln) / njd);
        JSD_t = jsd * T3;
        JSWD_t = jswd * T3;
        JSWGD_t = jswgd * T3;
        JTSS_t = jtss * lexp(Eg0 * xtss * TRatio_m1 / Vtm);
        JTSD_t = jtsd * lexp(Eg0 * xtsd * TRatio_m1 / Vtm);
        JTSSWS_t = jtssws * lexp(Eg0 * xtssws * TRatio_m1 / Vtm);
        JTSSWD_t = jtsswd * lexp(Eg0 * xtsswd * TRatio_m1 / Vtm);
        JTSSWGS_t = jtsswgs * (sqrt(jtweff / Weff0) + 1.0) * lexp(Eg0 * xtsswgs * TRatio_m1 / Vtm);
        JTSSWGD_t = jtsswgd * (sqrt(jtweff / Weff0) + 1.0) * lexp(Eg0 * xtsswgd * TRatio_m1 / Vtm);
        NJTS_t = hypsmooth((njts * (1.0 + tnjts * TRatio_m1) - 0.01), 1.0e-3) + 0.01;
        NJTSD_t = hypsmooth((njtsd * (1.0 + tnjtsd * TRatio_m1) - 0.01), 1.0e-3) + 0.01;
        NJTSSW_t = hypsmooth((njtssw * (1.0 + tnjtssw * TRatio_m1) - 0.01), 1.0e-3) + 0.01;
        NJTSSWD_t = hypsmooth((njtsswd * (1.0 + tnjtsswd * TRatio_m1) - 0.01), 1.0e-3) + 0.01;
        NJTSSWG_t = hypsmooth((njtsswg * (1.0 + tnjtsswg * TRatio_m1) - 0.01), 1.0e-3) + 0.01;
        NJTSSWGD_t = hypsmooth((njtsswgd * (1.0 + tnjtsswgd * TRatio_m1) - 0.01), 1.0e-3) + 0.01;
    end

    if (!$param_given(vfbsd)) begin
        if (ngate > 0.0) begin
            if (cryomod == 0) begin
                vfbsd_v = devsign * (hypsmooth((0.5 * Eg - Vtm * llnf(ngate / ni)), 1.0e-4) - (0.5 * Eg - devsign * (0.5 * Eg - hypsmooth((0.5 * Eg - Vtm * llnf(nsd / ni)), 1.0e-4))));
            end else begin
                vfbsd_v = devsign * (hypsmooth((0.5 * Eg - Vtm * (llnf(ngate) - niln)), 1.0e-4) - (0.5 * Eg - devsign * (0.5 * Eg - hypsmooth((0.5 * Eg - Vtm * (llnf(nsd) - niln)), 1.0e-4))));
            end
        end else begin
            if (cryomod == 0) begin
                vfbsd_v = devsign * (PHIG_i - (easub + 0.5 * Eg - devsign * (0.5 * Eg - hypsmooth((0.5 * Eg - Vtm * llnf(nsd / ni)), 1.0e-4))));
            end else begin
                vfbsd_v = devsign * (PHIG_i - (easub + 0.5 * Eg - devsign * (0.5 * Eg - hypsmooth((0.5 * Eg - Vtm * (llnf(nsd) - niln)), 1.0e-4))));
            end
        end
    end else begin
        vfbsd_v = vfbsd;
    end
    if (!$param_given(vfbsdcv)) begin
        vfbsdcv_v = vfbsd_v;
    end else begin
        vfbsdcv_v = vfbsdcv;
    end
    if (cryomod == 0) begin
        phib = Vtm * llnf(NBODY_i / ni);
        phib = smoothminx(phib, 0, 1e-10);
        vbi = Vtm * llnf(NBODY_i * nsd / (ni * ni));
    end else begin
        phib = Vtm * (llnf(NBODY_i) - niln);
        phib = smoothminx(phib, 0, 1e-10);
        vbi = Vtm * (llnf(NBODY_i * nsd) - 2 * niln);
    end

    // Workfunction difference between gate and n+ source.
    deltaPhi = devsign * (PHIG_i - (easub + (type == `ntype ? 0.0 : Eg)));

    // Mobility degradation
    eta_mu = 0.5 * ETAMOB_t;
    eta_mu_cv = 0.5;
    if (type != `ntype) begin
        eta_mu = `ONE_OV_3 * ETAMOB_t;
        eta_mu_cv = `ONE_OV_3;
    end

    // Junction current and capacitance
    if (bulkmod != 0) begin
        // Source-side junction current
        Isbs = asej * JSS_t + psej * JSWS_t + tfin * NFINtotal * JSWGS_t;
        if (Isbs > 0.0) begin
            Nvtms = Vtm * njs;
            XExpBVS = lexp(-bvs / Nvtms) * xjbvs;
            T2 = max(ijthsfwd / Isbs, 10.0);
            Tb = 1.0 + T2 - XExpBVS;
            VjsmFwd = Nvtms * llnf(0.5 * (Tb + sqrt(Tb * Tb + 4.0 * XExpBVS)));
            T0 = lexp(VjsmFwd / Nvtms);
            IVjsmFwd = Isbs * (T0 - XExpBVS / T0 + XExpBVS - 1.0);
            SslpFwd = Isbs * (T0 + XExpBVS / T0) / Nvtms;
            T2 = hypsmooth((ijthsrev / Isbs - 10.0), 1.0e-3) + 10.0;
            VjsmRev = -bvs - Nvtms * llnf((T2 - 1.0) / xjbvs);
            T1 = xjbvs * lexp(-(bvs + VjsmRev) / Nvtms);
            IVjsmRev = Isbs * (1.0 + T1);
            SslpRev = -Isbs * T1 / Nvtms;
        end
        // Drain-side junction current
        Isbd = adej * JSD_t + pdej * JSWD_t + tfin * NFINtotal * JSWGD_t;
        if (Isbd > 0.0) begin
            Nvtmd = Vtm * njd;
            XExpBVD = lexp(-bvd / Nvtmd) * xjbvd;
            T2 = max(ijthdfwd / Isbd, 10.0);
            Tb = 1.0 + T2 - XExpBVD;
            VjdmFwd = Nvtmd * llnf(0.5 * (Tb + sqrt(Tb * Tb + 4.0 * XExpBVD)));
            T0 = lexp(VjdmFwd / Nvtmd);
            IVjdmFwd = Isbd * (T0 - XExpBVD / T0 + XExpBVD - 1.0);
            DslpFwd = Isbd * (T0 + XExpBVD / T0) / Nvtmd;
            T2 = hypsmooth((ijthdrev / Isbd - 10.0), 1.0e-3) + 10.0;
            VjdmRev = -bvd - Nvtmd * llnf((T2 - 1.0) / xjbvd);
            T1 = xjbvd * lexp(-(bvd + VjdmRev) / Nvtmd);
            IVjdmRev = Isbd * (1.0 + T1);
            DslpRev = -Isbd * T1 / Nvtmd;
        end
        // Junction capacitance
        Czbs = CJS_t * asej;
        Czbssw = CJSWS_t * psej;
        Czbsswg = CJSWGS_t * Weff0 * NFINtotal;
        Czbd = CJD_t * adej;
        Czbdsw = CJSWD_t * pdej;
        Czbdswg = CJSWGD_t * Weff0 * NFINtotal;
        // Bias-independent part
        `juncap_bias_indep(sjs, PBS_t, mjs, mjs2, vec1s, pb21s)
        `juncap_bias_indep(sjsws, PBSWS_t, mjsws, mjsws2, vec2s, pb22s)
        `juncap_bias_indep(sjswgs, PBSWGS_t, mjswgs, mjswgs2, vec3s, pb23s)
        `juncap_bias_indep(sjd, PBD_t, mjd, mjd2, vec1d, pb21d)
        `juncap_bias_indep(sjswd, PBSWD_t, mjswd, mjswd2, vec2d, pb22d)
        `juncap_bias_indep(sjswgd, PBSWGD_t, mjswgd, mjswgd2, vec3d, pb23d)
    end

    // Generation-recombination current
    igentemp = lexp(Eg * TRatio_m1 / Vtm / NTGEN_i);

    // Bias-dependent calculations
    vgs_noswap = devsign * V(gi, si);
    vds_noswap = devsign * V(di, si);
    vgd_noswap = devsign * V(gi, di);
    ves_jct = devsign * V(e, si);
    ved_jct = devsign * V(e, di);
    vge = devsign * V(gi, e);
    if (rgatemod !=2) begin
        vgdrift = devsign * V(ge, di);
        vgdrift_s = devsign * V(ge, si);
    end else begin
        vgdrift = devsign * V(gintd, di);
        vgdrift_s = devsign * V(gints, si);
    end

    // Source/drain swap
    sigvds = 1.0;
    if (vds_noswap < 0.0) begin
        sigvds = -1.0;
        vgs = vgs_noswap - vds_noswap;
        vds = -1.0 * vds_noswap;
        ves = ved_jct;
    end else begin
        vgs = vgs_noswap;
        vds = vds_noswap;
        ves = ves_jct;
    end
    vgsfb = vgs - deltaPhi;

    // Vds smoothing
    vdsx = sqrt(vds * vds + 0.01) - 0.1;

    // Ves Smoothing
    if (bulkmod != 0) begin
        vesx = ves - 0.5 * (vds - vdsx);
        vesmax = 0.95 * PHIBE_i;
        T2 = vesmax - vesx - 1.0e-3;
        veseff = vesmax - 0.5 * (T2 + sqrt(T2 * T2 + 0.004 * vesmax));
    end

    // Asymmetry model
    T0 = tanh(0.6 * vds_noswap / Vtm);
    wf = 0.5 + 0.5 * T0;
    wr_v = 1.0 - wf;
    if (asymmod != 0) begin
        CDSCD_a = CDSCDR_i * wr_v + CDSCD_i * wf;
        ETA0_a = ETA0R_t * wr_v + ETA0_t * wf;
        PDIBL1_a = PDIBL1R_i * wr_v + PDIBL1_i * wf;
        PDIBL2_a = PDIBL2R_i * wr_v + PDIBL2_i * wf;
        MEXP_a = MEXPR_t * wr_v + MEXP_t * wf;
        PTWG_a = PTWGR_t * wr_v + PTWG_t * wf;
        VSAT1_a = VSAT1R_t * wr_v + VSAT1_t * wf;
        RSDR_a = RSDRR_t * wr_v + RSDR_t * wf;
        RDDR_a = RDDRR_t * wr_v + RDDR_t * wf;
        PCLM_a = PCLMR_i * wr_v + PCLM_t * wf;
        VSAT_a = VSATR_t * wr_v + VSAT_t * wf;
        KSATIV_a = KSATIVR_i * wr_v + KSATIV_t * wf;
        DVTSHIFT_a = DVTSHIFTR_i * wr_v + DVTSHIFT_i * wf;
        CIT_a = CITR_i * wr_v + CIT_i * wf;
        u0_a = u0r_v * wr_v + u0_v * wf;
        UA_a = UAR_t * wr_v + UA_t * wf;
        UD_a = UDR_t * wr_v + UD_t * wf;
        UC_a = UCR_t * wr_v + UC_t * wf;
        EU_a = EUR_i * wr_v + EU_t * wf;
    end else begin
        CDSCD_a = CDSCD_i;
        ETA0_a = ETA0_t;
        PDIBL1_a = PDIBL1_i;
        PDIBL2_a = PDIBL2_i;
        MEXP_a = MEXP_t;
        PTWG_a = PTWG_t;
        VSAT1_a = VSAT1_t;
        RSDR_a = RSDR_t;
        RDDR_a = RDDR_t;
        PCLM_a = PCLM_t;
        VSAT_a = VSAT_t;
        KSATIV_a = KSATIV_t;
        DVTSHIFT_a = DVTSHIFT_i;
        CIT_a = CIT_i;
        u0_a = u0_v;
        UA_a = UA_t;
        UD_a = UD_t;
        UC_a = UC_t;
        EU_a = EU_t;
    end

    // Drain saturation voltage
    inv_MEXP = 1.0 / MEXP_a;

    // SCE, DIBL, SS degradation, Ref: BSIM4
    phist = 0.4 + phib + PHIN_i;
    T1 = 2.0 * (Cins / Weff_UFCM) / (rc + 2.0);
    cdsc_v = Theta_SW * (CDSC_i + CDSCD_a * vdsx);
    if (nvtm == 0.0) begin
        if (cryomod == 0) begin
            nVtm = Vtm * ThetaSS * (1.0 + (CIT_a + cdsc_v) / T1);
        end else begin
            nVtm = Vtmeff * ThetaSS * (1.0 + (CIT_a + cdsc_v) / T1);
        end
    end else begin
        nVtm = nvtm;
    end

    // Unified FinFET compact model
    qdep = Qdep_ov_Cins / nVtm;
    vth_fixed_factor_SI = llnf(Cins * nVtm / (`q * Nc * 2.0 * Ach));
    vth_fixed_factor_Sub = llnf((qdep * rc) * (qdep * rc) / ((lexp(qdep * rc) - qdep * rc - 1.0))) + vth_fixed_factor_SI;
    q0 = 10.0 * nVtm / rc + 2.0 * qbs;

    // New QM parameter calculation
    fieldnormalizationfactor = Vtm * Cins / (Weff_UFCM * epssub);
    auxQMfact = pow(4.5 * `HBAR * `M_PI * `q / (4.0 * sqrt(2.0 * mx)), `TWO_OV_3);
    QMFACTORCVfinal = qmfactorcv * auxQMfact * pow(fieldnormalizationfactor, `TWO_OV_3) / (`q * Vtm);

    // Delta Vth
    dvth_vtroll = -DVT0_i * Theta_SCE * (vbi - phist);
    dvth_dibl = -ETA0_a * Theta_DIBL * (vdsx + ETA1_i * sqrt(vdsx + 0.01)) + (DVTP0_i * Theta_DITS * pow(vdsx+0.01, DVTP1_i));
    dvth_rsce = K1RSCE_i * Theta_RSCE * sqrt(phist);
    dvth_all = dvth_vtroll + dvth_dibl + dvth_rsce + dvth_temp + DVTSHIFT_a;
    vgsfb = vgsfb - dvth_all;

    // Vgs clamping for inversion region
    beta0_v = u0_a * cox * Weff0 / Leff;
    if (cryomod == 0) begin
        T3 = pow((2.0 * cox * imin / (beta0_v * nVtm * `q * Nc * tfin)), nVtm);
        T0 = -(dvch_qm + llnf(T3));
        T1 = vgsfb + T0 + delvtrand;
        vgsfbeff = hypsmooth(T1, 1.0e-4) - T0;
    end else begin
        T0 = -nVtm * llnf(2.0 * cox * imin / (beta0_v * nVtm * `q * Nc * tfin));
        T1  = -dvch_qm + smoothminx(T0, 0.01, 1e-4);
        T2 = vgsfb + T1 + delvtrand;
        vgsfbeff = hypsmooth(T2, 1.0e-4) - T1;
    end

    // Core model calculation at source
    vch = dvch_qm;
    T4 = pow(-qdep, `TWO_OV_3);
    if (bulkmod != 0) begin
        T1 = hypsmooth((2.0 * phib + vch - ves), 0.1);
        T3 = -K1_t / (2.0 * nVtm) * (sqrt(T1) - sqrt(2.0 * phib));
        T0 = -qdep - T3 + vth_fixed_factor_Sub + QMFACTORCVfinal * T4;
        T1 = -qdep - T3 + vth_fixed_factor_SI;
    end else begin
        T0 = -qdep + vth_fixed_factor_Sub + QMFACTORCVfinal * T4;
        T1 = -qdep + vth_fixed_factor_SI;
    end
    T2 = (vgsfbeff - vch) / nVtm;
    F0 = -T2 + T1;
    T3 = 0.5 * (T2 - T0);
    qm = lexp(T3);
    if (qm > 1.0e-7) begin
        T7 = ln(1.0 + qm);
        qm = 2.0 * (1.0 - sqrt(1.0 + T7 * T7));
        T8 = (qm * alpha_ufcm + qdep) * rc;
        T4 = T8 / (lexp(T8) - T8 - 1.0);
        T5 = T8 * T4;
        qm_ln = ln(-(qm + qdep));
        e0 = F0 - qm + llnf(-qm) + llnf(T5) + QMFACTORCVfinal * exp(`TWO_OV_3 * qm_ln);
        e1 = -1.0 + 1.0 / qm + (2.0 / T8 - T4 - 1.0) * rc - `TWO_OV_3 * QMFACTORCVfinal * exp(-`ONE_OV_3 * qm_ln);
        e2 = -1.0 / (qm * qm) - (2.0 / 9.0) * QMFACTORCVfinal * exp(-`FOUR_OV_3 * qm_ln);
        qm = qm - (e0 / e1) * (1.0 + (e0 * e2) / (2.0 * e1 * e1));
        T8 = (qm * alpha_ufcm + qdep) * rc;
        T4 = T8 / (lexp(T8) - T8 - 1.0);
        T5 = T8 * T4;
        qm_ln = ln(-(qm + qdep));
        e0 = F0 - qm + llnf(-qm) + llnf(T5) + QMFACTORCVfinal * exp(`TWO_OV_3 * qm_ln);
        e1 = -1.0 + 1.0 / qm + (2.0 / T8 - T4 - 1.0) * rc - `TWO_OV_3 * QMFACTORCVfinal * exp(-`ONE_OV_3 * qm_ln);
        e2 = -1.0 / (qm * qm) - (2.0 / 9.0) * QMFACTORCVfinal * exp(-`FOUR_OV_3 * qm_ln);
        qm = qm - (e0 / e1) * (1.0 + (e0 * e2) / (2.0 * e1 * e1));
    end else begin
        qm = -qm * qm;
    end
    qis = -qm * nVtm;

    //Gate-All-Around FET quantum subband model: source side
    if (subbandmod == 1) begin
        QT2 = (vgsfb - vch) / nVtm;
        QT3 = smoothminx(QT2, 0, p1);
        QT4 = pow(QT3, d1 / 2);
        qnds1 = qnd10 * QT4 * lexp(QT2 - QT3);

        QT5 = (vgsfb - vch - qe2) / nVtm;
        QT6 = smoothminx(QT5, 0, p2);
        QT7 = pow(QT6, d2 / 2);
        qnds2 = qnd20 * QT7 * lexp(QT5 - QT6);

        QT8 = (vgsfb - vch - qe3) / nVtm;
        QT9 = smoothminx(QT8, 0, p3);
        QT10 = pow(QT9, d3 / 2);
        qnds3 = qnd30 * QT10 * lexp(QT8 - QT9) ;

        qis = nc3d * qis + ncq * (qnds1 + qnds2 + qnds3);
    end

    // Drain-to-source saturation voltage
    qb0 = 1.0e-2 / cox;
    Eeffs = EeffFactor * (qbs + eta_mu * qis);
    T2 = pow((0.5 * (1.0 + qis / qb0)), UCS_t);
    T3 = pow(Eeffs, EU_a);
    if (bulkmod != 0) begin
        T3 = (UA_a + UC_a * veseff) * T3 + UD_a / T2;
    end else begin
        T3 = UA_a * T3 + UD_a / T2;
    end
    Dmobs = 1.0 + T3;
    Dmobs = smoothminx(Dmobs, 1.0, dmobclamp);
    Dmobs = Dmobs / u0mult;
    if (rdsmod == 1) begin
        Rdss = 0.0;
    end else if (rdsmod == 0) begin
        T4 = 1.0 + PRWGS_i * qis;
        T1 = 1.0 / T4;
        T0 = 0.5 * (T1 + sqrt(T1 * T1 + 0.01));
        Rdss = (rdswmin + RDSW_i * T0) * WeffWRFactor * NFINtotal * rdstemp;
    end else begin
        T4 = 1.0 + PRWGS_i * qis;
        T1 = 1.0 / T4;
        T0 = 0.5 * (T1 + sqrt(T1 * T1 + 0.01));
        Rdss = (RSourceGeo + RDrainGeo + (rdswmin + RDSW_i * T0) * WeffWRFactor * NFINtotal) * rdstemp;
    end
    Esat = 2.0 * VSAT_a / u0_a * Dmobs;
    EsatL = Esat * Leff;
    if (cryomod == 0) begin
        T6 = KSATIV_a * (qis + 2.0 * Vtm);
    end else begin
        T6 = KSATIV_a * (qis + 2.0 * Vtmeff);
    end
    if (Rdss > 0.0) begin
        WVCox = Weff0 * VSAT_a * cox;
        T0 = WVCox * Rdss;
        Ta = 2.0 * T0;
        Tb = T6 + EsatL + 3.0 * T6 * T0;
        Tc = T6 * (EsatL + 2.0 * T6 * T0);
        Vdsat = (Tb * Tb - (Tb * Tb - 2.0 * Ta * Tc))/((Tb + sqrt(Tb * Tb - 2.0 * Ta * Tc)) * Ta);
    end else begin
        Vdsat = EsatL * T6 / (EsatL + T6);
    end
    Vdsat = hypsmooth((Vdsat - 1.0e-3), 1.0e-5) + 1.0e-3;
    T7 = pow((vds / Vdsat)+1e-6, MEXP_a);
    T8 = pow((1.0 + T7), inv_MEXP);
    Vdseff = min((vds / T8), vds);

    // Core model calculation at drain side
    vch = Vdseff + dvch_qm;
    T2 = pow(-qdep, `TWO_OV_3);
    if (bulkmod != 0) begin
        T1 = hypsmooth((2.0 * phib + vch - ves), 0.1);
        T3 = -K1_t / (2.0 * nVtm) * (sqrt(T1) - sqrt(2.0 * phib));
        T0 = -qdep - T3 + vth_fixed_factor_Sub + QMFACTORCVfinal * T2;
        T1 = -qdep - T3 + vth_fixed_factor_SI;
    end else begin
        T0 = -qdep + vth_fixed_factor_Sub + QMFACTORCVfinal * T2;
        T1 = -qdep + vth_fixed_factor_SI;
    end
    T2 = (vgsfbeff - vch) / nVtm;
    F0 = -T2 + T1;
    T3 = (T2 - T0) * 0.5;
    qm = lexp(T3);
    if (qm > 1.0e-7) begin
        T7 = ln(1.0 + qm);
        qm = 2.0 * (1.0 - sqrt(1.0 + T7 * T7));
        T8 = (qm * alpha_ufcm + qdep) * rc;
        T4 = T8 / (lexp(T8) - T8 - 1.0);
        T5 = T8 * T4;
        qm_ln = ln(-(qm + qdep));
        e0 = F0 - qm + llnf(-qm) + llnf(T5) + QMFACTORCVfinal * exp(`TWO_OV_3 * qm_ln);
        e1 = -1.0 + (1.0 / qm) + (2.0 / T8 - T4 - 1.0) * rc - `TWO_OV_3 * QMFACTORCVfinal * exp(-`ONE_OV_3 * qm_ln);
        e2 = -1.0 / (qm * qm) - (2.0 / 9.0) * QMFACTORCVfinal * exp(-`FOUR_OV_3 * qm_ln);
        qm = qm - (e0 / e1) * (1.0 + (e0 * e2) / (2.0 * e1 * e1));
        T8 = (qm * alpha_ufcm + qdep) * rc;
        T4 = T8 / (lexp(T8) - T8 - 1.0);
        T5 = T8 * T4;
        qm_ln = ln(-(qm + qdep));
        e0 = F0 - qm + llnf(-qm) + llnf(T5) + QMFACTORCVfinal * exp(`TWO_OV_3 * qm_ln);
        e1 = -1.0 + (1.0 / qm) + (2.0 / T8 - T4 - 1.0) * rc - `TWO_OV_3 * QMFACTORCVfinal * exp(-`ONE_OV_3 * qm_ln);
        e2 = -1.0 / (qm * qm) - (2.0 / 9.0) * QMFACTORCVfinal * exp(-`FOUR_OV_3 * qm_ln);
        qm = qm - (e0 / e1) * (1.0 + (e0 * e2) / (2.0 * e1 * e1));
    end else begin
        qm = -qm * qm;
    end
    qid = -qm * nVtm;

    //Gate-All-Around quantum subband model: drain side
    if (subbandmod == 1) begin
        QT2 = (vgsfb - vch) / nVtm;
        QT3 = smoothminx(QT2, 0, p1);
        QT4 = pow(QT3, d1 / 2);
        qndd1 = qnd10 * QT4 * lexp(QT2 - QT3);

        QT5 = (vgsfb - vch - qe2) / nVtm;
        QT6 = smoothminx(QT5, 0, p2);
        QT7 = pow(QT6, d2 / 2);
        qndd2 = qnd20 * QT7 * lexp(QT5 - QT6);

        QT8 = (vgsfb - vch - qe3) / nVtm;
        QT9 = smoothminx(QT8, 0, p3);
        QT10 = pow(QT9, d3 / 2);
        qndd3 = qnd30 * QT10 * lexp(QT8 - QT9);

        qid = nc3d * qid + ncq * (qndd1 + qndd2 + qndd3);
    end

    // Core model calculation for C-V
    if (cvmod == 1) begin
        // Delta Vth_cv
        dvth_dibl_cv = -ETA0CV_t * Theta_DIBL * (vdsx + ETA1_i * sqrt(vdsx + 0.01)) + (DVTP0_i * Theta_DITS * pow(vdsx + 0.01, DVTP1_i));
        dvth_all_cv = dvth_vtroll + dvth_dibl_cv + dvth_rsce + dvth_temp + DVTSHIFT_a;
        vgsfb_cv = vgs - deltaPhi - dvth_all_cv;

        // Vgs clamping for inversion region
        beta0_cv = u0_cv * cox * Weff0 / Leff;
        if (cryomod == 0) begin
            T3 = pow((2.0 * cox * imin / (beta0_cv * nVtm * `q * Nc * tfin)), nVtm);
            T0 = -(dvch_qm + llnf(T3));
            T1 = vgsfb_cv + T0 + delvtrand;
            vgsfbeff_cv = hypsmooth(T1, 1.0e-4) - T0;
        end else begin
            T0 = -nVtm * llnf(2.0 * cox * imin / (beta0_cv * nVtm * `q * Nc * tfin));
            T1  = -dvch_qm + smoothminx(T0, 0.01, 1e-4);
            T2 = vgsfb_cv + T1 + delvtrand;
            vgsfbeff_cv = hypsmooth(T2, 1.0e-4) - T1;
        end

        // Core model calculation at source
        vch_cv = dvch_qm;
        T4 = pow(-qdep, `TWO_OV_3);
        if (bulkmod != 0) begin
            T1 = hypsmooth((2.0 * phib + vch_cv - ves), 0.1);
            T3 = -K1_t / (2.0 * nVtm) * (sqrt(T1) - sqrt(2.0 * phib));
            T0 = -qdep - T3 + vth_fixed_factor_Sub + QMFACTORCVfinal * T4;
            T1 = -qdep - T3 + vth_fixed_factor_SI;
        end else begin
            T0 = -qdep + vth_fixed_factor_Sub + QMFACTORCVfinal * T4;
            T1 = -qdep + vth_fixed_factor_SI;
        end
        T2 = (vgsfbeff_cv - vch_cv) / nVtm;
        F0 = -T2 + T1;
        T3 = 0.5 * (T2 - T0);
        qm = lexp(T3);
        if (qm > 1.0e-7) begin
            T7 = ln(1.0 + qm);
            qm = 2.0 * (1.0 - sqrt(1.0 + T7 * T7));
            T8 = (qm * alpha_ufcm + qdep) * rc;
            T4 = T8 / (lexp(T8) - T8 - 1.0);
            T5 = T8 * T4;
            qm_ln = ln(-(qm + qdep));
            e0 = F0 - qm + llnf(-qm) + llnf(T5) + QMFACTORCVfinal * exp(`TWO_OV_3 * qm_ln);
            e1 = -1.0 + 1.0 / qm + (2.0 / T8 - T4 - 1.0) * rc - `TWO_OV_3 * QMFACTORCVfinal * exp(-`ONE_OV_3 * qm_ln);
            e2 = -1.0 / (qm * qm) - (2.0 / 9.0) * QMFACTORCVfinal * exp(-`FOUR_OV_3 * qm_ln);
            qm = qm - (e0 / e1) * (1.0 + (e0 * e2) / (2.0 * e1 * e1));
            T8 = (qm * alpha_ufcm + qdep) * rc;
            T4 = T8 / (lexp(T8) - T8 - 1.0);
            T5 = T8 * T4;
            qm_ln = ln(-(qm + qdep));
            e0 = F0 - qm + llnf(-qm) + llnf(T5) + QMFACTORCVfinal * exp(`TWO_OV_3 * qm_ln);
            e1 = -1.0 + 1.0 / qm + (2.0 / T8 - T4 - 1.0) * rc - `TWO_OV_3 * QMFACTORCVfinal * exp(-`ONE_OV_3 * qm_ln);
            e2 = -1.0 / (qm * qm) - (2.0 / 9.0) * QMFACTORCVfinal * exp(-`FOUR_OV_3 * qm_ln);
            qm = qm - (e0 / e1) * (1.0 + (e0 * e2) / (2.0 * e1 * e1));
        end else begin
            qm = -qm * qm;
        end
        qis_cv = -qm * nVtm;

        //Gate-All-Around FET quantum subband model: source side
        if (subbandmod == 1) begin
            QT2 = (vgsfb_cv - vch_cv) / nVtm;
            QT3 = smoothminx(QT2, 0, p1);
            QT4 = pow(QT3, d1 / 2);
            qnds1 = qnd10 * QT4 * lexp(QT2 - QT3);

            QT5 = (vgsfb_cv - vch_cv - qe2) / nVtm;
            QT6 = smoothminx(QT5, 0, p2);
            QT7 = pow(QT6, d2 / 2);
            qnds2 = qnd20 * QT7 * lexp(QT5 - QT6);

            QT8 = (vgsfb_cv - vch_cv - qe3) / nVtm;
            QT9 = smoothminx(QT8, 0, p3);
            QT10 = pow(QT9, d3 / 2);
            qnds3 = qnd30 * QT10 * lexp(QT8 - QT9) ;

            qis_cv = nc3d * qis_cv + ncq * (qnds1 + qnds2 + qnds3);
        end

        // Drain-to-source saturation voltage
        Eeffs_cv = EeffFactor * (qbs + eta_mu * qis_cv);
        T2 = pow((0.5 * (1.0 + qis_cv / qb0)), UCS_t);
        T3 = pow(Eeffs_cv, EU_a);
        if (bulkmod != 0) begin
            T3 = (UACV_t + UCCV_t * veseff) * T3 + UDCV_t / T2;
        end else begin
            T3 = UACV_t * T3 + UDCV_t / T2;
        end
        Dmobs_cv = 1.0 + T3;
        Dmobs_cv = smoothminx(Dmobs_cv, 1.0, dmobclamp);
        Dmobs_cv = Dmobs_cv / u0mult;
        if (rdsmod == 1) begin
            Rdss_cv = 0.0;
        end else if (rdsmod == 0) begin
            T4 = 1.0 + PRWGS_i * qis_cv;
            T1 = 1.0 / T4;
            T0 = 0.5 * (T1 + sqrt(T1 * T1 + 0.01));
            Rdss_cv = (rdswmin + RDSW_i * T0) * WeffWRFactor * NFINtotal * rdstemp;
        end else begin
            T4 = 1.0 + PRWGS_i * qis_cv;
            T1 = 1.0 / T4;
            T0 = 0.5 * (T1 + sqrt(T1 * T1 + 0.01));
            Rdss_cv = (RSourceGeo + RDrainGeo + (rdswmin + RDSW_i * T0) * WeffWRFactor * NFINtotal) * rdstemp;
        end
        Esats_cv = 2.0 * VSATCV_t / u0_cv * Dmobs_cv;
        EsatLs_cv = Esats_cv * Leff;
        if (cryomod == 0) begin
            T6 = KSATIV_a * (qis_cv + 2.0 * Vtm);
        end else begin
            T6 = KSATIV_a * (qis_cv + 2.0 * Vtmeff);
        end
        if (Rdss_cv > 0.0) begin
            T0 = Weff0 * VSATCV_t * cox * Rdss_cv;
            Ta = 2.0 * T0;
            Tb = T6 + EsatLs_cv + 3.0 * T6 * T0;
            Tc = T6 * (EsatLs_cv + 2.0 * T6 * T0);
            Vdsat_cv = (Tb * Tb - (Tb * Tb - 2.0 * Ta * Tc))/((Tb + sqrt(Tb * Tb - 2.0 * Ta * Tc)) * Ta);
        end else begin
            Vdsat_cv = EsatLs_cv * T6 / (EsatLs_cv + T6);
        end
        Vdsat_cv = hypsmooth((Vdsat_cv - 1.0e-3), 1.0e-5) + 1.0e-3;
        T7 = pow((vds / Vdsat_cv) + 1e-6, MEXP_a);
        T8 = pow((1.0 + T7), inv_MEXP);
        Vdseff_cv = min((vds / T8), vds);

        // Core model calculation at drain side
        vch_cv = Vdseff_cv + dvch_qm;
        T2 = pow(-qdep, `TWO_OV_3);
        if (bulkmod != 0) begin
            T1 = hypsmooth((2.0 * phib + vch_cv - ves), 0.1);
            T3 = -K1_t / (2.0 * nVtm) * (sqrt(T1) - sqrt(2.0 * phib));
            T0 = -qdep - T3 + vth_fixed_factor_Sub + QMFACTORCVfinal * T2;
            T1 = -qdep - T3 + vth_fixed_factor_SI;
        end else begin
            T0 = -qdep + vth_fixed_factor_Sub + QMFACTORCVfinal * T2;
            T1 = -qdep + vth_fixed_factor_SI;
        end
        T2 = (vgsfbeff_cv - vch_cv) / nVtm;
        F0 = -T2 + T1;
        T3 = (T2 - T0) * 0.5;
        qm = lexp(T3);
        if (qm > 1.0e-7) begin
            T7 = ln(1.0 + qm);
            qm = 2.0 * (1.0 - sqrt(1.0 + T7 * T7));
            T8 = (qm * alpha_ufcm + qdep) * rc;
            T4 = T8 / (lexp(T8) - T8 - 1.0);
            T5 = T8 * T4;
            qm_ln = ln(-(qm + qdep));
            e0 = F0 - qm + llnf(-qm) + llnf(T5) + QMFACTORCVfinal * exp(`TWO_OV_3 * qm_ln);
            e1 = -1.0 + (1.0 / qm) + (2.0 / T8 - T4 - 1.0) * rc - `TWO_OV_3 * QMFACTORCVfinal * exp(-`ONE_OV_3 * qm_ln);
            e2 = -1.0 / (qm * qm) - (2.0 / 9.0) * QMFACTORCVfinal * exp(-`FOUR_OV_3 * qm_ln);
            qm = qm - (e0 / e1) * (1.0 + (e0 * e2) / (2.0 * e1 * e1));
            T8 = (qm * alpha_ufcm + qdep) * rc;
            T4 = T8 / (lexp(T8) - T8 - 1.0);
            T5 = T8 * T4;
            qm_ln = ln(-(qm + qdep));
            e0 = F0 - qm + llnf(-qm) + llnf(T5) + QMFACTORCVfinal * exp(`TWO_OV_3 * qm_ln);
            e1 = -1.0 + (1.0 / qm) + (2.0 / T8 - T4 - 1.0) * rc - `TWO_OV_3 * QMFACTORCVfinal * exp(-`ONE_OV_3 * qm_ln);
            e2 = -1.0 / (qm * qm) - (2.0 / 9.0) * QMFACTORCVfinal * exp(-`FOUR_OV_3 * qm_ln);
            qm = qm - (e0 / e1) * (1.0 + (e0 * e2) / (2.0 * e1 * e1));
        end else begin
            qm = -qm * qm;
        end
        qid_cv = -qm * nVtm;

        //Gate-All-Around quantum subband model: drain side
        if (subbandmod == 1) begin
            QT2 = (vgsfb_cv - vch_cv) / nVtm;
            QT3 = smoothminx(QT2, 0, p1);
            QT4 = pow(QT3, d1 / 2);
            qndd1 = qnd10 * QT4 * lexp(QT2 - QT3);

            QT5 = (vgsfb_cv - vch_cv - qe2) / nVtm;
            QT6 = smoothminx(QT5, 0, p2);
            QT7 = pow(QT6, d2 / 2);
            qndd2 = qnd20 * QT7 * lexp(QT5 - QT6);

            QT8 = (vgsfb_cv - vch_cv - qe3) / nVtm;
            QT9 = smoothminx(QT8, 0, p3);
            QT10 = pow(QT9, d3 / 2);
            qndd3 = qnd30 * QT10 * lexp(QT8 - QT9);

            qid_cv = nc3d * qid_cv + ncq * (qndd1 + qndd2 + qndd3);
        end
        qia_cv = 0.5 * (qis_cv + qid_cv);
        dqi_cv = qis_cv - qid_cv;
        T0 = Vdseff_cv * Vdseff_cv / 6.25e-4;
        if (chargewf != 0.0) begin
            qia2_cv = 0.5 * (qis_cv + qid_cv) + chargewf * (1.0 - lexp(-T0)) * 0.5 * dqi_cv;
        end else begin
            qia2_cv = 0.5 * (qis_cv + qid_cv);
        end
    end

    if (bulkmod != 0) begin
        T9 = K1_t / (2.0 * nVtm) * sqrt(Vtm);
        T0 = T9 / 2.0;
        T2 = (vge - (deltaPhi - Eg - Vtm * llnf(NBODY_i / Nc) + delvfbacc)) / Vtm;
        if ((T2 * Vtm) > phib + T9 * sqrt(phib * Vtm)) begin
            T1 = sqrt(T2 - 1.0 + T0 * T0) - T0;
            T10 = 1.0 + T1 * T1;
            T6 = expm1(-T10);
        end else begin
            T3 = T2 * 0.5 - 3.0 * (1.0 + T9 / sqrt(2.0));
            T10 = T3 + sqrt(T3 * T3 + 6.0 * T2);
            if (T2 < 0.0) begin
                T4 = (T2 - T10) / T9;
                T6 = -T10 + T4 * T4;
                T10 = -llnf(1.0 - T10 + T4 * T4);
            end else begin
                T11 = lexp(-T10);
                T4 = sqrt(T2 - 1.0 + T11 + T0 * T0) - T0;
                T10 = 1.0 - T11 + T4 * T4;
                T6  = expm1(-T10);
            end
        end
        T7 = sqrt(T6 + T10);
        if (T10 > 1.0e-15) begin
            e0 = -(T2 - T10) + T9 * T7;
            e1 = 1.0 - T9 * 0.5 * T6 / T7;
            T8 = T10 - (e0 / e1);
            T11 = expm1(-T8);
            T12 = sqrt(T11 + T8);
            qba = -T9 * T12 * Vtm;
        end else begin
            if (T10 < -1.0e-15) begin
                e0 = -(T2 - T10) - T9 * T7;
                e1 = 1.0 + T9 * 0.5 * T6 / T7;
                T8 = T10 - e0 / e1;
                T12a = expm1(-T8) + T8;
                T12 = T9 * sqrt(T12a);
            end else begin
                T8 = 0.0;
                T12 = 0.0;
            end
            qba = T12 * Vtm;
        end
        qi_acc_for_QM = T9 * lexp(-T8 / 2.0) * Vtm;
        psipclamp = 0.5 * (T8 + 1.0 + sqrt((T8 - 1.0) * (T8 - 1.0) + 0.25 * 2.0 * 2.0));
        sqrtpsip = sqrt(psipclamp);
        nq = 1.0 + T9 / sqrtpsip;
    end

    // Average surface potential / charge
    qia = 0.5 * (qis + qid);
    dqi = qis - qid;
    T0 = Vdseff * Vdseff / 6.25e-4;
    if (chargewf != 0.0) begin
        qia2 = 0.5 * (qis + qid) + chargewf * (1.0 - lexp(-T0)) * 0.5 * dqi;
    end else begin
        qia2 = 0.5 * (qis + qid);
    end

    // Toxeff model for quantum mechanical effects
    if (QMTCENCV_i > 0.0) begin
        T4 = qia / qm0;
        T5 = 1.0 + pow(T4, PQM_i);
        Tcen = Tcen0 / T5;
        coxeff = 1.0 / (1.0 / (cox * eot / toxp) + Tcen * QMTCENCV_i / epssub);
    end else begin
        coxeff = cox;
    end
    // Quantum mechanical effect correction for accumulation
    if (bulkmod != 0 && QMTCENCVA_i != 0.0) begin
        T6 = 1.0 + pow((qi_acc_for_QM / qm0acc), pqmacc);
        Tcen = Tcen0 / T6;
        cox_acc = 1.0 / (1.0 / cox_acc + Tcen * QMTCENCVA_i / epssub);
    end

    // Multiplication factor for I-V
    beta_v = u0_a * cox * Weff0 / Leff;

    // Mobility degradation
    Eeffm = EeffFactor * (qbs + eta_mu * qia2);
    if (cryomod == 0) begin
        T2 = pow((0.5 * (1.0 + qia2 / qb0)), UCS_t);
    end else begin
        T0 = Vdseff * Vdseff / 6.25e-4;
        T1 = 1.0 - lexp(-T0);
        T0 = (UDSeff_t * qis + UDDeff_t * qid) * T1;
        T1 = hypsmooth(T0, 1.0e-12);
        T2 = pow((0.5 * (1.0 + T1 / qb0)), UCS_t);
    end
    T0 = pow(Eeffm, EU_a);
    if (bulkmod != 0) begin
        T3 = (UA_a + UC_a * veseff) * T0 + UD_a / T2;
    end else begin
        T3 = UA_a * T0 + UD_a / T2;
    end
    Dmob = 1.0 + T3;
    Dmob = smoothminx(Dmob, 1.0, dmobclamp);
    u0mult_v = u0mult * (1 - muhc0 * lexp(-muhc1 * Vdseff));
    Dmob = Dmob / u0mult_v;
    ueff = u0_a / Dmob;

    // Mobility degradation for C-V
    if (cvmod == 1) begin
        if (cryomod == 0) begin
            T2 = pow((0.5 * (1.0 + qia2_cv / qb0)), UCS_t);
        end else begin
            T0 = UDSeff_t * qis_cv + UDDeff_t * qid_cv;
            T1 = hypsmooth(T0, 1.0e-12);
            T2 = pow((0.5 * (1.0 + T1 / qb0)), UCS_t);
        end
        Eeffm_cv = EeffFactor * (qbs + eta_mu_cv * qia2_cv);
        T3 = UACV_t * pow(Eeffm_cv, EU_a) + UDCV_t / T2;
    end else begin
        Eeffm_cv = EeffFactor * (qbs + eta_mu_cv * qia2);
        T3 = UA_a * pow(Eeffm_cv, EU_a) + UD_a / T2;
    end
    Dmob_cv = 1.0 + T3;
    Dmob_cv = smoothminx(Dmob_cv, 1.0, dmobclamp);
    Dmob_cv = Dmob_cv / u0mult_v;

    // CLM and DIBL effects
    tmp = DROUT_i * Leff / scl + 1.0e-6;
    if (tmp < 40.0) begin
        DIBLfactor = 0.5 * PDIBL1_a / (cosh(tmp) - 1.0) + PDIBL2_a;
    end else begin
        DIBLfactor = PDIBL1_a * lexp(-tmp) + PDIBL2_a;
    end
    if (PVAG_i > 0.0) begin
        PVAGfactor = 1.0 + PVAG_i * qia / EsatL;
    end else begin
        PVAGfactor = 1.0 / (1.0 - PVAG_i * qia / EsatL);
    end
    diffVds = vds - Vdseff;
    if (cryomod == 0) begin
        Vgst2Vtm = qia + 2.0 * Vtm;
    end else begin
        Vgst2Vtm = qia + 2.0 * Vtmeff;
    end
    if (DIBLfactor > 0.0) begin
        T1 = Vgst2Vtm;
        T3 = T1 / (Vdsat + T1);
        VaDIBL = T1 / DIBLfactor * T3 * PVAGfactor;
        Moc = 1.0 + diffVds / VaDIBL;
    end else begin
        Moc = 1.0;
    end
    if (PCLM_a > 0.0) begin
        if (PCLMG_i < 0.0) begin
            T1 = 1.0 / (1.0 / PCLM_a - PCLMG_i * qia);
        end else begin
            T1 = PCLM_a + PCLMG_i * qia;
        end
        Mclm = 1.0 + T1 * llnf(1.0 + (vds - Vdseff) / T1 / (Vdsat + EsatL));
    end else begin
        Mclm = 1.0;
    end
    Moc = Moc * Mclm;

    // Current degradation due to velocity saturation
    Esat1 = 2.0 * VSAT1_a / ueff;
    Esat1L = Esat1 * Leff;
    T0 = lexp(PSAT_i * llnf(dqi / Esat1L));
    T1 = 1.0 / PSAT_i;
    Ta = 1.0 + lexp(T1 * llnf(DELTAVSAT_i));
    Dvsat = (1.0 + lexp(T1 * llnf(DELTAVSAT_i + T0))) / Ta;
    Dvsat = Dvsat + 0.5 * PTWG_a * qia * dqi * dqi;

    // Non-saturation effect
    T0 = A1_t + A2_t / (qia + 2.0 * nVtm);
    T1 = T0 * dqi * dqi;
    T2 = T1 + 1.0 - 0.001;
    T3 = -1.0 + 0.5 * (T2 + sqrt(T2 * T2 + 0.004));
    Nsat = 0.5 * (1.0 + sqrt(1.0 + T3));
    Dvsat = Dvsat * Nsat;
    Dvsat = smoothminx(Dvsat, 1.0, dvsatclamp);

    // Lateral non-uniform doping effect (Vth shift between I-V and C-V)
    T1 = K0_t / (max(0.0, K0SI_t + K0SISAT_t * dqi * dqi) * qia + 2.0 * nVtm);
    Mnud = lexp(-T1);

    // Body effect for bulkmod = 2
    if (bulkmod == 2) begin
        T0 = hypsmooth((K2_t + K2SAT_t * vdsx), 1.0e-6);
        T1 = T0 / (max(0.0, K2SI_t + K2SISAT_t * dqi * dqi) * qia + 2.0 * nVtm);
        T3 = sqrt(PHIBE_i - veseff) - sqrt(PHIBE_i);
        Mob = lexp(-T1 * T3);
    end else begin
        Mob = 1.0;
    end

    // Velocity saturation for C-V
    if (cvmod == 1) begin
        EsatCV = 2.0 * VSATCV_t * Dmob_cv / u0_cv;
    end else begin
        EsatCV = 2.0 * VSATCV_t * Dmob_cv / u0_a;
    end
    EsatCVL = EsatCV * LeffCV;
    if (cvmod == 1) begin
        T0 = pow((dqi_cv / EsatCVL), PSATCV_i);
    end else begin
        T0 = pow((dqi / EsatCVL), PSATCV_i);
    end
    T1 = 1.0 / PSATCV_i;
    Ta = 1.0 + pow(DELTAVSATCV_i, T1);
    DvsatCV = (1.0 + pow((DELTAVSATCV_i + T0), T1)) / Ta;
    ASAT_i = smoothminx(ASAT_i, 0.1, 0.001);
    DvsatCV = DvsatCV * ASAT_i;

    // Channel Length Modulation for C-V
    if (PCLMCV_i != 0.0) begin
        MclmCV = 1.0 + PCLMCV_i * llnf(1.0 + (vds - Vdseff) / PCLMCV_i / (Vdsat + EsatCVL));
    end else begin
        MclmCV = 1.0;
    end

    // Fixed body charge qb_v
    qb_v = -`q * NBODY_i * Ach * LeffCV;

    // Quasi-static I-V model
    etaiv = q0 / (q0 + qia);
    ids0_ov_dqi = qia + (2.0 - etaiv) * nVtm;
    ids0 = ids0_ov_dqi * dqi;

    // Source/drain series resistance
    case (rdsmod)
        // Bias-dependent part of parasitic resistances is internal, bias-independent part is external
        0: begin
            Rsource = RSourceGeo;
            Rdrain = RDrainGeo;
            T4 = 1.0 + PRWGS_i * qia;
            T1 = 1.0 / T4;
            T0 = 0.5 * (T1 + sqrt(T1 * T1 + 0.01));
            Rdsi = rdstemp * (rdswmin + RDSW_i * T0) * WeffWRFactor;
            Dr = 1.0 + NFINtotal * beta_v * ids0_ov_dqi / (Dmob * Dvsat) * Rdsi;
        end
        // Both bias-dependent and bias-independent parts of parasitic resistances are external
        1: begin
            Rdsi = 0.0;
            Dr = 1.0;
            T2 = devsign * V(gi, si1) - vfbsd_v;
            T3 = sqrt(T2 * T2 + 0.1);
            vgs_eff = 0.5 * (T2 + T3);
            T4 = 1.0 + PRWGS_i * vgs_eff;
            T1 = 1.0 / T4;
            T0 = 0.5 * (T1 + sqrt(T1 * T1 + 0.01));
            T5 = RSW_i * (1.0 + RSDR_a * pow((V(s, si1) * V(s, si1) + 1.0e-6), (0.5 * prsdr)));
            Rsource = rdstemp * (RSourceGeo + (rswmin + T5 * T0) * WeffWRFactor);
            T2 = devsign * V(gi, di2) - vfbsd_v;
            T3 = sqrt(T2 * T2 + 0.1);
            vgd_eff = 0.5 * (T2 + T3);
            T4 = 1.0 + PRWGD_i * vgd_eff;
            T1 = 1.0 / T4;
            T0 = 0.5 * (T1 + sqrt(T1 * T1 + 0.01));
            T5 = RDW_i * (1.0 + RDDR_a * pow((V(d, di2) * V(d, di2) + 1.0e-6), (0.5 * prddr)));
            Rdrain = rdstemp * (RDrainGeo + (rdwmin + T5 * T0) * WeffWRFactor);
        end
        // Both bias-dependent and bias-independent parts of parasitic resistances are internal
        2: begin
            T4 = 1.0 + PRWGS_i * qia;
            T1 = 1.0 / T4;
            T0 = 0.5 * (T1 + sqrt(T1 * T1 + 0.01));
            Rdsi = rdstemp * ((rdswmin + RDSW_i * T0) * WeffWRFactor + RSourceGeo + RDrainGeo);
            Dr = 1.0 + NFINtotal * beta_v * ids0_ov_dqi / (Dmob * Dvsat) * Rdsi;
            Rsource = 0.0;
            Rdrain = 0.0;
        end
    endcase

    // Drain current
    ids_v = NFINtotal * beta_v * ids0 * Moc * Mnud * Mob / (Dmob * Dvsat * Dr);
    ids_v = ids_v * ids0mult;

    // Quasi-static C-V model
    if (cvmod == 1) begin
        T11 = (2.0 * qia_cv + nVtm) / DvsatCV;
        qg_v = qia_cv + dqi_cv * dqi_cv / (6.0 * T11);
        qd_v = -0.5 * (qia_cv - (dqi_cv / 6.0) * (1.0 - (dqi_cv / T11) * (1.0 + dqi_cv / (5.0 * T11))));
    end else begin
        T11 = (2.0 * qia + nVtm) / DvsatCV;
        qg_v = qia + dqi * dqi / (6.0 * T11);
        qd_v = -0.5 * (qia - (dqi / 6.0) * (1.0 - (dqi / T11) * (1.0 + dqi / (5.0 * T11))));
    end

    // CLM in qg_v and qd_v
    inv_MclmCV = 1.0 / MclmCV;
    qg_v = inv_MclmCV * qg_v + (MclmCV - 1.0) * qid;
    qd_v = inv_MclmCV * inv_MclmCV * qd_v + 0.5 * (MclmCV - inv_MclmCV) * qid;

    if (nqsmod == 2) begin
        xdpart = - qd_v / qg_v;
    end else begin
        xdpart = 0.0;
    end

    qs_v = -qg_v - qd_v;
    T6 = NFINtotal * WeffCV0 * LeffCV * coxeff;
    qg_v = T6 * qg_v;
    qd_v = T6 * qd_v;
    qs_v = T6 * qs_v;
    qinv = qg_v;

    if (bulkmod != 0) begin
        if (geomod == 5) begin
            T1 = NFINtotal * WeffCV_acc * LeffCV_acc * cox_acc;
        end else begin
            T1 = NFINtotal * WeffCV0 * LeffCV_acc * cox_acc;
        end
        T7 = qi_acc_for_QM;
        T10 = T7 * T1;
        qg_acc = -T10;
        qb_acc = T10;
        T1 = NFINtotal * WeffCV0 * LeffCV * cox;
        T2 = qba - qi_acc_for_QM;
        T10 = T1 * T2;
        qg_acc = qg_acc - T10;
        qb_acc = qb_acc + T10;
        T1 = NFINtotal * WeffCV0 * LeffCV * cox;
        T2 = (nq - 1.0) * 0.5 * (qia + (dqi * dqi / (6.0 * T11)));
        T10 = T1 * T2;
        qg_acc = qg_acc - T10;
        qb_acc = qb_acc + T10;
    end

    if (sigvds < 0.0) begin
        T1 = qd_v;
        qd_v = qs_v;
        qs_v = T1;
    end

    // Bias-dependent overlap capacitances
    if (cgeomod != 1) begin
        if (rgatemod != 2) begin
            T1 = NFINtotal * WeffCV0 * devsign;
            T2 = devsign * V(ge, si);
            T0 = T2 - vfbsdcv_v + `DELTA_1;
            vgs_overlap = 0.5 * (T0 - sqrt(T0 * T0 + 4.0 * `DELTA_1));
            qgs_ov = T1 * (CGSL_i * (T2 - vfbsdcv_v - vgs_overlap - 0.5 * CKAPPAS_i * (sqrt(1.0 - 4.0 * vgs_overlap / CKAPPAS_i) - 1.0)) + CGSO_i * T2);
            T2 = devsign * V(ge, di);
            T0 = T2 - vfbsdcv_v + `DELTA_1;
            vgd_overlap = 0.5 * (T0 - sqrt(T0 * T0 + 4.0 * `DELTA_1));
            qgd_ov = T1 * (CGDL_i * (T2 - vfbsdcv_v - vgd_overlap - 0.5 * CKAPPAD_i * (sqrt(1.0 - 4.0 * vgd_overlap / CKAPPAD_i) - 1.0)) + CGDO_i * T2);
        end else begin
            T1 = NFINtotal * WeffCV0 * devsign;
            T2 = devsign * V(gints, si);
            T0 = T2 - vfbsdcv_v + `DELTA_1;
            vgs_overlap = 0.5 * (T0 - sqrt(T0 * T0 + 4.0 * `DELTA_1));
            qgs_ov = T1 * (CGSL_i * (T2 - vfbsdcv_v - vgs_overlap - 0.5 * CKAPPAS_i * (sqrt(1.0 - 4.0 * vgs_overlap / CKAPPAS_i) - 1.0)) + CGSO_i * T2);
            T2 = devsign * V(gintd, di);
            T0 = T2 - vfbsdcv_v + `DELTA_1;
            vgd_overlap = 0.5 * (T0 - sqrt(T0 * T0 + 4.0 * `DELTA_1));
            qgd_ov = T1 * (CGDL_i * (T2 - vfbsdcv_v - vgd_overlap - 0.5 * CKAPPAD_i * (sqrt(1.0 - 4.0 * vgd_overlap / CKAPPAD_i) - 1.0)) + CGDO_i * T2);
        end
    end
    if (cgeomod == 0) begin
        if (rgatemod != 2) begin
            T1 = NFINtotal * WeffCV0;
            qgs_fr = T1 * CFS_i * V(ge, si);
            qgd_fr = T1 * CFD_i * V(ge, di);
            qgs_parasitic = qgs_ov + qgs_fr;
            qgd_parasitic = qgd_ov + qgd_fr;
        end else begin
            T1 = NFINtotal * WeffCV0;
            qgs_fr = T1 * CFS_i * V(gints, si);
            qgd_fr = T1 * CFD_i * V(gintd, di);
            qgs_parasitic = qgs_ov + qgs_fr;
            qgd_parasitic = qgd_ov + qgd_fr;
        end
    end else if (cgeomod == 1) begin
        if (rgatemod != 2) begin
            if (cgeo1sw == 1) begin
                T0 = NFINtotal * WeffCV0;
                COVS_i = T0 * COVS_i;
                COVD_i = T0 * COVD_i;
                cgsp_v = T0 * cgsp;
                cgdp_v = T0 * cgdp;
            end else begin
                cgsp_v = cgsp;
                cgdp_v = cgdp;
            end
            qgs_ov = COVS_i * V(ge, si);
            qgd_ov = COVD_i * V(ge, di);
            qgs_parasitic = qgs_ov;
            qgd_parasitic = qgd_ov;
            qgs_fr = cgsp_v * V(ge, s);
            qgd_fr = cgdp_v * V(ge, d);
        end else begin
            if (cgeo1sw == 1) begin
                T0 = NFINtotal * WeffCV0;
                COVS_i = T0 * COVS_i;
                COVD_i = T0 * COVD_i;
                cgsp_v = T0 * cgsp;
                cgdp_v = T0 * cgdp;
            end else begin
                cgsp_v = cgsp;
                cgdp_v = cgdp;
            end
            qgs_ov = COVS_i * V(gints, si);
            qgd_ov = COVD_i * V(gintd, di);
            qgs_parasitic = qgs_ov;
            qgd_parasitic = qgd_ov;
            qgs_fr = cgsp_v * V(gints, s);
            qgd_fr = cgdp_v * V(gintd, d);
        end
    end else begin
        if (rgatemod != 2) begin
            qgs_fr = Cfr_geo * V(ge, si);
            qgd_fr = Cfr_geo * V(ge, di);
            qgs_parasitic = qgs_ov + qgs_fr;
            qgd_parasitic = qgd_ov + qgd_fr;
        end else begin
            qgs_fr = Cfr_geo * V(gints, si);
            qgd_fr = Cfr_geo * V(gintd, di);
            qgs_parasitic = qgs_ov + qgs_fr;
            qgd_parasitic = qgd_ov + qgd_fr;
        end
    end

    //hvmod overlap charges
    if (hvmod == 1) begin
        K1_t = 1e-6;
        T9 = K1_t / (2.0 * nVtm) * sqrt(Vtm);
        T0 = T9 / 2.0;
        T2 = - (vgdrift - vfbdrifts) / Vtm;
        if ((T2 * Vtm) > phib + T9 * sqrt(phib * Vtm)) begin
            T1 = sqrt(T2 - 1.0 + T0 * T0) - T0;
            T10 = 1.0 + T1 * T1;
            T6 = lexp(-T10) - 1.0;
        end else begin
            T3 = T2 * 0.5 - 3.0 * (1.0 + T9 / sqrt(2.0));
            T10 = T3 + sqrt(T3 * T3 + 6.0 * T2);
            if (T2 < 0.0) begin
                T4 = (T2 - T10) / T9;
                T6 = -T10 + T4 * T4;
                T10 = -llnf(1.0 - T10 + T4 * T4);
            end else begin
                T11 = lexp(-1.2*T10);
                T4 = sqrt(T2 - 1.0 + T11 + T0 * T0) - T0;
                T10 = 1.0 - T11 + T4 * T4;
                T6  = lexp(-T10) - 1.0;
            end
        end
        T7 = sqrt(T6 + T10);
        if (T10 > 1.0e-15) begin
            e0 = -(T2 - T10) + T9 * T7;
            e1 = 1.0 - T9 * 0.5 * T6 / T7;
            T8 = T10 - (e0 / e1);
        end else begin
            if (T10 < -1.0e-15) begin
                e0 = -(T2 - T10) - T9 * T7;
                e1 = 1.0 + T9 * 0.5 * T6 / T7;
                T8 = T10 - e0 / e1;
            end else begin
                T8 = 0.0;
            end
        end
        qdrift_s = T9 * lexp(-T8 / 2.0) * Vtm;
        vdr_ov = abs(V(di1, si));
        Esat_ov = 2.0 * vsatdr / u0_a * Dmobs;
        EsatL_ov = Esat_ov * lover;
        inv_mexpdr = 1 / mexpdr;
        T6 = ksativdr * (qdrift_s + 2.0 * Vtmeff);
        Vdsat_ov = EsatL_ov * T6 / (EsatL_ov + T6);
        Vdsat_ov = hypsmooth((Vdsat_ov - 1.0e-3), 1.0e-5) + 1.0e-3;
        T7 = pow((vdr_ov / Vdsat_ov) + 1e-6, mexpdr);
        T8 = pow((1.0 + T7), inv_mexpdr);
        Vdseff_ov = min((vdr_ov / T8), vdr_ov);
        K1_t = 1e-6;
        T9 = K1_t / (2.0 * nVtm) * sqrt(Vtm);
        T0 = T9 / 2.0;
        T2 = - (vgdrift_s + Vdseff_ov - (vfbdriftd)) / Vtm;
        if ((T2 * Vtm) > phib + T9 * sqrt(phib * Vtm)) begin
            T1 = sqrt(T2 - 1.0 + T0 * T0) - T0;
            T10 = 1.0 + T1 * T1;
            T6 = lexp(-T10) - 1.0;
        end else begin
            T3 = T2 * 0.5 - 3.0 * (1.0 + T9 / sqrt(2.0));
            T10 = T3 + sqrt(T3 * T3 + 6.0 * T2);
            if (T2 < 0.0) begin
                T4 = (T2 - T10) / T9;
                T6 = -T10 + T4 * T4;
                T10 = -llnf(1.0 - T10 + T4 * T4);
            end else begin
                T11 = lexp(-1.2*T10);
                T4 = sqrt(T2 - 1.0 + T11 + T0 * T0) - T0;
                T10 = 1.0 - T11 + T4 * T4;
                T6  = lexp(-T10) - 1.0;
            end
        end
        T7 = sqrt(T6 + T10);
        if (T10 > 1.0e-15) begin
            e0 = -(T2 - T10) + T9 * T7;
            e1 = 1.0 - T9 * 0.5 * T6 / T7;
            T8 = T10 - (e0 / e1);
        end else begin
            if (T10 < -1.0e-15) begin
                e0 = -(T2 - T10) - T9 * T7;
                e1 = 1.0 + T9 * 0.5 * T6 / T7;
                T8 = T10 - e0 / e1;
            end else begin
                T8 = 0.0;
            end
        end
        qdrift_d = T9 * lexp(-T8 / 2.0) * Vtm;
        qdrift_diff = qdrift_s - qdrift_d;
        qdrift_a = (qdrift_s + qdrift_d) / 2;
        T11 = (2.0 * qdrift_a + nVtm) / Dvsat;
        qdrift = qdrift_a + qdrift_diff * qdrift_diff / (6.0 * T11);
        qdrift_D = 0.5 * (qdrift_a - (qdrift_diff / 6.0) * (1.0 - (qdrift_diff / T11) * (1.0 + qdrift_diff / (5.0 * T11))));
        qdrift_S = qdrift - qdrift_D;
        if (geomod == 5) begin
            T1 = NFINtotal * WeffCV_acc * (lover) * cox_acc;
        end else begin
            T1 = NFINtotal * WeffCV0 * (lover) * cox_acc;
        end
        T7 = qdrift_S;
        T8 = qdrift_D;
        T10 = T7 * T1;
        T11 = T8 * T1;
        qdrift_S = T10;
        qdrift_D = T11;
        qbov_s = qdrift_S;
        qbov = qdrift_D;
    end

    // Drain-to-source fringe capacitance
    qds_fr = cdsp * V(d, s);

    // Impact ionization current
    if (iimod == 1) begin
        T0 = (ALPHA0_t + ALPHA1_t * Leff) / Leff;
        if ((T0 <= 0.0) || (BETA0_t <= 0.0))
            Iii = 0.0;
        else begin
            T1 = -BETA0_t / (diffVds + 1.0e-30);
            Iii = T0 * diffVds * ids_v * lexp(T1);
        end
    end else if (iimod == 2) begin
        ALPHAII = (ALPHAII0_t + ALPHAII1_t * Leff) / Leff;
        if (ALPHAII <= 0.0) begin
            Iii = 0.0;
        end else begin
            T0 = ESATII_i * Leff;
            T1 = SII0_t * T0 / (1.0 + T0);
            T0 = 1.0 / (1.0 + hypsmooth((SII1_i * vgsfbeff), iimod2clamp1));
            T3 = T0 + SII2_i;
            T2 = hypsmooth((vgsfbeff * T3), iimod2clamp2);
            T3 = 1.0 / (1.0 + SIID_i * vds);
            VgsStep = T1 * T2 * T3;
            Vdsatii = VgsStep * (1.0 - LII_i / Leff);
            Vdiff = vds - Vdsatii;
            T0 = BETAII2_i + BETAII1_i * Vdiff + BETAII0_i * Vdiff * Vdiff;
            T1 = sqrt(T0 * T0 + 1.0e-10);
            Ratio = -hypmax(-ALPHAII * lexp(Vdiff / T1), -10.0, iimod2clamp3);
            Iii = Ratio * ids_v;
        end
    end

    // Gate currents, Ref: BSIM4
    // Igb calculation
    if (igbmod != 0) begin
        // Igbinv
        T1 = (qia - EIGBINV_i) / NIGBINV_i / Vtm;
        Vaux_Igbinv = NIGBINV_i * Vtm * ln_one_plus_exp(T1);
        T2 = hypmax(AIGBINV_t - BIGBINV_i * qia, -igbinvclamp, 1.0e-6);
        T3 = 1.0 + CIGBINV_i * qia;
        T4 = -9.82222e11 * toxg * T2 * T3;
        T5 = lexp(T4);
        T6 = 3.75956e-7;
        igbinv_v = Weff0 * Leff * T6 * Toxratio * vge * Vaux_Igbinv * T5;
        igbinv_v = igb0mult * igbinv_v * igtemp;
        // Igbacc
        vfbzb = deltaPhi - (Eg / 2.0) - phib;
        T0 = vfbzb - vge;
        T1 = T0 / NIGBACC_i / Vtm;
        Vaux_Igbacc = NIGBACC_i * Vtm * ln_one_plus_exp(T1);
        if (bulkmod != 0) begin
            Voxacc = qi_acc_for_QM;
        end else begin
            if (vfbzb <= 0.0) begin
                Voxacc = 0.5 * (T0 - 0.02 + sqrt((T0 - 0.02) * (T0 - 0.02) - 0.08 * vfbzb));
            end else begin
                Voxacc = 0.5 * (T0 - 0.02 + sqrt((T0 - 0.02) * (T0 - 0.02) + 0.08 * vfbzb));
            end
        end
        T2 = hypmax(AIGBACC_t - BIGBACC_i * Voxacc, -igbaccclamp, 1.0e-6);
        T3 = 1.0 + CIGBACC_i * Voxacc;
        T4 = -7.45669e11 * toxg * T2 * T3;
        T5 = lexp(T4);
        T6 = 4.97232e-7;
        igbacc_v = Weff0 * Leff * T6 * Toxratio * vge * Vaux_Igbacc * T5;
        igbacc_v = igb0mult * igbacc_v * igtemp;
    end
    // Igc calculation
    if (igcmod != 0) begin
        // Igcinv
        T1 = hypmax(AIGC_t - BIGC_i * qia, -igcinvclamp, 1.0e-6);
        T2 = 1.0 + CIGC_i * qia;
        T3 = -Bechvb * toxg * T1 * T2;
        T4 = qia * lexp(T3);
        T5 = (vge + 0.5 * vdsx + 0.5 * (ves_jct + ved_jct));
        igc0 = igc0mult * Weff0 * Leff * Aechvb * Toxratio * T4 * T5 * igtemp;
        // Gate-current partitioning
        Vdseffx = sqrt(Vdseff * Vdseff + 0.01) - 0.1;
        T1 = PIGCD_i * Vdseffx;
        T1_exp = lexp(-T1);
        T3 = T1 + T1_exp - 1.0 + 1.0e-4;
        T4 = 1.0 - (T1 + 1.0) * T1_exp + 1.0e-4;
        T5 = T1 * T1 + 2.0e-4;
        igcd_v = igc0 * T4 / T5;
        igcs_v = igc0 * T3 / T5;
        // Igs
        T0 = vgs_noswap - vfbsd_v;
        vgs_eff = sqrt(T0 * T0 + 1.0e-4);
        if (igclamp == 1) begin
            T1 = hypsmooth((AIGS_t - BIGS_i * vgs_eff), 1.0e-6);
            if (CIGS_i < 0.01) begin
                CIGS_i = 0.01;
            end
        end else begin
            T1 = AIGS_t - BIGS_i * vgs_eff;
        end
        T2 = 1.0 + CIGS_i * vgs_eff;
        T3 = -Bechvb * toxg * POXEDGE_i * T1 * T2;
        T4 = lexp(T3);
        if (sigvds > 0.0) begin
            igs_v = igsd_mult * dlcigs * vgs_noswap * vgs_eff * T4;
        end else begin
            igd_v = igsd_mult * dlcigs * vgs_noswap * vgs_eff * T4;
        end
        // Igd
        T0 = vgd_noswap - vfbsd_v;
        vgd_eff = sqrt(T0 * T0 + 1.0e-4);
        if (igclamp == 1) begin
            T1 = hypsmooth((AIGD_t - BIGD_i * vgd_eff), 1.0e-6);
            if (CIGD_i < 0.01) begin
                CIGD_i = 0.01;
            end
        end else begin
            T1 = AIGD_t - BIGD_i * vgd_eff;
        end
        T2 = 1.0 + CIGD_i * vgd_eff;
        T3 = -Bechvb * toxg * POXEDGE_i * T1 * T2;
        T4 = lexp(T3);
        if (sigvds > 0.0) begin
            igd_v = igsd_mult * dlcigd * vgd_noswap * vgd_eff * T4;
        end else begin
            igs_v = igsd_mult * dlcigd * vgd_noswap * vgd_eff * T4;
        end
    end

    // GIDL, GISL currents, Ref: BSIM4
    if (gidlmod != 0) begin
        T0 = epsratio * eot;
        // GIDL current
        if ((AGIDL_i <= 0.0) || (BGIDL_t <= 0.0)) begin
            T6 = 0.0;
        end else begin
            T1 = (-vgd_noswap - EGIDL_i + vfbsd_v) / T0;
            T1 = hypsmooth(T1, 1.0e-2);
            T2 = BGIDL_t / (T1 + 1.0e-3);
            T3 = pow(T1, PGIDL_i);
            if (bulkmod != 0) begin
                T4 = -ved_jct * ved_jct * ved_jct;
                T4a = CGIDL_i + abs(T4) + 1.0e-5;
                T5 = hypsmooth((T4 / T4a), 1.0e-6) - 1.0e-6;
                T6 = AGIDL_i * Weff0 * T3 * lexp(-T2) * T5;
            end else begin
                T6 = AGIDL_i * Weff0 * T3 * lexp(-T2) * vds_noswap;
            end
        end
        // Trap Assisted Tunneling GIDL
        if (gidlmod == 3 && ATATD_i > 0.0) begin
            if (bulkmod != 0) begin
                CTATD_t = CTATD_i * hypsmooth((1.0 + TTAT_i * delTemp - 1.0e-6), 1.0e-3);
                T1 = (BTATD_i * vgd_noswap * vgd_noswap - CTATD_t * vgd_noswap - DTATD_i + vfbsd_v) / Vtm;
                T2 = ATATD_i * Weff0 * ni * lexp(T1);
                T4 = -ved_jct * ved_jct * ved_jct;
                T4a = CGIDL_i + abs(T4) + 1.0e-5;
                T5 = hypsmooth((T4 / T4a), 1.0e-6) - 1.0e-6;
                T6 = T6 + T2 * T5;
            end else begin
                CTATD_t = CTATD_i * hypsmooth((1.0 + TTAT_i * delTemp - 1.0e-6), 1.0e-3);
                T1 = (BTATD_i * vgd_noswap * vgd_noswap - CTATD_t * vgd_noswap - DTATD_i + vfbsd_v) / Vtm;
                T2 = ATATD_i * Weff0 * ni * lexp(T1);
                T6 = T6 + T2 * vds_noswap;
            end
        end
        // Parasitic substrate GIDL
        if (bulkmod != 0 && (gidlmod == 2 || gidlmod == 3) && (geomod == 2 || geomod == 3 || geomod == 5)) begin
            BGIDLB_t = BGIDLB_i * hypsmooth((1.0 + TGIDL_i * delTemp - 1.0e-6), 1.0e-3);
            if ((AGIDLB_i <= 0.0) || (BGIDLB_t <= 0.0)) begin
                T7 = 0.0;
            end else begin
                T1 = (-vgd_noswap - EGIDLB_i + vfbsd_v) / T0;
                T1 = hypsmooth(T1, 1.0e-2);
                T2 = BGIDLB_t / (T1 + 1.0e-3);
                T3 = pow(T1, PGIDLB_i);
                T4 = -ved_jct * ved_jct * ved_jct;
                T4a = CGIDLB_i + abs(T4) + 1.0e-5;
                T5 = hypsmooth((T4 / T4a), 1.0e-6) - 1.0e-6;
                T7 = AGIDLB_i * WeffB * T3 * lexp(-T2) * T5;
            end
        end
        if (sigvds > 0.0) begin
            igidl_v = T6;
            igidlb = T7;
        end else begin
            igisl_v = T6;
            igislb = T7;
        end
        // GISL current
        if ((AGISL_i <= 0.0) || (BGISL_t <= 0.0)) begin
            T6 = 0.0;
        end else begin
            T1 = (-vgs_noswap - EGISL_i + vfbsd_v) / T0;
            T1 = hypsmooth(T1, 1.0e-2);
            T2 = BGISL_t / (T1 + 1.0e-3);
            T3 = pow(T1, PGISL_i);
            if (bulkmod != 0) begin
                T4 = -ves_jct * ves_jct * ves_jct;
                T4a = CGISL_i + abs(T4) + 1.0e-5;
                T5 = hypsmooth((T4 / T4a), 1.0e-6) - 1.0e-6;
                T6 = AGISL_i * Weff0 * T3 * lexp(-T2) * T5;
            end else begin
                T6 = AGISL_i * Weff0 * T3 * lexp(-T2) * (-vds_noswap);
            end
        end
        // Trap Assisted Tunneling GISL
        if (gidlmod == 3 && ATATS_i > 0.0) begin
            if (bulkmod != 0) begin
                CTATS_t=  CTATS_i*hypsmooth((1.0 + TTAT_i * delTemp - 1.0e-6), 1.0e-3);
                T1 = (BTATS_i * vgs_noswap * vgs_noswap - CTATS_t * vgs_noswap - DTATS_i + vfbsd_v) / Vtm;
                T2 = ATATS_i * Weff0 * ni * lexp(T1);
                T4 = -ves_jct * ves_jct * ves_jct;
                T4a = CGISL_i + abs(T4) + 1.0e-5;
                T5 = hypsmooth((T4 / T4a), 1.0e-6) - 1.0e-6;
                T6 = T6 + T2 * T5;
            end else begin
                CTATS_t=  CTATS_i*hypsmooth((1.0 + TTAT_i * delTemp - 1.0e-6), 1.0e-3);
                T1 = (BTATS_i * vgs_noswap * vgs_noswap - CTATS_t * vgs_noswap - DTATS_i + vfbsd_v) / Vtm;
                T2 = ATATS_i * Weff0 * ni * lexp(T1);
                T6 = T6 + T2 * (-vds_noswap);
            end
        end
        // Parasitic substrate GISL
        if (bulkmod != 0 && (gidlmod == 2 || gidlmod == 3) && (geomod == 2 || geomod == 3 || geomod == 5)) begin
            BGISLB_t = BGISLB_i * hypsmooth((1.0 + TGIDL_i * delTemp - 1.0e-6), 1.0e-3);
            if ((AGISLB_i <= 0.0) || (BGISLB_t <= 0.0)) begin
                T7 = 0.0;
            end else begin
                T1 = (-vgs_noswap - EGISLB_i + vfbsd_v) / T0;
                T1 = hypsmooth(T1, 1.0e-2);
                T2 = BGISLB_t / (T1 + 1.0e-3);
                T3 = pow(T1, PGISLB_i);
                T4 = -ves_jct * ves_jct * ves_jct;
                T4a = CGISLB_i + abs(T4) + 1.0e-5;
                T5 = hypsmooth((T4 / T4a), 1.0e-6) - 1.0e-6;
                T7 = AGISLB_i * WeffB * T3 * lexp(-T2) * T5;
            end
        end
        if (sigvds > 0.0) begin
            igisl_v = T6;
            igislb = T7;
        end else begin
            igidl_v = T6;
            igidlb = T7;
        end
    end

    // Junction currents
    if (bulkmod != 0) begin
        // Source-side junction current
        if (Isbs > 0.0) begin
            if (ves_jct < VjsmRev) begin
                T0 = ves_jct / Nvtms;
                T1 = lexp(T0) - 1.0;
                T2 = IVjsmRev + SslpRev * (ves_jct - VjsmRev);
                Ies = T1 * T2;
            end else if (ves_jct <= VjsmFwd) begin
                T0 = ves_jct / Nvtms;
                T1 = (bvs + ves_jct) / Nvtms;
                T2 = lexp(-T1);
                Ies = Isbs * (lexp(T0) + XExpBVS - 1.0 - xjbvs * T2);
            end else begin
                Ies = IVjsmFwd + SslpFwd * (ves_jct - VjsmFwd);
            end
        end else begin
            Ies = 0.0;
        end
        // Source-side junction tunneling current
        if (JTSS_t > 0.0) begin
            if ((vtss - ves_jct) < (vtss * 1.0e-3)) begin
                T0 = -ves_jct / Vtm0 / NJTS_t;
                T1 = lexp(T0 * 1.0e3) - 1.0;
                Ies = Ies - asej * JTSS_t * T1;
            end else begin
                T0 = -ves_jct / Vtm0 / NJTS_t;
                T1 = lexp(T0 * vtss / (vtss - ves_jct)) - 1.0;
                Ies = Ies - asej * JTSS_t * T1;
            end
        end
        if (JTSSWS_t > 0.0) begin
            if ((vtssws - ves_jct) < (vtssws * 1.0e-3)) begin
                T0 = -ves_jct / Vtm0 / NJTSSW_t;
                T1 = lexp(T0 * 1.0e3) - 1.0;
                Ies = Ies - psej * JTSSWS_t * T1;
            end else begin
                T0 = -ves_jct / Vtm0 / NJTSSW_t;
                T1 = lexp(T0 * vtssws / (vtssws - ves_jct)) - 1.0;
                Ies = Ies - psej * JTSSWS_t * T1;
            end
        end
        if (JTSSWGS_t > 0.0) begin
            if ((vtsswgs - ves_jct) < (vtsswgs * 1.0e-3)) begin
                T0 = -ves_jct / Vtm0 / NJTSSWG_t;
                T1 = lexp(T0 * 1.0e3) - 1.0;
                Ies = Ies - tfin * NFINtotal * JTSSWGS_t * T1;
            end else begin
                T0 = -ves_jct / Vtm0 / NJTSSWG_t;
                T1 = lexp(T0 * vtsswgs / (vtsswgs - ves_jct)) - 1.0;
                Ies = Ies - tfin * NFINtotal * JTSSWGS_t * T1;
            end
        end
        // Drain-side junction current
        if (Isbd > 0.0) begin
            if (ved_jct < VjdmRev) begin
                T0 = ved_jct / Nvtmd;
                T1 = lexp(T0) - 1.0;
                T2 = IVjdmRev + DslpRev * (ved_jct - VjdmRev);
                Ied = T1 * T2;
            end else if (ved_jct <= VjdmFwd) begin
                T0 = ved_jct / Nvtmd;
                T1 = (bvd + ved_jct) / Nvtmd;
                T2 = lexp(-T1);
                Ied = Isbd * (lexp(T0) + XExpBVD - 1.0 - xjbvd * T2);
            end else begin
                Ied = IVjdmFwd + DslpFwd * (ved_jct - VjdmFwd);
            end
        end else begin
            Ied = 0.0;
        end
        // Drain-side junction tunneling current
        if (JTSD_t > 0.0) begin
            if ((vtsd - ved_jct) < (vtsd * 1.0e-3)) begin
                T0 = -ved_jct / Vtm0 / NJTSD_t;
                T1 = lexp(T0 * 1.0e3) - 1.0;
                Ied = Ied - adej * JTSD_t * T1;
            end else begin
                T0 = -ved_jct / Vtm0 / NJTSD_t;
                T1 = lexp(T0 * vtsd/ (vtsd - ved_jct)) - 1.0;
                Ied = Ied - adej * JTSD_t * T1;
            end
        end
        if (JTSSWD_t > 0.0) begin
            if ((vtsswd - ved_jct) < (vtsswd * 1.0e-3)) begin
                T0 = -ved_jct / Vtm0 / NJTSSWD_t;
                T1 = lexp(T0 * 1.0e3) - 1.0;
                Ied = Ied - pdej * JTSSWD_t * T1;
            end else begin
                T0 = -ved_jct / Vtm0 / NJTSSWD_t;
                T1 = lexp(T0 * vtsswd / (vtsswd - ved_jct)) - 1.0;
                Ied = Ied - pdej * JTSSWD_t * T1;
            end
        end
        if (JTSSWGD_t > 0.0) begin
            if ((vtsswgd - ved_jct) < (vtsswgd * 1.0e-3)) begin
                T0 = -ved_jct / Vtm0 / NJTSSWGD_t;
                T1 = lexp(T0 * 1.0e3) - 1.0;
                Ied = Ied - tfin * NFINtotal * JTSSWGD_t * T1;
            end else begin
                T0 = -ved_jct / Vtm0 / NJTSSWGD_t;
                T1 = lexp(T0 * vtsswgd / (vtsswgd - ved_jct)) - 1.0;
                Ied = Ied - tfin * NFINtotal * JTSSWGD_t * T1;
            end
        end
        // Source-to-substrate junction capacitance
        `junction_cap(juncaps1, ves_jct, vec1s, pb21s, Czbs, PBS_t, sjs, mjs, mjs2, Qesj1)
        `junction_cap(juncaps2, ves_jct, vec2s, pb22s, Czbssw, PBSWS_t, sjsws, mjsws, mjsws2, Qesj2)
        `junction_cap(juncaps3, ves_jct, vec3s, pb23s, Czbsswg, PBSWGS_t, sjswgs, mjswgs, mjswgs2, Qesj3)
        Qesj = Qesj1 + Qesj2 + Qesj3;
        // Drain-to-substrate junction capacitance
        `junction_cap(juncapd1, ved_jct, vec1d, pb21d, Czbd, PBD_t, sjd, mjd, mjd2, Qedj1)
        `junction_cap(juncapd2, ved_jct, vec2d, pb22d, Czbdsw, PBSWD_t, sjswd, mjswd, mjswd2, Qedj2)
        `junction_cap(juncapd3, ved_jct, vec3d, pb23d, Czbdswg, PBSWGD_t, sjswgd, mjswgd, mjswgd2, Qedj3)
        Qedj = Qedj1 + Qedj2 + Qedj3;
    end
    Qes = Qesj + csbox * ves_jct;
    Qed = Qedj + cdbox * ved_jct;

    // Gate-to-substrate parasitic capacitance
    // Bias-independent component
    Qeg = cgbox * devsign * V(e, ge);
    // Bias-dependent component
    if (bulkmod != 0) begin
        T2 = devsign * V(ge, e);
        T3 = T2 - deltaPhi + Eg / 2.0 + phib - delvfbacc;
        T0 = T3 + `DELTA_1;
        vge_overlap = 0.5 * (T0 + sqrt(T0 * T0 + 4.0 * `DELTA_1));
        Qeg = Qeg - NFINtotal * LeffCV * (CGBL_i * (T3 - vge_overlap + 0.5 * CKAPPAB_i * (sqrt(1.0 + 4.0 * vge_overlap / CKAPPAB_i) - 1.0)));
    end

    // Generation-recombination component
    T1 = vds * (AIGEN_i + BIGEN_i * vds * vds);
    idsgen_v = hfin * tfin * (Leff - 2.0 * LINTIGEN_i) * igentemp * T1;

    // NQS gate resistance, Ref: BSIM4
    T0 = ueff * coxeff * Weff0 / Leff;
    if (nqsmod != 0 && XRCRG1_i != 0.0) begin
        IdovVds = beta_v * ids0_ov_dqi * Moc / (Dmob * Dvsat * Dr);
        gcrg = NFINtotal * XRCRG1_i * (IdovVds + XRCRG2_i * Vtm * T0);
    end
    if (nqsmod == 2) begin
        gtau = 1e-9 * gcrg / (cox * Weff0 * Leff);
    end

    // Multiply all current and charge components by NFINtotal
    igidl_v = NFINtotal * igidl_v;
    igisl_v = NFINtotal * igisl_v;
    igidlb = NFINtotal * igidlb;
    igislb = NFINtotal * igislb;
    igcd_v = NFINtotal * igcd_v;
    igcs_v = NFINtotal * igcs_v;
    igs_v = NFINtotal * igs_v;
    igd_v = NFINtotal * igd_v;
    igbinv_v = NFINtotal * igbinv_v;
    igbacc_v = NFINtotal * igbacc_v;
    idsgen_v = NFINtotal * idsgen_v;

    // Gate-to-substrate tunneling current empirical partition
    if (bulkmod == 0) begin
        igbs_v = (igbinv_v + igbacc_v) * wf;
        igbd_v = (igbinv_v + igbacc_v) * wr_v;
    end

    // Transconductance
    ids = devsign * ids_v;
    gm = ddx(ids, V(gi));
    // Noise model
// ---- begin `include "bsimcmg_noise.include" ----
// *  BSIM-CMG 112.1.0 released on 04/28/2026                            *
// *  BSIM Common Multi-Gate Model (Verilog-A)                                *
// ****************************************************************************

// ****************************************************************************
// *  Copyright © 2026 University of California                               *
// *                                                                          *
// *  Project director: Prof. Sayeef Salahuddin                               *
// *                    Prof. Chenming Hu                                     *
// *                                                                          *
// *  Developers: https://www.bsim.berkeley.edu/models/bsimcmg/auth_cmg/      *
// ****************************************************************************

// Noise model
Esatnoi = 2.0 * VSAT_a / ueff;

// Flicker noise (Ref: BSIM4 Model from K. K. Hung et al. TED 1990 and P. Kushwaha et al. EDL June 2019)
if (noia > 0.0 || noib > 0.0 || noic > 0.0) begin
    Leffnoi = Leff - 2.0 * lintnoi;
    if (Leffnoi <= 0.0) begin
        $strobe("Warning: lintnoi = %g is too large to have positive Leff for noise. Set lintnoi = 0.", lintnoi);
        Leffnoi = Leff;
    end
    if (fnmod == 1 || fnmod == 0) begin
        Leffnoisq = Leffnoi * Leffnoi;
        if (em > 0.0) begin
            T0 = (diffVds / litl + em) / Esatnoi;
            DelClm = litl * llnf(T0);
        end else begin
            DelClm = 0.0;
        end
        if (fnmod == 1) begin
            T1 = qia2/QSREF_i;
            T2 = 1 + pow(T1, MPOWER_i);
            T3 = NOIA2_i/T2;
            T4 = T3 / noia;
            T5 = 0.5 * (T4 + 1 + sqrt((T4 - 1) * (T4 - 1) + 0.25 * smooth * smooth));
            NOIAeff = noia * T5;
        end else begin
            NOIAeff = noia;
        end
        T1 = `q * `q * `q * Vtm * abs(ids_v) * ueff;
        T2 = 1.0e10 * coxeff * Leffnoisq;
        N0 = coxeff * qis / `q;
        Nl = coxeff * qid / `q;
        Nstar = Vtm / `q * (coxeff + CIT_a);
        T3 = NOIAeff * llnf((N0 + Nstar) / (Nl + Nstar));
        T4 = noib * (N0 - Nl);
        T5 = 0.5 * noic * (N0 * N0 - Nl * Nl);
        T6 = `q * Vtm * ids_v * ids_v;
        T7 = 1.0e10 * Leffnoisq * Weff0 * NFINtotal;
        T8 = NOIAeff + noib * Nl + noic * Nl * Nl;
        T9 = (Nl + Nstar) * (Nl + Nstar);
        Ssi = T1 / T2 * (T3 + T4 + T5) + T6 / T7 * DelClm * T8 / T9;
        T10 = NOIAeff * `q * Vtm;
        T11 = Weff0 * NFINtotal * Leffnoi * 1.0e10 * Nstar * Nstar;
        Swi = T10 / T11 * ids_v * ids_v;
        T1 = Swi + Ssi;
        if (T1 > 0.0) begin
            FNPowerAt1Hz = (Ssi * Swi) / T1;
        end else begin
            FNPowerAt1Hz = 0.0;
        end
    end else if (fnmod == 2) begin
        T1 = qia2/QSREF_i;
        T2 = 1 + pow(T1, MPOWER_i);
        T3 = NOIA2_i/T2;
        T4 = T3 / noia;
        T5 = 0.5 * (T4 + 1 + sqrt((T4 - 1) * (T4 - 1) + 0.25 * smooth * smooth));
        NOIAeff = noia * T5;
        lambdac_fn2 = 2.0 * Vtm / EsatL;
        T1 = 1.0 + lambdac_fn2 * dqi;
        T2 = 1.0 + k0noi * dqi;
        NeffT = NOIAeff + noib * qia + noic * qia * qia;
        if (T1 > 0.0 && T2 > 0.0) begin
            DrainFac = pow(T2, -k1noi);
            T3 = llnf( (qis + 0.5) / ( qid + 0.5 ) ) * ( qis + qid + 1 );
            T4 = 2 * (qis - qid);
            FNPowerAt1Hz = ( T3 / T4 ) * (`P_Q * `P_Q * `P_Q * Vtm) * gm * gm * NeffT * DrainFac / (1.0e14 * cox * cox * Weff0 * Weff0 * Leffnoi * NFINtotal);
        end else begin
            FNPowerAt1Hz = 0.0;
        end
    end
end else begin
    FNPowerAt1Hz = 0.0;
end

// Thermal noise
case (tnoimod)
    // Charge-based thermal noise model, Ref: BSIM4
    0: begin
        T0 = ueff * qinv;
        T1 = T0 * Rdsi + Leff * Leff;
        Gtnoi = (T0 / T1) * ntnoi;
        sid = 4.0 * Vtm * `q * Gtnoi;
    end
    // Correlated thermal noise model, Ref: Chap. 6 of Darsen Lu's Ph.D. thesis
    1: begin
        T0 = qia / EsatL;
        T0 = T0 * T0;
        // Empirical parameters for short-channel excess noise
        noiBeta = rnoia * (1.0 + T0 * tnoia * Leff);
        noiTheta = rnoib * (1.0 + T0 * tnoib * Leff);
        noiCorr = rnoic * (1.0 + T0 * tnoic * Leff);
        noiLowId = rnoik * (1.0 + T0 * tnoik * Leff);
        // T1, T2, T3 are all 1.0 by default
        T1 = 3.0 * noiBeta * noiBeta;
        T2 = 7.5 * noiTheta * noiTheta;
        T3 = 2.5298 * noiCorr;
        // Theoretical equations
        noiEta = (qid / qis) * (1.0 - Vdseff / Vdsat);
        Dvsat3 = Dvsat * Dvsat * Dvsat;
        noiWI = q0 / (q0 + qia);
        // Mnud at Vds = 0

        T4 = K0_t / (max(0.0, K0SI_t) * qis + 2.0 * nVtm);
        Mnud0 = lexp(-T4);

        // Mob at Vds = 0
        if (bulkmod == 2) begin
            T4 = hypsmooth(K2_t, 1.0e-6);
            T5 = T4 / (max(0.0, K2SI_t) * qis + 2.0 * nVtm);
            T6 = sqrt(PHIBE_i - veseff) - sqrt(PHIBE_i);
            Mob0 = lexp(-T5 * T6);
        end else begin
            Mob0 = 1.0;
        end
        // Dmob at Vds = 0
        Eeffm0 = EeffFactor * (qba + eta_mu * qis);
        T4 = pow(0.5 * (1.0 + abs(qis / qb0)), UCS_t);
        if (bulkmod != 0) begin
            T5 = (UA_a + UC_a * veseff) * pow(abs(Eeffm0), EU_a) + UD_a / T4;
        end else begin
            T5 = UA_a * pow(abs(Eeffm0), EU_a) + UD_a / T4;
        end
        Dmob0 = 1.0 + T5;
        Dmob0 = smoothminx(Dmob0, 1.0, dmobclamp);
        Dmob0 = Dmob0 / u0mult;
        // Dvsat at Vds = 0
        Dvsat0 = 1.0 + 0.25 * dvsatclamp;
        // ids0_ov_dqi at Vds = 0
        etaiv0 = q0 / (q0 + qis);
        T4 = (2.0 - etaiv0) * nVtm;
        ids0_ov_dqi0 = qis + T4;
        // Dr at Vds = 0
        case (rdsmod)
            0: begin
                T4 = 1.0 + PRWGS_i * qis;
                T5 = 1.0 / T4;
                T6 = 0.5 * (T5 + sqrt(T5 * T5 + 0.01));
                Rdsi0 = rdstemp * (rdswmin + RDSW_i * T6) * WeffWRFactor;
                Dr0 = 1.0 + NFINtotal * beta_v * ids0_ov_dqi0 / (Dmob0 * Dvsat0) * Rdsi0;
            end
            1: begin
                Dr0 = 1.0;
            end
            2: begin
                T4 = 1.0 + PRWGS_i * qis;
                T5 = 1.0 / T4;
                T6 = 0.5 * (T5 + sqrt(T5 * T5 + 0.01));
                Rdsi0 = (rdswmin + RDSW_i * T6) * WeffWRFactor;
                Rdsi0 = rdstemp * (RSourceGeo + RDrainGeo +  Rdsi0);
                Dr0 = 1.0 + NFINtotal * beta_v * ids0_ov_dqi0 / (Dmob0 * Dvsat0) * Rdsi0;
            end
        endcase
        // Gds at Vds = 0, Moc will always be 1.0 at Vds = 0
        noiGd0 = NFINtotal * beta_v * qis * Mnud0 * Mob0 / (Dmob0 * Dvsat0 * Dr0);
        T4 = 1.0 + noiEta;
        T5 = 1.0 - noiEta;
        T6 = (2.0 * noiWI) / qis * nVtm;
        T7 = T4 + T6;
        T5_2 = T5 * T5;
        T5_3 = T5_2 * T5;
        T5_4 = T5_3 * T5;
        T7_2 = T7 * T7;
        T7_3 = T7_2 * T7;
        T7_4 = T7_3 * T7;
        T7_5 = T7_4 * T7;
        // Theoretical Sid for long-channel devices
        gamma1 = 0.5 * T4;
        gamma2 = T5_2 / (6.0 * T7);
        gamma = (Moc / Dvsat) * (gamma1 + gamma2);
        // Theoretical Sig for long-channel devices
        delta1 = T4 / T7_2;
        delta2 = (6.0 * T4 + T6) * T5_2 / (15.0 * T7_4);
        delta3 = T5_4 / (9.0 * T7_5);
        delta = (Moc / 6.0) * Dvsat3 * (delta1 - delta2 + delta3);
        // Theoretical correlated noise between Sid and Sig for long-channel devices
        epsilon1 = T5 / T7;
        epsilon2 = T5_3 / (3.0 * T7_3);
        epsilon = (Moc / 6.0) * Dvsat * (epsilon1 - epsilon2);
        // Empirical tuning of correlation coefficient between Sid and Sig by T3
        // ctnoi = 1: fully correlated; ctnoi = 0: uncorrelated
        ctnoi = T3 * epsilon / sqrt(gamma * delta);
        if (ctnoi > 1.0) begin
            ctnoi = 1.0;
        end else if (ctnoi < 0.0) begin
            ctnoi = 0.0;
        end
        // Empirical tuning of Sid, T1: saturation region, T8: subthreshold and linear region
        T8 = 1.0 + noiLowId * noiLowId / (tnoik2 + qia) * (Vdseff / Vdsat);
        gamma = (Moc / Dvsat) * (T8 * gamma1 + T1 * gamma2);
        // Sid level
        sid = 4.0 * Vtm * `q * gamma * noiGd0;
        // Empirical tuning of Sig by T2, rnoib = 0 turns Sig off
        delta = (Moc / 6.0) * Dvsat3 * T2 * (delta1 - delta2 + delta3);
        // Sig ratio to Sid
        sigrat = sqrt(delta / gamma) * NFINtotal * coxeff * WeffCV0 * LeffCV / noiGd0;
    end
endcase
// ---- end `include "bsimcmg_noise.include" ----

    // Loading Ids, gate and drain charges
    if (sigvds > 0.0) begin
        I(di, si) <+ devsign * ids_v;
    end else begin
        I(si, di) <+ devsign * ids_v;
    end
    if (nqsmod == 2) begin
        I(gi, si) <+ devsign * gtau * -V(q);
        I(di, si) <+ devsign * xdpart * gtau * V(q);
    end else begin
        I(di, si) <+ devsign * ddt(qd_v);
        I(gi, si) <+ devsign * ddt(qg_v);
    end
    if (hvmod == 1) begin
        I(di1, di) <+ V(di1,di)*1e3;
    end else begin
        V(di1, di) <+ 0.0;
    end

    // Loading other currents
    if (sigvds > 0.0) begin
        I(di, si) <+ devsign * idsgen_v;
        I(gi, si) <+ devsign * (igcs_v + igs_v);
        I(gi, di) <+ devsign * (igcd_v + igd_v);
        if (bulkmod != 0) begin
            if (gidlmod == 2 && (geomod == 2 || geomod == 3 || geomod == 5)) begin
                I(di, si) <+ devsign * (igidl_v + Iii);
                I(si, di) <+ devsign * igisl_v;
                I(di, e) <+ devsign * igidlb;
                I(si, e) <+ devsign * igislb;
            end else begin
                I(di, e) <+ devsign * (igidl_v + Iii);
                I(si, e) <+ devsign * igisl_v;
            end
            I(gi, e) <+ devsign * (igbinv_v + igbacc_v);
        end else begin
            I(di, si) <+ devsign * (igidl_v + Iii);
            I(si, di) <+ devsign * igisl_v;
        end
    end else begin
        I(si, di) <+ devsign * idsgen_v;
        I(gi, di) <+ devsign * (igcs_v + igs_v);
        I(gi, si) <+ devsign * (igcd_v + igd_v);
        if (bulkmod != 0) begin
            if (gidlmod == 2 && (geomod == 2 || geomod == 3 || geomod == 5)) begin
                I(si, di) <+ devsign * (igidl_v + Iii);
                I(di, si) <+ devsign * igisl_v;
                I(si, e) <+ devsign * igidlb;
                I(di, e) <+ devsign * igislb;
            end else begin
                I(si, e) <+ devsign * (igidl_v + Iii);
                I(di, e) <+ devsign * igisl_v;
            end
            I(gi, e) <+ devsign * (igbinv_v + igbacc_v);
        end else begin
            I(si, di) <+ devsign * (igidl_v + Iii);
            I(di, si) <+ devsign * igisl_v;
        end
    end
    if (bulkmod == 0) begin
        I(gi, si) <+ devsign * igbs_v;
        I(gi, di) <+ devsign * igbd_v;
    end
    if (bulkmod != 0) begin
        I(e, si) <+ devsign * Ies + V(e, si) * gmin;
        I(e, di) <+ devsign * Ied + V(e, di) * gmin;
    end
    I(e, si) <+ devsign * ddt(Qes);
    I(e, di) <+ devsign * ddt(Qed);
    I(e, ge) <+ devsign * ddt(Qeg);

    // Loading other charges
    if (rgatemod != 2) begin
        I(ge, si) <+ ddt(qgs_parasitic);
        if (hvmod == 1) begin
            I(ge, di1) <+ ddt(qgd_parasitic);
            I(ge, di1) <+ devsign * ddt(qbov);
            I(ge, di) <+ devsign * ddt(qbov_s);
        end else begin
            I(ge, di) <+ ddt(qgd_parasitic);
        end
        I(d, s) <+ ddt(qds_fr);
        if (cgeomod == 1) begin
            I(ge, s) <+ ddt(qgs_fr);
            I(ge, d) <+ ddt(qgd_fr);
        end
    end else begin
        I(gints, si) <+ ddt(qgs_parasitic);
        if (hvmod == 1) begin
            I(gintd, di1) <+ ddt(qgd_parasitic);
            I(gintd, di1) <+ devsign * ddt(qbov);
            I(gintd, di) <+ devsign * ddt(qbov_s);
        end else begin
            I(gintd, di) <+ ddt(qgd_parasitic);
        end
        I(d, s) <+ ddt(qds_fr);
        if (cgeomod == 1) begin
            I(gints, s) <+ ddt(qgs_fr);
            I(gintd, d) <+ ddt(qgd_fr);
        end
    end

    // Accumulation charge for bulk FET
    if (bulkmod != 0) begin
        I(gi, si) <+ devsign * ddt(qg_acc);
        I(e, si) <+ devsign * ddt(qb_acc);
    end

    // Velocity saturation in source/drain resistances
    if (rdsmod == 1) begin
        if (rdlcw > 0) begin
            rdstempvs = hypsmooth((1.0 + prtvsrsd * delTemp - 1.0e-6), 1.0e-3);
            `tempdep(VSATRSD_t, vsatrsd, -atvsrsd)
            T0 = qis - ptwg1vsrsd;
            T0 = smoothminx(T0, 0.1, 2.0);
            T1  = 10.0 * psatxvsrsd * T0 / (10.0 * psatxvsrsd + T0);
            vsatrsd_eff = VSATRSD_t * (1.0 + ptwgvsrsd * T1);
            vsatrsd_eff = hypsmooth(vsatrsd_eff, 10.0);
            T2 = NFINtotal * Weff0 * `q * vsatrsd_eff;
            T5 = abs(V(di2, di1));
            if (gavsrd == 0) begin
                T3 = 1.0;
            end else begin
                T3 = smoothminx((T5 - rdvds), 0, 0.5);
                T3 = 1.0 + T3 * gavsrd;
            end
            isat_rd = T2 * nvsrd * T3;
            T4 = rdstempvs * rdlcw * WeffWRFactor;
            vsat_rd = isat_rd * T4;
            delta_vsrd = pow(T5, 4 - mvsrsd) / (pow(T5, 4 - mvsrsd) + vsrdfactor * pow(vsat_rd, 4 - mvsrsd));
            T6 = pow(delta_vsrd, 1.0 / mvsrsd) * T5 / vsat_rd;
            Rvs_d = T4 * pow((1.0 + pow(T6, mvsrsd)), 1 / mvsrsd);
        end
        if (rslcw > 0) begin
            if (rdlcw == 0.0) begin
                rdstempvs = hypsmooth((1.0 + prtvsrsd * delTemp - 1.0e-6), 1.0e-3);
                `tempdep(VSATRSD_t, vsatrsd, -atvsrsd)
                T0 = qis - ptwg1vsrsd;
                T0 = smoothminx(T0, 0.1, 2.0);
                T1  = 10.0 * psatxvsrsd * T0 / (10.0 * psatxvsrsd + T0);
                vsatrsd_eff = VSATRSD_t * (1.0 + ptwgvsrsd * T1);
                vsatrsd_eff = hypsmooth(vsatrsd_eff, 10.0);
                T2 = NFINtotal * Weff0 * `q * vsatrsd_eff;
            end
            isat_rs = T2 * nvsrs;
            T4 = rdstempvs * rslcw * WeffWRFactor;
            vsat_rs = isat_rs * T4;
            T5 = abs(V(si, si1));
            delta_vsrs = pow(T5, 4 - mvsrsd) / (pow(T5, 4 - mvsrsd) + vsrsfactor * pow(vsat_rs, 4 - mvsrsd));
            T6 = pow(delta_vsrs, 1.0 / mvsrsd) * T5 / vsat_rs;
            Rvs_s = T4 * pow((1.0 + pow(T6, mvsrsd)), 1 / mvsrsd);
        end
    end

    // External source/drain resistance
    if (rdsmod != 2 && RDrainGeo > 0) begin
        gdpr = 1.0 / Rdrain;
        I(d, di2) <+ V(d, di2) * gdpr;
        if (rdsmod == 1 && rdlcw > 0) begin
            gvs_d = 1.0 / Rvs_d;
            I(di2, di1) <+ V(di2, di1) * gvs_d;
        end else begin
            V(di2, di1) <+ 0.0;
        end
    end else begin
        V(d, di2) <+ 0.0;
        V(di2, di1) <+ 0.0;
    end
    if (rdsmod != 2 && RSourceGeo > 0) begin
        gspr = 1.0 / Rsource;
        I(s, si1) <+ V(s, si1) * gspr;
        if (rdsmod == 1 && rslcw > 0) begin
            gvs_s = 1.0 / Rvs_s;
            I(si1, si) <+ V(si1, si) * gvs_s;
        end else begin
            V(si1, si) <+ 0.0;
        end
    end else begin
        V(s, si1) <+ 0.0;
        V(si1, si) <+ 0.0;
    end

    // NQS gate resistance model
    if (nqsmod == 1 && XRCRG1_i != 0.0) begin
        I(gint, gi) <+ V(gint, gi) * gcrg;
    end else begin
        V(gint, gi) <+ 0.0;
    end
    if (nqsmod == 2) begin
        I(q) <+ ddt(qg_v - qb_v);
        I(q) <+ V(q) * gtau;
        I(q) <+ 1.0e-9 * ddt(V(q));
    end else begin
        V(q) <+ 0.0;
    end

    // Gate electrode resistance
    if (rgatemod != 0) begin
        I(g, ge) <+ V(g, ge) * ggeltd;
        if (rgatemod == 2) begin
            I(ge, gint) <+ V(ge, gint) * ggint;
            I(ge, gints) <+ V(ge, gints) * ggp;
            I(ge, gintd) <+ V(ge, gintd) * ggp;
        end else begin
            V(ge, gint) <+ 0.0;
            V(ge, gints) <+ 0.0;
            V(ge, gintd) <+ 0.0;
        end
    end else begin
        V(g, ge) <+ 0.0;
        V(ge, gint) <+ 0.0;
        V(ge, gints) <+ 0.0;
        V(ge, gintd) <+ 0.0;
    end

    // Flicker noise
    I(di, si) <+ flicker_noise(sigvds * FNPowerAt1Hz, ef_v, "1overf");

    // Thermal noise for parasitics
    if (rdsmod != 2 && RDrainGeo > 0) begin
        I(d, di2) <+ white_noise(4.0 * Vtm * `q * gdpr, "rd");
        if (rdsmod == 1 && rdlcw > 0) begin
            I(di2, di1) <+ white_noise(4.0 * Vtm * `q * gvs_d, "rd");
        end
    end
    if (rdsmod != 2 && RSourceGeo > 0) begin
        I(s, si1) <+ white_noise(4.0 * Vtm * `q * gspr, "rs");
        if (rdsmod == 1 && rslcw > 0) begin
            I(si1, si) <+ white_noise(4.0 * Vtm * `q * gvs_s, "rs");
        end
    end
    if (rgatemod != 0) begin
        I(g, ge) <+ white_noise(4.0 * Vtm * `q * ggeltd, "rg");
    end

    // Channel thermal noise and induced gate noise stamping
    if (tnoimod == 0) begin
        I(di, si) <+ white_noise(sid, "id");
        V(n) <+ 0.0;
    end else begin
        // Additional node for correlated noise
        I(n) <+ V(n);
        I(n) <+ white_noise(sid, "corl");
        I(di, si) <+ white_noise(sid * (1.0 - ctnoi * ctnoi), "id");
        I(di, si) <+ ctnoi * V(n);
        // Correlated Sig noise to S/D through capacitive coupling
        I(gi, si) <+ ddt(0.7071 * sigrat * V(n));
        I(gi, di) <+ ddt(0.7071 * sigrat * V(n));
    end

    // Gate current shot noise
    if (igcmod != 0) begin
        if (sigvds > 0.0) begin
            I(gi, si) <+ white_noise(2.0 * `q * abs(igcs_v + igs_v), "igs_v");
            I(gi, di) <+ white_noise(2.0 * `q * abs(igcd_v + igd_v), "igd_v");
        end else begin
            I(gi, di) <+ white_noise(2.0 * `q * abs(igcs_v + igs_v), "igd_v");
            I(gi, si) <+ white_noise(2.0 * `q * abs(igcd_v + igd_v), "igs_v");
        end
    end
    if (igbmod != 0) begin
        if (bulkmod != 0) begin
            I(gi, e)  <+ white_noise(2.0 * `q * abs(igbinv_v + igbacc_v), "igb");
        end else begin
            I(gi, si) <+ white_noise(2.0 * `q * abs(igbs_v), "igbs_v");
            I(gi, di) <+ white_noise(2.0 * `q * abs(igbd_v), "igbd_v");
        end
    end

    // Self-heating
    if (shmod != 0 && rth0 > 0.0) begin
        Pwr(t) <+ -(devsign * sigvds * V(di, si) * ids_v);
        if (rdsmod != 2 && RDrainGeo > 0) begin
            Pwr(t) <+ -V(d, di2) * V(d, di2) * gdpr;
            if (rdsmod == 1 && rdlcw > 0) begin
                Pwr(t) <+ -V(di2, di1) * V(di2, di1) * gvs_d;
            end
        end
        if (rdsmod != 2 && RSourceGeo > 0) begin
            Pwr(t) <+ -V(s, si1) * V(s, si1) * gspr;
            if (rdsmod == 1 && rslcw > 0) begin
                Pwr(t) <+ -V(si1, si) * V(si1, si) * gvs_s;
            end
        end
        Pwr(t) <+ Temp(t) * gth;
        Pwr(t) <+ ddt(Temp(t) * cth);
    end else begin
        Temp(t) <+ 0.0;
    end

    // Operating-point information
    // W & l
    weff = Weff0;
    leff = Leff;
    weffcv = WeffCV0;
    leffcv = LeffCV;
    // Intrinsic drain current
    ids = devsign * ids_v;
    // Total drain and source currents
    if (sigvds > 0.0) begin
        if (bulkmod != 0) begin
            if (gidlmod == 2 && (geomod == 2 || geomod == 3 || geomod == 5)) begin
                ideff = ids + devsign * idsgen_v - devsign * (igd_v + igcd_v) + devsign * (Iii + igidl_v + igidlb) - devsign * Ied;
                iseff = -ids - devsign * idsgen_v - devsign * (igs_v + igcs_v) + devsign * (igisl_v + igislb) - devsign * Ies;
            end else begin
                ideff = ids + devsign * idsgen_v - devsign * (igd_v + igcd_v) + devsign * (Iii + igidl_v) - devsign * Ied;
                iseff = -ids - devsign * idsgen_v - devsign * (igs_v + igcs_v) + devsign * igisl_v - devsign * Ies;
            end
        end else begin
            ideff = ids + devsign * idsgen_v - devsign * (igd_v + igcd_v + igbd_v) + devsign * (Iii + igidl_v - igisl_v);
            iseff = -ids - devsign * idsgen_v - devsign * (igs_v + igcs_v + igbs_v) + devsign * (igisl_v - igidl_v - Iii);
        end
    end else begin
        if (bulkmod != 0) begin
            if (gidlmod == 2 && (geomod == 2 || geomod == 3 || geomod == 5)) begin
                ideff = -ids - devsign * idsgen_v - devsign * (igs_v + igcs_v) + devsign * (igisl_v + igislb) - devsign * Ied;
                iseff = ids + devsign * idsgen_v - devsign * (igd_v + igcd_v) + devsign * (Iii + igidl_v + igidlb) - devsign * Ies;
            end else begin
                ideff = -ids - devsign * idsgen_v - devsign * (igs_v + igcs_v) + devsign * igisl_v - devsign * Ied;
                iseff = ids + devsign * idsgen_v - devsign * (igd_v + igcd_v) + devsign * (Iii + igidl_v) - devsign * Ies;
            end
        end else begin
            ideff = -ids - devsign * idsgen_v - devsign * (igs_v + igcs_v + igbd_v) + devsign * (igisl_v - igidl_v - Iii);
            iseff = ids + devsign * idsgen_v - devsign * (igd_v + igcd_v + igbs_v) + devsign * (Iii + igidl_v - igisl_v);
        end
    end
    // Total gate current
    if (bulkmod == 0) begin
        igtot = devsign * (igs_v + igd_v + igcs_v + igcd_v + igbs_v + igbd_v);
    end else begin
        igtot = devsign * (igs_v + igd_v + igcs_v + igcd_v + igbacc_v + igbinv_v);
    end
    // Generation-recombination current
    idsgen = sigvds * devsign * idsgen_v;
    // Impact ionization current
    iii = devsign * Iii;
    // GIDL, GISL currents
    if (sigvds > 0.0) begin
        if (bulkmod != 0 && gidlmod == 2 && (geomod == 2 || geomod == 3 || geomod == 5)) begin
            igidl = devsign * (igidl_v + igidlb);
            igisl = devsign * (igisl_v + igislb);
        end else begin
            igidl = devsign * igidl_v;
            igisl = devsign * igisl_v;
        end
    end else begin
        if (bulkmod != 0 && gidlmod == 2 && (geomod == 2 || geomod == 3 || geomod == 5)) begin
            igidl = devsign * (igisl_v + igislb);
            igisl = devsign * (igidl_v + igidlb);
        end else begin
            igidl = devsign * igisl_v;
            igisl = devsign * igidl_v;
        end
    end
    // Source-to-substrate and drain-to-substrate junction currents
    if (bulkmod != 0) begin
        ijsb = -devsign * Ies;
        ijdb = -devsign * Ied;
    end else begin
        ijsb = 0.0;
        ijdb = 0.0;
    end
    // Substrate current
    if (bulkmod != 0) begin
        if ((gidlmod == 2 || gidlmod == 3) && (geomod == 2 || geomod == 3 || geomod == 5)) begin
            isub = -iii - devsign * (igidlb + igislb) - ijsb - ijdb - devsign * (igbinv_v + igbacc_v);
        end else begin
            isub = -iii - igidl - igisl - ijsb - ijdb - devsign * (igbinv_v + igbacc_v);
        end
    end else begin
        isub = 0.0;
    end
    // Drain current prefactor per fin per finger
    beta = beta_v;
    // Drain-to-source saturation voltage
    Lterm0 = 0.15 * (Lg-10e-9) / 10e-9 + 1.12;
    Lterm = Lterm0 / pow(1 + pow(Lterm0 / 1.45, 3), 0.33);
    vdssat = Vdsat * Lterm / pow(1 + pow(Vdsat / 0.5, 1.8), 1 / 1.8);
    // Effective drain-to-source voltage
    vdseff = Vdseff;
    // Flatband voltage
    if (NGATE_i > 0.0) begin
        if (cryomod == 0) begin
            vfb = -devsign * (phib + Vtm * llnf(NGATE_i / ni));
        end else begin
            vfb = -devsign * (phib + Vtm * (llnf(NGATE_i) - niln));
        end
    end else begin
        vfb = PHIG_i - (easub + 0.5 * Eg + devsign * phib);
    end
    // Threshold voltage calculation
    q0 = 10.0 * Vtm / rc + 2.0 * qbs;
    T1 = Vtm * (Vtm + q0);
    T2 = cox * cox * T1;
    T3 = 2.0 * `q * ni * epssub * Vtm;
    vth = vfb + devsign * (Vtm * llnf(T2 / T3) + dvch_qm + phib + qbs + Vtm + dvth_all - delvtrand);
    // Transconductance
    gm = ddx(ids, V(gi));
    // Output conductance
    if (sigvds > 0) begin
        gds = ddx(ids, V(di));
    end else begin
        gds = ddx(ids, V(si));
    end

    // Body transconductance
    if (bulkmod != 0) begin
        gmbs = ddx(ids, V(e));
    end else begin
        gmbs = 0.0;
    end
    // Intrinsic charges
    qgi = devsign * (qg_v + qg_acc);
    qdi = devsign * qd_v;
    qsi = devsign * qs_v;
    qbi = devsign * (qb_v + qb_acc);
    // Total charges
    qg = devsign * qg_v + qgs_parasitic + qgd_parasitic + (cgeomod == 1 ? qgs_fr + qgd_fr : 0.0) + devsign * qg_acc - devsign * Qeg + devsign * (qbov + qbov_s);
    qd = devsign * qd_v - qgd_parasitic - (cgeomod == 1 ? qgd_fr : 0.0) - devsign * Qed +  qds_fr - devsign * qbov;
    qs = devsign * qs_v - qgs_parasitic - (cgeomod == 1 ? qgs_fr : 0.0) - devsign * Qes -  qds_fr - devsign * qbov_s;
    qb = devsign * (qb_v + qb_acc) + devsign * (Qeg + Qes + Qed);
    // Intrinsic capacitances
    cggi = ddx(qgi, V(gi));
    cgsi = -ddx(qgi, V(si));
    cgdi = -ddx(qgi, V(di));
    cgei = -ddx(qgi, V(e));
    csgi = -ddx(qsi, V(gi));
    csdi = -ddx(qsi, V(di));
    cssi = ddx(qsi, V(si));
    csei = -ddx(qsi, V(e));
    cdgi = -ddx(qdi, V(gi));
    cddi = ddx(qdi, V(di));
    cdsi = -ddx(qdi, V(si));
    cdei = -ddx(qdi, V(e));
    cegi = -ddx(qbi, V(gi));
    cedi = -ddx(qbi, V(di));
    cesi = -ddx(qbi, V(si));
    ceei = ddx(qbi, V(e));
    // Total capacitances
    if (rgatemod == 2) begin
        cgg = cggi + ddx(qgs_parasitic + (cgeomod == 1 ? qgs_fr : 0.0), V(gints)) + ddx(qgd_parasitic + (cgeomod == 1 ? qgd_fr : 0.0), V(gintd)) - ddx(devsign * Qeg, V(ge));
    end else begin
        cgg = cggi + ddx(qgs_parasitic + (cgeomod == 1 ? qgs_fr : 0.0), V(ge)) + ddx(qgd_parasitic + (cgeomod == 1 ? qgd_fr : 0.0), V(ge)) - ddx(devsign * Qeg, V(ge));
    end
    cgs = -ddx(qg, V(si));
    cgd = -ddx(qg, V(di));
    cge = -ddx(qg, V(e));
    if (rgatemod == 2) begin
        csg = csgi + ddx(qgs_parasitic + (cgeomod == 1 ? qgs_fr : 0.0), V(gints));
    end else begin
        csg = csgi + ddx(qgs_parasitic + (cgeomod == 1 ? qgs_fr : 0.0), V(ge));
    end
    csd = -ddx(qs, V(di)) + cdsp;
    css = ddx(qs, V(si))  + cdsp;
    cse = -ddx(qs, V(e));
    if (rgatemod == 2) begin
        cdg = cdgi + ddx(qgd_parasitic + (cgeomod == 1 ? qgd_fr : 0.0), V(gintd));
    end else begin
        cdg = cdgi + ddx(qgd_parasitic + (cgeomod == 1 ? qgd_fr : 0.0), V(ge));
    end
    cdd = ddx(qd, V(di))  + cdsp;
    cds = -ddx(qd, V(si)) + cdsp;
    cde = -ddx(qd, V(e));
    ceg = cegi - ddx(devsign * Qeg, V(ge));
    ced = -ddx(qb, V(di));
    ces = -ddx(qb, V(si));
    cee = ddx(qb, V(e));
    // Gate-to-source overlap and outer fringe capacitance
    cgsext = -ddx(qgs_parasitic + (cgeomod == 1 ? qgs_fr : 0.0), V(si));
    // Gate-to-drain overlap and outer fringe capacitance
    cgdext = -ddx(qgd_parasitic + (cgeomod == 1 ? qgd_fr : 0.0), V(di));
    // Gate-to-substrate overlap capacitance
    cgbov = -devsign * ddx(Qeg, V(e));
    // Total junction and source/drain-to-substrate overlap capacitances
    cjst = -devsign * ddx(Qes, V(si));
    cjdt = -devsign * ddx(Qed, V(di));
    // External bias-independent source resistance
    rsgeo = RSourceGeo;
    // External bias-independent drain resistance
    rdgeo = RDrainGeo;
    // Geometric parasitic capacitance
    cfgeo = Cfr_geo;
    // Output for self-heating temperature
    t_total_k = DevTemp;
    t_total_c = DevTemp - `P_CELSIUS0;
    t_delta_sh = Temp(t);
    // Gate current components
    igs = devsign * igs_v;
    igd = devsign * igd_v;
    igcs = devsign * igcs_v;
    igcd = devsign * igcd_v;
    if (bulkmod == 0) begin
        igbs = devsign * igbs_v;
        igbd = devsign * igbd_v;
        igbinv = 0.0;
        igbacc = 0.0;
    end else begin
        igbinv = devsign * igbinv_v;
        igbacc = devsign * igbacc_v;
        igbs = 0.0;
        igbd = 0.0;
    end
    didsdvg = devsign * sigvds * ddx(ids_v, V(gi));
    didsdvs = devsign * sigvds * ddx(ids_v, V(si));
    didsdvd = devsign * sigvds * ddx(ids_v, V(di));
    digsdvg = devsign * ddx(igs_v + igcs_v, V(gi));
    digsdvs = devsign * ddx(igs_v + igcs_v, V(si));
    digsdvd = devsign * ddx(igs_v + igcs_v, V(di));
    digddvg = devsign * ddx(igd_v + igcd_v, V(gi));
    digddvs = devsign * ddx(igd_v + igcd_v, V(si));
    digddvd = devsign * ddx(igd_v + igcd_v, V(di));
    diiidvg = devsign * ddx(Iii, V(gi));
    diiidvs = devsign * ddx(Iii, V(si));
    diiidvd = devsign * ddx(Iii, V(di));
    digidldvg = devsign * ddx(igidl_v, V(gi));
    digidldvs = devsign * ddx(igidl_v, V(si));
    digidldvd = devsign * ddx(igidl_v, V(di));
    digisldvg = devsign * ddx(igisl_v, V(gi));
    digisldvs = devsign * ddx(igisl_v, V(si));
    digisldvd = devsign * ddx(igisl_v, V(di));
    cgt = ddx(qg, Temp(t));
    cst = ddx(qs, Temp(t));
    cdt = ddx(qd, Temp(t));
    didsdvth = devsign * sigvds * ddx(ids_v, Temp(t));
    digsdvth = devsign * ddx(igs_v + igcs_v, Temp(t));
    digddvth = devsign * ddx(igd_v + igcd_v, Temp(t));
    diiidvth = devsign * ddx(Iii, Temp(t));
    digidldvth = devsign * ddx(igidl_v, Temp(t));
    digisldvth = devsign * ddx(igisl_v, Temp(t));
    if (rdsmod != 2) begin
        if (rdsmod == 1 && (rdlcw > 0 || rslcw > 0)) begin
            ith = V(di, si) * ids_v + V(di2, di1) * V(di2, di1) * gvs_d + V(d, di2) * V(d, di2) * gdpr + V(si1, si) * V(si1, si) * gvs_s + V(s, si1) * V(s, si1) * gspr;
        end else begin
            ith = V(di, si) * ids_v + V(d, di2) * V(d, di2) * gdpr + V(s, si1) * V(s, si1) * gspr;
        end
    end else begin
        ith = V(di, si) * ids_v;
    end
    dithdvth = ddx(ith, Temp(t));
    dithdvg = ddx(ith, V(gi));
    dithdvs = ddx(ith, V(si));
    dithdvd = ddx(ith, V(di));
end

// ---- end `include "bsimcmg_body.include" ----
endmodule
