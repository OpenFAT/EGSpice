// Inductor: linear, V(p,n) = l * d/dt I(br).
//
// Verilog-A implementation: Omar El-Sawy, University of Waterloo.

`include "constants.vams"
`include "disciplines.vams"

module inductor(p, n);
    inout p, n;
    electrical p, n;
    branch (p, n) br;
    parameter real l = 1e-9 from (0:inf);  // H  inductance

    analog V(br) <+ l * ddt(I(br));
endmodule
