// BSIM2: Berkeley Short-channel IGFET Model 2 (ngspice netlist letter M, level 5).
//
// Verilog-A implementation: Omar El-Sawy, University of Waterloo.
// Based on: ngspice bsim2 (b2eval.c, b2temp.c, b2ld.c, b2set.c), BSIM2 by the
//   UC Berkeley BSIM group (M.-C. Jeng, P. K. Ko, C. Hu).
//   ngspice: Copyright Regents of the University of California and others,
//   modified BSD license.
//
// Laid out like models/mos1.va (same sections, same local names); the channel
// core is b2eval.c's:
//     d --[RD]-- di --[channel]-- si --[RS]-- s
//     bulk diodes b-di / b-si, b2eval.c's gate/bulk/drain charges (no Meyer caps)
//
// Every core coefficient carries L- and W-sensitivity siblings combined as
// P_eff = P0 + PL/Leff_um + PW/Weff_um (b2temp.c).
//
// The channel block (b2eval.c) is one equation, not a region ladder: the gate
// drive Vgst = Vgs - Vth is mapped through Vgeff, which is Vgst in strong
// inversion, an exponential in weak inversion, and a C1 cubic between the
// VGLOW/VGHIGH knots. Subthreshold current therefore enters the same Ids
// expression rather than as a separate factor.

`include "constants.vams"
`include "disciplines.vams"

module bsim2(d, g, s, b);
    inout d, g, s, b;
    electrical d, g, s, b;
    electrical di, si;              // internal drain/source behind rd/rs

    // --- polarity ---------------------------------------------------------
    parameter integer type = 1 from [-1:1] exclude 0;  // +1 NMOS, -1 PMOS

    // --- threshold voltage ------------------------------------------------
    parameter real vfb  = -1.0;   // flat-band voltage [V]
    parameter real lvfb = 0.0;
    parameter real wvfb = 0.0;
    parameter real phi  = 0.75;   // strong-inversion surface potential [V]
    parameter real lphi = 0.0;
    parameter real wphi = 0.0;
    parameter real k1   = 0.8;    // bulk-effect coefficient 1 [V^0.5]
    parameter real lk1  = 0.0;
    parameter real wk1  = 0.0;
    parameter real k2   = 0.0;    // bulk-effect coefficient 2
    parameter real lk2  = 0.0;
    parameter real wk2  = 0.0;
    parameter real eta0 = 0.0;    // vdsx dependence of vth (DIBL)
    parameter real leta0 = 0.0;
    parameter real weta0 = 0.0;
    parameter real etab = 0.0;    // vbx dependence of eta
    parameter real letab = 0.0;
    parameter real wetab = 0.0;

    // --- geometry ---------------------------------------------------------
    parameter real dl  = 0.0;     // channel length reduction [um]
    parameter real dw  = 0.0;     // channel width reduction [um]
    parameter real ld  = 0.0;     // lateral diffusion [m] (accepted, unused)
    parameter real tox = 0.03 from (0:inf);  // gate oxide thickness [um]

    // --- mobility ---------------------------------------------------------
    parameter real mu0  = 400.0;  // low-field mobility at vdsx = 0 [cm^2/V/s]
    parameter real mu0b = 0.0;    // vbx dependence of mu0
    parameter real lmu0b = 0.0;
    parameter real wmu0b = 0.0;
    parameter real mus0 = 500.0;  // mobility at vdsx = vdd [cm^2/V/s]
    parameter real lmus0 = 0.0;
    parameter real wmus0 = 0.0;
    parameter real musb = 0.0;    // vbx dependence of mus
    parameter real lmusb = 0.0;
    parameter real wmusb = 0.0;
    parameter real mu20 = 1.5;    // vdsx dependence of mu, tanh term (unitless)
    parameter real lmu20 = 0.0;
    parameter real wmu20 = 0.0;
    parameter real mu2b = 0.0;
    parameter real lmu2b = 0.0;
    parameter real wmu2b = 0.0;
    parameter real mu2g = 0.0;
    parameter real lmu2g = 0.0;
    parameter real wmu2g = 0.0;
    parameter real mu30 = 10.0;   // vdsx dependence of mu, linear term
    parameter real lmu30 = 0.0;
    parameter real wmu30 = 0.0;
    parameter real mu3b = 0.0;
    parameter real lmu3b = 0.0;
    parameter real wmu3b = 0.0;
    parameter real mu3g = 0.0;
    parameter real lmu3g = 0.0;
    parameter real wmu3g = 0.0;
    parameter real mu40 = 0.0;    // vdsx dependence of mu, quadratic term
    parameter real lmu40 = 0.0;
    parameter real wmu40 = 0.0;
    parameter real mu4b = 0.0;
    parameter real lmu4b = 0.0;
    parameter real wmu4b = 0.0;
    parameter real mu4g = 0.0;
    parameter real lmu4g = 0.0;
    parameter real wmu4g = 0.0;

    // --- gate-field mobility degradation ----------------------------------
    parameter real ua0 = 0.2;     // linear vgsx degradation [1/V]
    parameter real lua0 = 0.0;
    parameter real wua0 = 0.0;
    parameter real uab = 0.0;
    parameter real luab = 0.0;
    parameter real wuab = 0.0;
    parameter real ub0 = 0.0;     // quadratic vgsx degradation [1/V^2]
    parameter real lub0 = 0.0;
    parameter real wub0 = 0.0;
    parameter real ubb = 0.0;
    parameter real lubb = 0.0;
    parameter real wubb = 0.0;

    // --- lateral-field (velocity-saturation) mobility ---------------------
    parameter real u10 = 0.1;     // [1/V]
    parameter real lu10 = 0.0;
    parameter real wu10 = 0.0;
    parameter real u1b = 0.0;     // vbx dependence of u1
    parameter real lu1b = 0.0;
    parameter real wu1b = 0.0;
    parameter real u1d = 0.0;     // triode-region modulation of u1 (unitless)
    parameter real lu1d = 0.0;
    parameter real wu1d = 0.0;

    // --- subthreshold -----------------------------------------------------
    parameter real n0 = 1.4;      // subthreshold slope factor
    parameter real ln0 = 0.0;
    parameter real wn0 = 0.0;
    parameter real nb = 0.5;      // body dependence of n (enters as nb/sqrt(phisb))
    parameter real lnb = 0.0;
    parameter real wnb = 0.0;
    parameter real nd = 0.0;      // vdsx dependence of n
    parameter real lnd = 0.0;
    parameter real wnd = 0.0;
    parameter real vof0 = 1.8;    // weak-inversion prefactor exponent (unitless)
    parameter real lvof0 = 0.0;
    parameter real wvof0 = 0.0;
    parameter real vofb = 0.0;
    parameter real lvofb = 0.0;
    parameter real wvofb = 0.0;
    parameter real vofd = 0.0;
    parameter real lvofd = 0.0;
    parameter real wvofd = 0.0;

    // --- hot-electron / output conductance --------------------------------
    parameter real ai0 = 0.0;     // pre-factor
    parameter real lai0 = 0.0;
    parameter real wai0 = 0.0;
    parameter real aib = 0.0;
    parameter real laib = 0.0;
    parameter real waib = 0.0;
    parameter real bi0 = 0.0;     // exponential factor [V]
    parameter real lbi0 = 0.0;
    parameter real wbi0 = 0.0;
    parameter real bib = 0.0;
    parameter real lbib = 0.0;
    parameter real wbib = 0.0;

    // --- Vgg/Vgt cubic-spline knots ----------------------------
    parameter real vghigh = 0.2;  // upper knot on vgst [V]
    parameter real lvghigh = 0.0;
    parameter real wvghigh = 0.0;
    parameter real vglow = -0.15; // lower knot on vgst [V]
    parameter real lvglow = 0.0;
    parameter real wvglow = 0.0;

    // --- extraction reference bias / nominal temperature ------------------
    // vdd is the Vds *reference point* of the mobility interpolation: the
    // mu0 -> mus endpoint is defined at vdsx = vdd (b2eval.c Beta1). All three
    // are ALSO hard clamps on the bias triple: b2eval.c:57-59 limits its local
    // Vbs/Vgs/Vds to 2*VBB / 2*VGG / 2*VDD before evaluating anything, and
    // b2temp.c:135-137 uses VBB for the betasB endpoint clamp.
    parameter real vdd = 5.0;     // V
    parameter real vgg = 5.0;     // V
    parameter real vbb = 5.0;     // V (real cards give it negative)
    // b2temp.c: `B2Vtm = 8.625e-5 * (B2temp + 273.0)`. BSIM2 has no
    // temperature maps (b2temp.c touches neither Eg, pb, js nor the cap
    // factors); the thermal voltage comes from this model-card parameter,
    // which ngspice spells `temp` in degC.
    parameter real temp = 27.0;   // degC, parameter measurement temperature

    // --- capacitances -----------------------------------------------------
    parameter real cgso = 0.0;    // gate-source overlap [F/m]
    parameter real cgdo = 0.0;    // gate-drain overlap [F/m]
    parameter real cgbo = 0.0;    // gate-bulk overlap [F/m]
    // Accepted, unused: b2mpar.c stores XPART as 0 or 1 and b2eval.c only
    // drops the charges above 1, so ngspice partitions 40/60 under either.
    parameter integer xpart = 0 from [0:1];

    // --- junctions --------------------------------------------------------
    parameter real js   = 0.0;    // saturation current density [A/m^2]
    parameter real pb   = 0.8 from (0:inf);   // bottom built-in potential [V]
    parameter real mj   = 0.0;    // bottom grading coefficient
    parameter real pbsw = 0.8 from (0:inf);   // sidewall built-in potential [V]
    parameter real mjsw = 0.0;    // sidewall grading coefficient
    parameter real cj   = 0.0;    // bottom junction cap [F/m^2]
    parameter real cjsw = 0.0;    // sidewall junction cap [F/m]

    // --- parasitic resistance ---------------------------------------------
    parameter real rsh  = 0.0;    // sheet resistance [ohm/sq]
    parameter real wdf  = 10.0;   // default diffusion width [um]
    parameter real dell = 0.0;    // diffusion length reduction [um]

    // --- flicker noise (mos1noi.c form) -----------------------------------
    parameter real kf = 0.0;
    parameter real af = 1.0;

    // --- instance ---------------------------------------------------------
    parameter real w = 5e-6 from (0:inf);     // channel width [m]
    parameter real l = 5e-6 from (0:inf);     // channel length [m]
    parameter real m = 1.0 from (0:inf);      // parallel multiplier
    parameter real ad = 0.0 from [0:inf);     // drain diffusion area [m^2]
    parameter real as = 0.0 from [0:inf);     // source diffusion area [m^2]
    parameter real pd = 0.0 from [0:inf);     // drain diffusion perimeter [m]
    parameter real ps = 0.0 from [0:inf);     // source diffusion perimeter [m]
    parameter real nrd = 1.0 from [0:inf);    // squares of drain diffusion
    parameter real nrs = 1.0 from [0:inf);    // squares of source diffusion

    // bias-independent
    real leff, weff, lum, wum, il, iw, tk, vt, vt0, cox, coxwl, bfac;
    real adrn, asrc, pdrn, psrc, isatd, isats, vcrits, vcritd;
    real czbs, czbssw, czbd, czbdsw, omj, omjsw;
    real gdrain, gsource, vddc, vdd2, vgg2, vbb2;
    real vfbe, phie, phis3, k1e, k2e, eta0e, etabe;
    real mu0be, mus0e, musbe;
    real mu20e, mu2be, mu2ge, mu30e, mu3be, mu3ge, mu40e, mu4be, mu4ge;
    real ua0e, uabe, ub0e, ubbe, u10e, u1be, u1de;
    real n0e, nbe, nde, vof0e, vofbe, vofde;
    real ai0e, aibe, bi0e, bibe, vghe, vgle;
    // bias-dependent
    real ty, vtx;
    real vgs, vgd, vds, vbs, vbd, ibs, ibd;
    real mode, vdsneg, vgsx, vdsx, vbx;
    real phisb, t1s, eta, vth, nsub, vof, gg, aa;
    real wds, wpre, vgwk, vglo, slo, hspan, tsp, h00, h10, h01, h11;
    real vgst, vgeff, dvgeff, ua, ub, uvert, u1s, u1, vc, kk, vdsat, vdsch, t4;
    real beta0b, betas, beta1, beta2, beta3, beta4, beta, betaeff, targ;
    real ai, bi, dvds, fclm, idscore, gmch, id, idst;
    real vbseff, arg1, qbulk, uvq, vcq, kkq, vdsq, vgdt, t0, t1, t5;
    real qgch, qbch, qdch, qgso, qgdo, qgbo, qbs, qbd, dqg, dqb, dq;

    // Junction depletion charge, forward/reverse blended by a steep sigmoid
    // (one differentiable expression instead of a v<0 branch). The reverse
    // branch is the integral of the cj/(1-v/pb)^mj law,
    // q = pb*cj/(1-mj) * (1 - (1-v/pb)^(1-mj)), clamped at (1-v/pb) >= 0.01
    // (b2ld.c: `sarg = arg^(-mj)`, `q = pb*cj*(1 - arg*sarg)/(1-mj)`).
    // cja/cjswa are absolute farads (area/perimeter scaled by the caller).
    // Bulk junction current, b2ld.c: linear (isat/vt + gmin)*v in reverse,
    // Shockley forward. b2ld.c's RHS is cbd - (gbd - gmin)*vbd, so the
    // converged current carries gmin twice; hence 2*gm. The exponent is
    // tangent-continued above 80*vtx so the restoring slope survives
    // evaluations at unlimited v.
    analog function real jcur;
        input v, isat, vtx, gm;
        real v, isat, vtx, gm;
        real u;
        begin
            u = min(v / vtx, 80.0);
            if (v <= 0.0)
                jcur = (isat / vtx + 2.0 * gm) * v;
            else
                jcur = isat * (exp(u) * (1.0 + (v / vtx - u)) - 1.0) + 2.0 * gm * v;
        end
    endfunction

    analog function real jcharge;
        input v, cja, cjswa, pba, pbswa, mja, mjswa, om, omsw;
        real v, cja, cjswa, pba, pbswa, mja, mjswa, om, omsw;
        real sg, qf, ar, arsw, qr;
        begin
            sg = 0.5 * (1.0 + tanh(max(min(100.0 * v, 30.0), -30.0)));
            qf = v * (cja + cjswa)
                 + v * v * (cja * mja / (2.0 * pba) + cjswa * mjswa / (2.0 * pbswa));
            ar   = max(1.0 - v / pba,   0.01);
            arsw = max(1.0 - v / pbswa, 0.01);
            qr = (pba * cja / om) * (1.0 - pow(ar, om))
                 + (pbswa * cjswa / omsw) * (1.0 - pow(arsw, omsw));
            jcharge = (1.0 - sg) * qr + sg * qf;
        end
    endfunction

    analog begin
        // ============ parameter defaulting (b2temp.c) =====================
        leff = max(l - dl * 1.0e-6, 1.0e-9);
        weff = max(w - dw * 1.0e-6, 1.0e-9);
        lum  = max(leff * 1.0e6, 0.01);
        wum  = max(weff * 1.0e6, 0.01);
        il   = 1.0 / lum;
        iw   = 1.0 / wum;

        // b2temp.c:44: `Cox = 3.453e-13 / (B2tox * 1.0e-4)` [F/cm^2], eps_ox
        // over TOX read as microns, with no floor (`from (0:inf)` keeps tox > 0).
        cox   = 3.453e-11 / (tox * 1.0e-6);            // eps_ox/tox [F/m^2]
        coxwl = cox * weff * leff;
        // Gate-drive-independent part of beta: 1e-4 converts cm^2/V/s -> m^2.
        bfac  = 1.0e-4 * cox * weff / leff;

        // P_eff = P0 + PL/Leff_um + PW/Weff_um.
        vfbe  = vfb  + lvfb  * il + wvfb  * iw;
        phie  = max(phi + lphi * il + wphi * iw, 0.1);
        phis3 = phie * sqrt(phie);
        k1e   = k1   + lk1   * il + wk1   * iw;
        k2e   = k2   + lk2   * il + wk2   * iw;
        eta0e = eta0 + leta0 * il + weta0 * iw;
        etabe = etab + letab * il + wetab * iw;

        mu0be = mu0b + lmu0b * il + wmu0b * iw;
        mus0e = mus0 + lmus0 * il + wmus0 * iw;
        musbe = musb + lmusb * il + wmusb * iw;
        // b2temp.c:129-137, on the RAW mobilities and BEFORE the CoxW/L scaling
        // at b2temp.c:168-171:
        //   if (betas0 < 1.01*beta0) betas0 = 1.01*beta0;
        //   tmp = betas0 - beta0 - beta0B*VBB;
        //   if ((-betasB*VBB) > tmp) betasB = -tmp/VBB;
        // beta0 there is the raw MU0 with no L/W siblings, beta0B is mu0be.
        mus0e = max(mus0e, 1.01 * mu0);
        musbe = (vbb != 0.0 && (-musbe * vbb) > (mus0e - mu0 - mu0be * vbb))
                ? -(mus0e - mu0 - mu0be * vbb) / vbb
                : musbe;
        mu20e = mu20 + lmu20 * il + wmu20 * iw;
        mu2be = mu2b + lmu2b * il + wmu2b * iw;
        mu2ge = mu2g + lmu2g * il + wmu2g * iw;
        mu30e = mu30 + lmu30 * il + wmu30 * iw;
        mu3be = mu3b + lmu3b * il + wmu3b * iw;
        mu3ge = mu3g + lmu3g * il + wmu3g * iw;
        mu40e = mu40 + lmu40 * il + wmu40 * iw;
        mu4be = mu4b + lmu4b * il + wmu4b * iw;
        mu4ge = mu4g + lmu4g * il + wmu4g * iw;

        ua0e = ua0 + lua0 * il + wua0 * iw;
        uabe = uab + luab * il + wuab * iw;
        ub0e = ub0 + lub0 * il + wub0 * iw;
        ubbe = ubb + lubb * il + wubb * iw;
        u10e = u10 + lu10 * il + wu10 * iw;
        u1be = u1b + lu1b * il + wu1b * iw;
        u1de = u1d + lu1d * il + wu1d * iw;

        n0e   = n0   + ln0   * il + wn0   * iw;
        nbe   = nb   + lnb   * il + wnb   * iw;
        nde   = nd   + lnd   * il + wnd   * iw;
        vof0e = vof0 + lvof0 * il + wvof0 * iw;
        vofbe = vofb + lvofb * il + wvofb * iw;
        vofde = vofd + lvofd * il + wvofd * iw;

        ai0e = ai0 + lai0 * il + wai0 * iw;
        aibe = aib + laib * il + waib * iw;
        bi0e = bi0 + lbi0 * il + wbi0 * iw;
        bibe = bib + lbib * il + wbib * iw;
        vghe = vghigh + lvghigh * il + wvghigh * iw;
        vgle = vglow  + lvglow  * il + wvglow  * iw;

        vddc = abs(vdd);
        // b2eval.c:57-59 clamps its LOCAL copies of the three bias arguments
        // before anything else runs:
        //     if (Vbs < B2vbb2) Vbs = B2vbb2;   /* B2vbb2 = 2*VBB, b2temp.c:47 */
        //     if (Vgs > B2vgg2) Vgs = B2vgg2;
        //     if (Vds > B2vdd2) Vds = B2vdd2;
        // VBB is a floor in the code even though b2.c:166 calls it "Maximum
        // Vbs", and b2set.c:388 defaults it to +5, so a card that omits VBB is
        // evaluated at Vbs = +10 whatever the real body bias. Real cards give
        // VBB negative, where it is inert.
        vdd2 = 2.0 * vdd;
        vgg2 = 2.0 * vgg;
        vbb2 = 2.0 * vbb;

        // ============ temperature scaling (b2temp.c) ======================
        tk = temp + 273.0;                           // degC -> K
        vt = 8.625e-5 * tk;                          // kT/q [V]
        vt0 = 1.38064852e-23 * 300.15 / 1.6021766208e-19; // b2ld.c's junctions: CONSTvt0

        // ============ geometry, junction sizing ===========================
        // Diffusion geometry: instance AD/AS/PD/PS when given, else the
        // process defaults (wdf/dell are um, hence 1e-12 to m^2; perimeter
        // falls back to the two channel-width edges).
        asrc = as > 0.0 ? as : wdf * dell * 1.0e-12;
        adrn = ad > 0.0 ? ad : wdf * dell * 1.0e-12;
        psrc = ps > 0.0 ? ps : 2.0 * weff;
        pdrn = pd > 0.0 ? pd : 2.0 * weff;

        // Is = JS * A_{S/D}; the 1e-15 floor is b2ld.c's.
        isats = max(asrc * js, 1.0e-15);
        isatd = max(adrn * js, 1.0e-15);
        vcrits = vt0 * ln(vt0 / (1.4142135623730951 * isats));
        vcritd = vt0 * ln(vt0 / (1.4142135623730951 * isatd));

        // CJ is F/m^2 and CJSW F/m: scale to farads before any charge use.
        czbs   = cj   * asrc;
        czbssw = cjsw * psrc;
        czbd   = cj   * adrn;
        czbdsw = cjsw * pdrn;

        omj   = max(1.0 - mj,   0.01);
        omjsw = max(1.0 - mjsw, 0.01);

        // ============ series resistance ===================================
        // g = m/(RSH*squares); RSH*squares = 0 collapses the node (b2set.c:486,
        // b2temp.c:250). A 1e12 stand-in short rounds gds to ulp(1e12) =
        // 1.2e-4 S in the AC Jacobian (#157).
        gdrain  = (rsh > 0.0 && nrd > 0.0) ? m / (rsh * nrd) : 0.0;
        gsource = (rsh > 0.0 && nrs > 0.0) ? m / (rsh * nrs) : 0.0;

        // ============ bias and limiting (b2ld.c) ==========================
        // mos1.va's ladder, which b2ld.c shares: "fetlimds" on both gate legs +
        // "limvds" fetlims the leg the OLD vds picks and derives the other;
        // "pnjlimds" limits one bulk junction, picked by the LIMITED vds, and
        // moves only the bulk. The trailing `ty` is VerA's frame sign; it must be
        // real-typed, hence the copy.
        ty  = type;
        vtx = vfbe + phie + k1e * sqrt(phie) - k2e * phie;  // zero-bias vth
        // The argument after the frame sign is the MODEINITJCT seed: vgs =
        // type*vt0, vds = 0, vbs = -1. ponytail: fetlim's threshold is the
        // zero-bias vth, where b2ld.c uses the previous load's von; porting the
        // von chain ahead of the limits (as mos1.va does) is the upgrade.
        vgs = ty * $limit(V(g, si), "fetlimds", vtx, ty, ty * vtx);
        vgd = ty * $limit(V(g, di), "fetlimds", vtx, ty);
        vds = ty * $limit(V(di, si), "limvds", ty, 0.0);
        vbs = ty * $limit(V(b, si), "pnjlimds", vt0, vcrits, ty, -1.0);
        vbd = ty * $limit(V(b, di), "pnjlimds", vt0, vcritd, ty);

        // ============ bulk junctions ======================================
        // On the true junction voltages (mode-free).
        ibs = jcur(vbs, isats, vt0, 1.0e-12);
        ibd = jcur(vbd, isatd, vt0, 1.0e-12);

        // ============ mode swap ===========================================
        vdsneg = min(vds, 0.0);                 // swap offset
        // b2eval.c:57-59, applied to the swapped (post-mode) triple, which is
        // what b2ld.c hands B2evaluate. The junction diodes and depletion
        // charges deliberately stay on the unclamped node voltages: they
        // are computed in b2ld.c, outside B2evaluate, and never see the clamp.
        vbx  = max(vbs - vdsneg, vbb2);
        vgsx = min(vgs - vdsneg, vgg2);
        vdsx = min(abs(vds), vdd2);
        // Smooth mode sign: +1 forward, -1 reverse.
        mode = vds / (abs(vds) + 1.0e-30);

        // ============ drain current (b2eval.c) ============================
        // Threshold voltage and the bulk-charge factor Aa (b2eval.c).
        // The vbx > 0 branch is BSIM2's own continuation (T1s = phi^1.5 /
        // (phi + vbx/2), which equals sqrt(phi) at vbx = 0).
        if (vbx <= 0.0) begin
            phisb = phie - vbx;
            t1s   = sqrt(phisb);
        end else begin
            phisb = phie * phie / (phie + vbx);
            t1s   = phis3 / (phie + 0.5 * vbx);
        end
        eta  = eta0e + etabe * vbx;
        vth  = vfbe + phie + k1e * t1s - k2e * phisb - eta * vdsx;
        vgst = vgsx - vth;

        gg = 1.0 - 1.0 / (1.744 + 0.8364 * phisb);
        aa = max(1.0 + 0.5 * gg * k1e / t1s, 0.1);

        // Vgeff — the Vgg/Vgt transition. Weak inversion below
        // vgle, Vgst above vghe, a C1 Hermite cubic between the two knots.
        // The weak-inversion Vgeff squared reproduces
        //   Ids = beta*Vt^2*exp(vof)*exp(vgst/(n*Vt))*(1 - exp(-vdsx/Vt))
        // through the same Ids expression, so no separate multiplicative
        // subthreshold factor (and no additive Isub) is needed.
        // nsub keeps a positive floor; note nb enters as nb/sqrt(phisb), which
        // is what b2eval.c does and is why it cannot flip sign.
        nsub = max(n0e + nbe / t1s + nde * vdsx, 0.5);
        vof  = vof0e + vofbe * vbx + vofde * vdsx;

        wds  = 1.0 - exp(-min(max(vdsx / vt, 0.0), 80.0));
        wpre = sqrt(2.0 * aa * max(wds, 0.0)) * vt;
        vgwk = wpre * exp(min(0.5 * vof + vgst / (2.0 * nsub * vt), 40.0));
        vglo = wpre * exp(min(0.5 * vof + vgle / (2.0 * nsub * vt), 40.0));
        slo  = vglo / (2.0 * nsub * vt);         // d(vgeff)/d(vgst) at vgle

        hspan = max(vghe - vgle, 1.0e-6);
        tsp   = min(max((vgst - vgle) / hspan, 0.0), 1.0);
        if (vgst >= vghe) begin
            vgeff  = vgst;
            dvgeff = 1.0;
        end else if (vgst <= vgle) begin
            vgeff  = vgwk;
            dvgeff = vgwk / (2.0 * nsub * vt);
        end else begin
            h00 = tsp * tsp * (2.0 * tsp - 3.0) + 1.0;
            h10 = tsp * (tsp * (tsp - 2.0) + 1.0);
            h01 = tsp * tsp * (3.0 - 2.0 * tsp);
            h11 = tsp * tsp * (tsp - 1.0);
            vgeff  = h00 * vglo + h10 * hspan * slo + h01 * vghe + h11 * hspan;
            dvgeff = (6.0 * tsp * (tsp - 1.0) * (vglo - vghe)
                      + (tsp * (3.0 * tsp - 4.0) + 1.0) * hspan * slo
                      + tsp * (3.0 * tsp - 2.0) * hspan) / hspan;
        end
        vgeff = max(vgeff, 1.0e-18);

        // Mobility: vertical field (Ua/Ub), lateral field (U1) and the
        // Vds interpolation of beta between its vdsx = 0 and vdsx = vdd
        // endpoints. Beta(0) = beta0b and Beta(vdd) = betas identically,
        // which is what makes MUS0/MUSB the vdsx = vdd endpoint.
        ua    = ua0e + uabe * vbx;
        ub    = ub0e + ubbe * vbx;
        uvert = max(1.0 + vgeff * (ua + vgeff * ub), 0.2);

        u1s   = u10e + u1be * vbx;
        // b2eval.c leaves Vc unclamped (U1s goes negative at deep Vbs); the
        // floor only keeps the sqrt argument positive.
        vc    = u1s * vgeff / (aa * uvert);
        kk    = 0.5 * (1.0 + vc + sqrt(max(1.0 + 2.0 * vc, 1.0e-18)));
        vdsat = max(vgeff / (aa * sqrt(kk)), 1.0e-18);
        vdsch = min(vdsx, vdsat);
        t4    = vdsch / vdsat - 1.0;             // 0 at vdsat, -1 at vdsx = 0
        u1    = u1s * (1.0 - u1de * t4 * t4);

        beta0b = bfac * (mu0   + mu0be * vbx);
        betas  = bfac * (mus0e + musbe * vbx);
        beta2  = mu20e + mu2be * vbx + mu2ge * vgsx;          // unitless
        beta3  = bfac * (mu30e + mu3be * vbx + mu3ge * vgsx);
        beta4  = bfac * (mu40e + mu4be * vbx + mu4ge * vgsx);
        beta1  = betas - (beta0b + vddc * (beta3 - vddc * beta4));
        targ   = max(min(vdsx * beta2 / vdsat, 30.0), -30.0);
        beta   = max(beta0b + beta1 * tanh(targ) + vdsx * (beta3 - beta4 * vdsx),
                     1.0e-18);
        // b2eval.c:274-287: Utot = Uvert + U1*Vds, floored at 0.5. The
        // saturation branch is Beta/Uvert with no U1 term; vdsch = min(vdsx,
        // vdsat) reproduces it because Uvert + U1*Vdsat = Uvert*(1 + Vc/sqrt(Kk))
        // cancels (2*sqrt(Kk) - 1) in the triode numerator.
        betaeff = beta / max(uvert + u1 * vdsch, 0.5);

        // Channel current; vdsch = min(vdsx, vdsat) unifies triode and
        // saturation (the triode expression evaluated at vdsat is exactly
        // b2eval.c's saturation branch, 0.5*beta*vgeff^2/(Aa*Kk), since
        // sqrt(Kk) = (1 + sqrt(1+2*Vc))/2).
        // b2eval.c:337-343: below vglow the current is the closed form
        // Beta*Vt^2*exp(Vof + Vgst/(n*Vt))*(1 - exp(-Vds/Vt)), with no
        // Uvert/U1/Kk/Aa in it (only Beta's tanh still sees Vdsat).
        if (vgst < vghe && vgst <= vgle)
            idscore = beta * vt * vt
                      * exp(vof + max(vgst / (nsub * vt), -60.0))
                      * (1.0 - exp(-min(vdsx / vt, 30.0)));
        else
            idscore = betaeff * (vgeff - 0.5 * aa * vdsch) * vdsch;

        // Output-conductance / hot-electron term, b2eval.c: only past Vdsat
        // and only when AI0 != 0 (AIB alone does not switch it on).
        ai   = ai0e + aibe * vbx;
        bi   = bi0e + bibe * vbx;
        dvds = max(vdsx - vdsat, 1.0e-20);
        fclm = (ai0e != 0.0 && vdsx > vdsat)
               ? 1.0 + ai * exp(-min(bi / dvds, 30.0)) : 1.0;

        id  = max(idscore * fclm, 0.0);
        idst = (id + 1.0e-12 * vdsx) * m * type * mode;

        // gm for the noise PSD only. ponytail: d(idscore)/d(vgeff) is vdsch in
        // triode and 2*idscore/vgeff in saturation; idscore/(vgeff -
        // 0.5*aa*vdsch) is both at once (at vdsch = vdsat, Kk -> 1, the
        // denominator is exactly vgeff/2). Chain through dvgeff for vgsx.
        gmch = idscore * dvgeff / max(vgeff - 0.5 * aa * vdsch, 1.0e-9);

        // ============ junction and gate charges ===========================
        // Overlaps are linear, on the drawn W for gate-source and gate-drain
        // and Leff for gate-bulk (b2ld.c:152-154).
        qgso = cgso * w * m * V(g, si);
        qgdo = cgdo * w * m * V(g, di);
        qgbo = cgbo * leff * m * V(g, b);

        // Intrinsic gate, bulk and drain charges, b2eval.c:407-559, in the
        // swapped frame on the clamped triple and the raw gate drive vgst
        // (not vgeff): accumulation, depletion, then strong inversion with
        // its own Vdsat. Drain partition 40/60 (cdg = -0.4*cgg).
        // Charges built from the folded voltages are folded charges; type
        // converts them back.
        vbseff = (vbx < 0.0) ? vbx : phie - phisb;
        arg1   = vgsx - vbseff - vfbe;
        qbulk  = coxwl / 3.0 * (arg1 - vgst);
        if (arg1 <= 0.0) begin
            qgch = coxwl * arg1;
            qbch = -qgch;
            qdch = 0.0;
        end else if (vgst <= 0.0) begin
            t0   = arg1 / (arg1 - vgst);
            qgch = coxwl * arg1 * (1.0 - t0 * (1.0 - t0 / 3.0));
            qbch = -qgch;
            qdch = 0.0;
        end else begin
            uvq  = max(1.0 + vgst * (ua + vgst * ub), 0.2);
            vcq  = u1s * vgst / (aa * uvq);
            kkq  = 0.5 * (1.0 + vcq + sqrt(max(1.0 + 2.0 * vcq, 1.0e-18)));
            vdsq = vgst / (aa * sqrt(kkq));
            qbch = -qbulk;
            if (vdsx >= vdsq) begin
                qgch = 2.0 / 3.0 * coxwl * vgst + qbulk;
                qdch = -0.4 * 2.0 / 3.0 * coxwl * vgst;
            end else begin
                vgdt = vgst * (1.0 - vdsx / vdsq);
                t0   = vgst / (vgst + vgdt);
                t1   = vgdt / (vgst + vgdt);
                t5   = t0 * t1;
                qgch = 2.0 / 3.0 * coxwl * (vgst + vgdt - vgdt * t0) + qbulk;
                qdch = -coxwl / 3.0 * (0.2 * vgdt + 0.8 * vgst + vgdt * t1
                                       + 0.2 * t5 * (vgdt - vgst));
            end
        end
        qgch = type * m * qgch;
        qbch = type * m * qbch;
        qdch = type * m * qdch;

        qbs = m * type * jcharge(type * V(b, si), czbs, czbssw,
                                  pb, pbsw, mj, mjsw, omj, omjsw);
        qbd = m * type * jcharge(type * V(b, di), czbd, czbdsw,
                                  pb, pbsw, mj, mjsw, omj, omjsw);

        // ============ contributions =======================================
        // Not the family's canonical order: the node sums are floating-point,
        // and the canonical order moves bsim2's DC sweeps by 1 ulp.
        I(di, si) <+ idst;

        // Series resistances with their thermal noise (mos1noi.c).
        if (gdrain > 0.0)
            I(d, di) <+ gdrain * V(d, di)
                      + white_noise(4.0 * 1.38064852e-23 * tk * gdrain, "rd");
        else V(d, di) <+ 0.0;
        if (gsource > 0.0)
            I(s, si) <+ gsource * V(s, si)
                      + white_noise(4.0 * 1.38064852e-23 * tk * gsource, "rs");
        else V(s, si) <+ 0.0;

        // ============ noise (mos1noi.c form) ==============================
        // The flicker denominator is Weff*Leff*Cox'^2.
        // Both sources carry m, as b2noi.c's B2m (#48).
        I(di, si) <+ white_noise(4.0 * 1.38064852e-23 * tk * 2.0 / 3.0 * m * abs(gmch),
                                 "channel");
        if (kf > 0.0) begin
            I(di, si) <+ flicker_noise(kf * m * pow(abs(id), af)
                                       / (weff * leff * cox * cox),
                                       1.0, "flicker");
        end

        I(b, si) <+ m * type * ibs;
        I(b, di) <+ m * type * ibd;
        I(g, si) <+ ddt(qgso);
        I(g, di) <+ ddt(qgdo);
        I(g, b)  <+ ddt(qgbo);
        I(b, si) <+ ddt(qbs);
        I(b, di) <+ ddt(qbd);
        // The intrinsic charges sit on the swapped frame: its source is si in
        // forward mode and di in reverse, which takes -(qg + qb + qd).
        // LRM 5.8.1: ddt on the spine, only its use conditional (E0514).
        dqg = ddt(qgch);
        dqb = ddt(qbch);
        dq  = ddt(qdch);
        if (mode >= 0.0) begin
            I(g, si)  <+ dqg;
            I(b, si)  <+ dqb;
            I(di, si) <+ dq;
        end else begin
            I(g, di)  <+ dqg;
            I(b, di)  <+ dqb;
            I(si, di) <+ dq;
        end
    end
endmodule
