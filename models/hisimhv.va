`include "constants.vams"

/***********************************************************************

 HiSIM (Hiroshima University STARC IGFET Model)
 Copyright (C) 2000-2016 Hiroshima University and STARC
 Copyright (C) 2016-2023 Hiroshima University
 HiSIM_HV (High-Voltage Model)
 Copyright (C) 2007-2016 Hiroshima University and STARC
 Copyright (C) 2016-2023 Hiroshima University

 MODEL NAME : HiSIM_HV
 ( VERSION : 2  SUBVERSION : 5  REVISION : 1 )
 Model Parameter 'VERSION' : 2.51
 FILE : hisimhv.va

 Date : 2023.02.09

 released by Hiroshima University

***********************************************************************/
//
////////////////////////////////////////////////////////////////
//
//
//
//
//Licensed under the Educational Community License, Version 2.0
//(the "License"); you may not use this file except in
//compliance with the License.
//
//You may obtain a copy of the License at:
//
//      http://opensource.org/licenses/ECL-2.0
//
//Unless required by applicable law or agreed to in writing,
//software distributed under the License is distributed on an
//"AS IS" BASIS, WITHOUT WARRANTIES OR CONDITIONS OF ANY KIND,
//either express or implied. See the License for the specific
//language governing permissions and limitations under the
//License.
//
//
//The HiSIM_HV standard has been supported by the members of
//Silicon Integration Initiative's Compact Model Coalition. A
//link to the most recent version of this standard can be found
//at:
//
//http://www.si2.org/cmc
//
////////////////////////////////////////////////////////////////
//
//
//* Memorandum on programming
//*
//*(1) Bias(x: b|d|g)
//*     . vxs : Input arguments: Outer branch voltages.
//*     . vxsi: Input arguments: Inner branch voltages.
//*     . deltemp: Input argument: delta temperature.
//*     . Vxse: Internal name for outer branch voltages.
//*     . Vxs:  Internal name for inner branch voltages.
//*     . Vbscl:Inner bulk source voltage is clamped within a specified region.
//*
//* (2) Device Mode
//*     . Normal mode(Vds>=0 for nMOS) is assumed.
//*     . The sign of Vdse is assumed to be changed simultaneously, if the sign of Vds is changed;
//*       hence Vdse may become negative even though Vds >=0.
//*     . In case of reverse mode, parent routines have to properly
//*       transform or interchange inputs and outputs except ones
//*       related to junction diodes, which are regarded as being
//*       fixed to the nodal S/D.
//*
//* (3) Modification for symmetry at Vds=0
//*     . Vxsz: Modified bias. (x: b|d|g)
//*     . Ps0z: Modified Ps0.
//*     . The following variables are calculated as a function of
//*       modified biases or potential.
//*         Tox, Cox, (-- with quantum effect)
//*         Vth*, dVth*, dPpg, Igate, Igidl, Igisl.
//*     . The following variables are calculated using a transform
//*       function.
//*         Lred
//*
//*(4) Zones and Cases(terminology)
//*
//*       Chi:=beta*(Ps0-Vbs)=       0    3    5
//*
//*                      Zone:    A  | D1 | D2 | D3
//*                                  |
//*                    (accumulation)|(depletion)
//*                                  |
//*                      Vgs =     Vgs_fb                Vth
//*                                              /       /
//*                      Case:    Nonconductive / Conductive
//*                                            /
//*             VgVt:=Qn0/Cox=             VgVt_small
//*
//*     . Ids is regarded as zero in zone-A.
//*     . Procedure to calculate Psl and dependent variables is
//*       omitted in the nonconductive case. Ids and Qi are regarded
//*       as zero in this case.
//*
//*********************************************************************/
//

`include "disciplines.vams"

// Definitions for `ifdef directives
//VAMPyRE NOTICE//`define _6_PORTS_CONNECTED_
//`define COEXTDIO 1                  // Flag of the External Diode Model
`define REPLACE_CLIPPING_WITH_SMOOTHING

//`define _AGING_
//`define _AGING_DEBUG_
// ---- begin `include "HSMHV_macrosAndDefs.inc" ----
/***********************************************************************

 HiSIM (Hiroshima University STARC IGFET Model)
 Copyright (C) 2000-2016 Hiroshima University and STARC
 Copyright (C) 2016-2023 Hiroshima University
 HiSIM_HV (High-Voltage Model)
 Copyright (C) 2007-2016 Hiroshima University and STARC
 Copyright (C) 2016-2023 Hiroshima University

 MODEL NAME : HiSIM_HV
 ( VERSION : 2  SUBVERSION : 5  REVISION : 1 )
 Model Parameter 'VERSION' : 2.51
 FILE : HSMHV_macrosAndDefs.inc

 Date : 2023.02.09

 released by Hiroshima University

***********************************************************************/
//
////////////////////////////////////////////////////////////////
//
//
//
//
//Licensed under the Educational Community License, Version 2.0
//(the "License"); you may not use this file except in
//compliance with the License.
//
//You may obtain a copy of the License at:
//
//      http://opensource.org/licenses/ECL-2.0
//
//Unless required by applicable law or agreed to in writing,
//software distributed under the License is distributed on an
//"AS IS" BASIS, WITHOUT WARRANTIES OR CONDITIONS OF ANY KIND,
//either express or implied. See the License for the specific
//language governing permissions and limitations under the
//License.
//
//
//The HiSIM_HV standard has been supported by the members of
//Silicon Integration Initiative's Compact Model Coalition. A
//link to the most recent version of this standard can be found
//at:
//
//http://www.si2.org/cmc
//
////////////////////////////////////////////////////////////////
//

//VAMPyRE NOTICE//`define ALIAS(alias,paramName) aliasparam alias = paramName;
`define OPP(nam,uni,des)               (*units=uni,                             desc=des*)           real    nam;
`define OPM(nam,uni,des)               (*units=uni, multiplicity="multiply",    desc=des*)           real    nam;
`define OPD(nam,uni,des)               (*units=uni, multiplicity="divide",      desc=des*)           real    nam;
`define MPRnb(nam,def,uni,        des) (*units=uni,                  desc=des*) parameter real    nam=def;
`define MPRcc(nam,def,uni,lwr,upr,des) (*units=uni,                  desc=des*) parameter real    nam=def from[lwr:upr];
`define MPRoo(nam,def,uni,lwr,upr,des) (*units=uni,                  desc=des*) parameter real    nam=def from(lwr:upr);
`define MPRco(nam,def,uni,lwr,upr,des) (*units=uni,                  desc=des*) parameter real    nam=def from[lwr:upr);
//VAMPyRE NOTICE//`define MPRoc(nam,def,uni,lwr,upr,des) (*units=uni,                  desc=des*) parameter real    nam=def from(lwr:upr];
`define MPIcc(nam,def,uni,lwr,upr,des) (*units=uni,                  desc=des*) parameter integer nam=def from[lwr:upr];
`define MPInb(nam,def,uni,        des) (*units=uni,                  desc=des*) parameter integer nam=def;
`define MPIsw(nam,def,uni,        des) (*units=uni,                  desc=des*) parameter integer nam=def from[  0:  1];
`define MPIty(nam,def,uni,        des) (*units=uni,                  desc=des*) parameter integer nam=def from[ -1:  1] exclude 0;
`define IPRnb(nam,def,uni,        des) (*units=uni, type="instance", desc=des*) parameter real    nam=def;
//VAMPyRE NOTICE//`define IPRcc(nam,def,uni,lwr,upr,des) (*units=uni, type="instance", desc=des*) parameter real    nam=def from[lwr:upr];
`define IPRoo(nam,def,uni,lwr,upr,des) (*units=uni, type="instance", desc=des*) parameter real    nam=def from(lwr:upr);
`define IPRco(nam,def,uni,lwr,upr,des) (*units=uni, type="instance", desc=des*) parameter real    nam=def from[lwr:upr);
//VAMPyRE NOTICE//`define IPRoc(nam,def,uni,lwr,upr,des) (*units=uni, type="instance", desc=des*) parameter real    nam=def from(lwr:upr];
//VAMPyRE NOTICE//`define IPInb(nam,def,uni,        des) (*units=uni, type="instance", desc=des*) parameter integer nam=def;
//VAMPyRE NOTICE//`define IPIsw(nam,def,uni,        des) (*units=uni, type="instance", desc=des*) parameter integer nam=def from[  0:  1];
`define BPRnb(nam,def,uni,        des) (*units=uni, type="instance", desc=des*) parameter real    nam=def;
`define BPIcc(nam,def,uni,lwr,upr,des) (*units=uni, type="instance", desc=des*) parameter integer nam=def from[lwr:upr];
//VAMPyRE NOTICE//`define BPRcc(nam,def,uni,lwr,upr,des) (*units=uni, type="instance", desc=des*) parameter real    nam=def from[lwr:upr];
`define BPRoo(nam,def,uni,lwr,upr,des) (*units=uni, type="instance", desc=des*) parameter real    nam=def from(lwr:upr);
`define BPRco(nam,def,uni,lwr,upr,des) (*units=uni, type="instance", desc=des*) parameter real    nam=def from[lwr:upr);
//VAMPyRE NOTICE//`define BPRoc(nam,def,uni,lwr,upr,des) (*units=uni, type="instance", desc=des*) parameter real    nam=def from(lwr:upr];
//VAMPyRE NOTICE//`define BPInb(nam,def,uni,        des) (*units=uni, type="instance", desc=des*) parameter integer nam=def;
`define BPIsw(nam,def,uni,        des) (*units=uni, type="instance", desc=des*) parameter integer nam=def from[  0:  1];
//VAMPyRE NOTICE//`define BPIty(nam,def,uni,        des) (*units=uni, type="instance", desc=des*) parameter integer nam=def from[ -1:  1] exclude 0;

`define IPM
//VAMPyRE NOTICE//`define TESTGIVEN(parameter) $param_given(parameter)
`define GMIN \
    begin \
        if ($param_given(GMIN)) \
            gminMod  = GMIN; \
        else \
            gminMod  = $simparam("gmin",0); \
    end
`define MFACTOR_DEC mMod = $mfactor;
`define MFACTOR_USE 1.0
//

`define C_RTH_MIN     0.0001
`define Kflic         1
`define Kwhite        1

// For Debugging print
//`define DEBUG 1
//VAMPyRE NOTICE//`ifdef DEBUG
//VAMPyRE NOTICE//`define DEBUG_PRINT(xName, x) $strobe("%s = %g", xName, 1.0*x)
//VAMPyRE NOTICE//`else
//VAMPyRE NOTICE//`define DEBUG_PRINT(xName, x)
//VAMPyRE NOTICE//`endif

//VAMPyRE NOTICE//`define NMOS         1                          // MOS type
//VAMPyRE NOTICE//`define PMOS         -1                         //
`define HiSIM_NORMAL_MODE 1                     // device working mode
//VAMPyRE NOTICE//`define HiSIM_REVERSE_MODE -1                   //

`define SUBVERSION ( VERSION*10 % 10 )

//---------------------------------------------------*
//* Numerical constants. (macro)
//*-----------------*/
`ifdef  _FLOAT_H
`define C_EPS_M      (DBL_EPSILON)              // machine epsilon
`else
`define C_EPS_M      (2.2204460492503131e-16)   //
`endif
//VAMPyRE NOTICE//`define MAX_EXP      5.834617425e14             //
//VAMPyRE NOTICE//`define MIN_EXP      1.713908431e-15            //
`define EXP_THR      34.0                       //

`define C_SQRT_2     (1.414213562373095e+00)    // sqrt(2)
`define C_1oSQRT2    (0.7071067811865475)       // 1/sqrt(2)
`define C_1o3        (3.333333333333333e-01)    // 1/3
`define C_2o3        (6.666666666666667e-01)    // 2/3
`define C_1o6        (1.666666666666667e-01)    // 1/6
`define C_2p_1o3     (1.259921049894873e+00)   // 2^(1/3)
`define C_Pi         (3.141592653589793)       // Pi
//VAMPyRE NOTICE//`define C_Pio2       (1.570796326794897)       //
//VAMPyRE NOTICE//`define C_Pio4       (0.7853981633974483)       //
`define C_m2cm_p2    (1.0e4)                    // Unit change
`define C_m2um       (1.0e6)                    //
//---------------------------------------------------*
//* Physical constants/properties. (macro)
//*-----------------*/
`define C_QE         (1.6021918e-19)            // Elemental charge
`define C_KB         (1.3806226e-23)            // Boltzmann constant
`define C_ESI        (1.034943e-10)             // Permittivity of Si, SiO2 and vacuum
`define C_EOX        (3.453133e-11)             //
`define C_VAC        (8.8541878e-12)            //
//VAMPyRE NOTICE//`define C_T300       (300e+00)                  // Room temperature constants
`define C_b300       (3.868283e+01)             //
`define C_Nin0       (1.04e+16)                 // Intrinsic carrier density at 300K
//---------------------------------------------------*
//* Functions. (macro)  Take care of the arguments.
//*-----------------*/
//VAMPyRE NOTICE//`define Fn_Sqr(x)   ( (x)*(x) ) // x^2 */
`define Fn_Max(x,y) ( (x) >= (y) ? (x) : (y) ) // max[x,y] */
`define Fn_Min(x,y) ( (x) <= (y) ? (x) : (y) ) // min[x,y] */
`define Fn_Sgn(x)   ( (x) >= 0  ?  (1) : (-1) )    // sign[x] */
//===========================================================*
//* pow
//*=================*/
`ifdef  POW_TO_EXP_AND_LOG
`define Fn_Pow( x , y ) ((x==0.0) ? 0.0 : exp((y) * ln( x ) ) )
`else
`define Fn_Pow( x , y ) ((x==0.0) ? 0.0 : pow( x , y ))
`endif
`define C_m2cm       (1.0e2)                    //
`define C_cm2m_p3    (1.0e-6)                   //
`define C_m2cm_p1o2  (1.0e1)                    //
//***********************************************************************/
`define C_rdtemp_min 5.0e-3                     //
`define C_rdtemp_dlt 1.0e-2                     //
`define vth_dlt      1.0e-3
`define cclmmdf      1.0e-1
`define C_cm2m       1.0e-2
`define qme_dlt      1.0e-9 * `C_cm2m
`define rdsl2_dlt    10.0e-3 * `C_cm2m
`define rdsu2_dlt    50.0e-6 * `C_cm2m
`define rdsz_dlt     0.1e-3 * `C_cm2m
`define eef_dlt      1.0e-2 / `C_cm2m
`define sti2_dlt     2.0e-3
`define pol_dlt      5.0e-2
`define psisti_dlt   5.0e-3
`define lp_s0_max    40
`define lp_sl_max    40
`define lp_se_max    150
`define dP_max       0.1e0
`define ps_conv      1.0e-12
`define ps_conv2     1.0e-10
`define gs_conv      1.0e-8
`define znbd3        3.0e0
`define znbd5        5.0e0
`define cn_nc3       `C_SQRT_2 / 108e0
`define cn_nc51      0.707106781186548      // sqrt(2)/2 */
`define cn_nc52      -0.117851130197758     // -sqrt(2)/12 */
`define cn_nc53      0.0178800506338833     // (187 - 112*sqrt(2))/1600 */
`define cn_nc54      -0.00163730162779191   // (-131 + 88*sqrt(2))/4000 */
`define cn_nc55      6.36964918866352e-5    // (1509-1040*sqrt(2))/600000 */
`define cn_im53      2.9693154855770998e-1
`define cn_im54      -7.0536542840097616e-2
`define cn_im55      6.1152888951331797e-3
`define c_ps0ini_2   8.0e-4
`define c_pslini_1   0.3e0
`define c_pslini_2   3.0e-2
`define VgVt_Small   1.0e-12
`define epsm10       10.0e0 * `C_EPS_M
`define Small        1.0e-25
`define Small2       1e-12                  // for Ra(Vdse) dependence */
`define c_exp_2      7.38905609893065
`define large_arg    60
`define pol_b        1.0
`define igate_dlt    1.0e-2 / `C_cm2m
`define gidlvds_dlt  1.0e-5
`define gidla        100.0
`define c_sqrt_15    3.872983346207417e0    // sqrt(15) */
`define Cox_Small    1.0e-6
`define c_16o135     1.185185185185185e-1   // 16/135 */
`define delta_rd     10e-3 * `C_cm2m
`define Ra_N         20.0                   // smoothing parameter for Ra */
`define Res_min      RMIN
`define RDVSUB       RDVSUB
`define RDVDSUB      RDVDSUB
`define DDRIFT       DDRIFT
`define VBISUB       VBISUB
`define NSUBSUB      MKS_NSUBSUB
`define dlt_rd23     1.0e-6 / `C_m2cm
`define tau_min      1.0e-15
`define inf          1e+300
`define VXBGMTDLT    ( 0.5     )
`define deepPT_dlt   0.01                   // [V]

//*-----------------*/
`define C_IDD_MIN    1.0e-15                    //
`define C_VDS_MIN    1.0E-6
`define C_sub_delta  0.1
`define C_gidl_delta 0.5                        //
//===========================================================*
//* Exp() for PGD.
//* - ExpLim(-3)=0
//*=================*/
`define Fn_ExpLim( y , x , dx ) begin \
    if ((x) < -3.0 ) begin \
        dx = 0.0 ; \
        y = 0.0 ; \
    end else if ((x) < 0.0 ) begin \
        dx =  1.0 + (x) * ( 2 * (1.0/3.0) + (x) * 3 * (1.0/27.0) )  ; \
        y = 1.0 + (x) * ( 1.0 + (x) * ( (1.0/3.0) + (x) * (1.0/27.0) ) ) ; \
    end else begin \
        dx =  1.0 + (x) * ( 2 * (1.0/3.0) + (x) * ( 3 * 0.0402052934513951 \
                + (x) * 4 * 0.148148111111111 ) ) ; \
        y = 1.0 + (x) * ( 1.0 + (x) * ( (1.0/3.0) + (x) * ( 0.0402052934513951 \
              + (x) * 0.148148111111111 ) ) ) ; \
    end \
end
//===========================================================*
//* Macro Functions for ceiling/flooring/symmetrization.
//*=================*/
//---------------------------------------------------*
//* smoothUpper: ceiling.
//*      y = xmax - 0.5 ( arg + sqrt( arg^2 + 4 xmax delta ) )
//*    arg = xmax - x - delta
//*-----------------*/
`define Fn_SU( y , x , xmax , delta , dx ) begin \
    TMF1 = ( xmax ) - ( x ) - ( delta ) ; \
    TMF2 = 4.0 * ( xmax ) * ( delta) ; \
    TMF2 = TMF2 > 0.0 ?  TMF2 : - ( TMF2 ) ; \
    TMF2 = sqrt ( TMF1 * TMF1 + TMF2 ) ; \
    dx = 0.5 * ( 1.0 + TMF1 / TMF2 ) ; \
    y = ( xmax ) - 0.5 * ( TMF1 + TMF2 ) ; \
end
`define Fn_SU2( y , x , xmax , delta , dy_dx , dy_dxmax ) begin \
    TMF1 = ( xmax ) - ( x ) - ( delta ) ; \
    TMF2 = 4.0 * ( xmax ) * ( delta) ; \
    TMF2 = TMF2 > 0.0 ?  TMF2 : - ( TMF2 ) ; \
    TMF2 = sqrt ( TMF1 * TMF1 + TMF2 ) ; \
    dy_dx = 0.5 * ( 1.0 + TMF1 / TMF2 ) ; \
    dy_dxmax = 0.5 * ( 1.0 - ( TMF1 + 2.0 * delta ) / TMF2 ) ; \
    y = ( xmax ) - 0.5 * ( TMF1 + TMF2 ) ; \
end
`define Fn_SUtemp( y , x , xmax , delta ) begin \
    TMF1 = ( xmax ) - ( x ) - ( delta ) ; \
    TMF2 = 4.0 * ( xmax ) * ( delta) ; \
    TMF2 = TMF2 > 0.0 ?  TMF2 : - ( TMF2 ) ; \
    TMF2 = sqrt ( TMF1 * TMF1 + TMF2 ) ; \
    y = ( xmax ) - 0.5 * ( TMF1 + TMF2 ) ; \
end
//---------------------------------------------------*
//* smoothLower: flooring.
//*      y = xmin + 0.5 ( arg + sqrt( arg^2 + 4 xmin delta ) )
//*    arg = x - xmin - delta
//*-----------------*/
`define Fn_SL( y , x , xmin , delta , dx ) begin \
    TMF1 = ( x ) - ( xmin ) - ( delta ) ; \
    TMF2 = 4.0 * ( xmin ) * ( delta ) ; \
    TMF2 = TMF2 > 0.0 ?  TMF2 : - ( TMF2 ) ; \
    TMF2 = sqrt ( TMF1 * TMF1 + TMF2 ) ; \
    dx = 0.5 * ( 1.0 + TMF1 / TMF2 ) ; \
    y = ( xmin ) + 0.5 * ( TMF1 + TMF2 ) ; \
end
`define Fn_SL2( y , x , xmin , delta , dy_dx, dy_dxmin ) begin \
    TMF1 = ( x ) - ( xmin ) - ( delta ) ; \
    TMF2 = 4.0 * ( xmin ) * ( delta ) ; \
    TMF2 = TMF2 > 0.0 ?  TMF2 : - ( TMF2 ) ; \
    TMF2 = sqrt ( TMF1 * TMF1 + TMF2 ) ; \
    dy_dx = 0.5 * ( 1.0 + TMF1 / TMF2 ) ; \
    dy_dxmin = 0.5 * ( 1.0 - ( TMF1 - 2.0 * delta ) / TMF2 ) ; \
    y = ( xmin ) + 0.5 * ( TMF1 + TMF2 ) ; \
end
//`ifdef _AGING_
`define Fn_SLtemp( y , x , xmin , delta ) begin \
    TMF1 = ( x ) - ( xmin ) - ( delta ) ; \
    TMF2 = 4.0 * ( xmin ) * ( delta ) ; \
    TMF2 = TMF2 > 0.0 ?  TMF2 : - ( TMF2 ) ; \
    TMF2 = sqrt ( TMF1 * TMF1 + TMF2 ) ; \
    y = ( xmin ) + 0.5 * ( TMF1 + TMF2 ) ; \
end
//`endif //_AGING_
//---------------------------------------------------*
//* smoothZero: flooring to zero.
//*      y = 0.5 ( x + sqrt( x^2 + 4 delta^2 ) )
//*-----------------*/
`define Fn_SZ( y , x , delta , dx ) begin \
    TMF2 = sqrt ( ( x ) *  ( x ) + 4.0 * ( delta ) * ( delta) ) ; \
    dx = 0.5 * ( 1.0 + ( x ) / TMF2 ) ; \
    y = 0.5 * ( ( x ) + TMF2 ) ; \
    if ( y < 0.0 ) begin y=0.0; dx=0.0; end \
end
`define Fn_SZtemp( y , x , delta ) begin \
    TMF1 = sqrt ( ( x ) *  ( x ) + 4.0 * ( delta ) * ( delta) ) ; \
    y = 0.5 * ( ( x ) + TMF1 ) ; \
end
//---------------------------------------------------*
//* CeilingPow: ceiling for positive x, flooring for negative x.
//*      y = x * xmax / ( x^{2m} + xmax^{2m} )^{1/(2m)}
//* note:
//*   - xmax has to be positive.
//*   - -xmax < y < xmax.
//*   - dy/dx|_{x=0} = 1.
//*-----------------*/
`define Fn_CP( y , x , xmax , pw , dx ) begin \
    x2 = (x) * (x) ; \
    xmax2 = (xmax) * (xmax) ; \
    xp = 1.0  ;\
    xmp = 1.0 ; \
    m0 = 0 ;\
    mm =0; \
    arg = 0.0 ;\
    dnm =0.0; \
    for ( m0 = 0 ; m0 < pw ; m0 = m0 + 1 ) begin \
        xp = xp * x2 ; \
        xmp = xmp * xmax2 ; \
    end \
    arg = xp + xmp ; \
    dnm = arg ; \
    if ( pw == 1 || pw == 2 || pw == 4 || pw == 8 ) begin \
        if ( pw == 1 ) begin mm = 1 ; \
        end else if ( pw == 2 ) begin \
            mm = 2 ; \
        end else if ( pw == 4 ) begin \
            mm = 3 ; \
        end else if ( pw == 8 ) begin \
            mm = 4 ; \
        end \
        for ( m0 = 0 ; m0 < mm ; m0 = m0 + 1 ) begin \
            dnm = sqrt( dnm ) ; \
        end \
    end else begin \
        dnm = `Fn_Pow( dnm , 1.0 / ( 2.0 * (pw) ) ) ; \
    end \
    dnm = 1.0 / dnm ; \
    y = (x) * (xmax) * dnm ; \
    dx = (xmax) * xmp * dnm / arg ; \
end

`define Fn_SU_CP( y , x , xmax , delta , pw , dx ) begin \
    if (x > xmax - (delta) && delta >= 0.0) begin \
        TMF1 = x - (xmax) + delta ; \
        `Fn_CP( TMF0 , TMF1 , delta , pw , dx )  \
        y = xmax - (delta) + TMF0 ; \
        dx = dx ; \
    end else begin \
        y = x ; \
        dx = 1.0 ; \
    end \
end

//VAMPyRE NOTICE//`define Fn_SU_CP2( y , x , xmax , delta , pw , dx , dxmax ) begin \
//VAMPyRE NOTICE//    if (x > xmax - (delta) && delta >= 0.0) { \
//VAMPyRE NOTICE//        TMF1 = x - (xmax) + delta ; \
//VAMPyRE NOTICE//    Fn_CP( TMF0 , TMF1 , delta , pw , dx )  \
//VAMPyRE NOTICE//    y = xmax - (delta) + TMF0 ; \
//VAMPyRE NOTICE//    dx = dx ; \
//VAMPyRE NOTICE//    dxmax = 1.0-dx ; \
//VAMPyRE NOTICE//end else begin \
//VAMPyRE NOTICE//    y = x ; \
//VAMPyRE NOTICE//    dx = 1.0 ; \
//VAMPyRE NOTICE//    dxmax = 0.0 ; \
//VAMPyRE NOTICE//end \
//VAMPyRE NOTICE//end

`define Fn_SL_CP( y , x , xmin , delta , pw , dx ) begin \
    if (x < xmin + delta && delta >= 0.0) begin \
        TMF1 = xmin + delta - x ; \
        `Fn_CP( TMF0 , TMF1 , delta , pw , dx )  \
        y = xmin + delta - TMF0 ; \
        dx = dx ; \
    end else begin \
        y = x ; \
        dx = 1.0 ; \
    end \
end

//---------------------------------------------------*
//* Declining function using a polynomial.
//*-----------------*/
`define Fn_DclPoly4( y , x , dx ) begin \
    TMF2 = (x) * (x) ; \
    TMF3 = TMF2 * (x) ; \
    TMF4 = TMF2 * TMF2 ; \
    y = 1.0 / ( 1.0 + (x) + TMF2 + TMF3 + TMF4 ) ; \
    dx = - ( 1.0 + 2.0 * (x) + 3.0 * TMF2 + 4.0 * TMF3 )  * y * y  ; \
end
//VAMPyRE NOTICE//`define Fn_DclPoly6( y , x , dx ) begin \
//VAMPyRE NOTICE//    TMF2 = (x) * (x) ; \
//VAMPyRE NOTICE//    TMF3 = TMF2 * (x) ; \
//VAMPyRE NOTICE//    TMF4 = TMF2 * TMF2 ; \
//VAMPyRE NOTICE//    TMF5 = TMF2 * TMF3 ; \
//VAMPyRE NOTICE//    TMF6 = TMF3 * TMF3 ; \
//VAMPyRE NOTICE//    y = 1.0 / ( 1.0 + (x) + TMF2 + TMF3 + TMF4 + TMF5 + TMF6 ) ; \
//VAMPyRE NOTICE//    dx = - ( 1.0 + 2.0 * (x) + 3.0 * TMF2 + 4.0 * TMF3 \
//VAMPyRE NOTICE//         + 5.0 * TMF4 + 6.0 * TMF5 )  * y * y  ; \
//VAMPyRE NOTICE//end
//---------------------------------------------------*
//* "smoothUpper" using a polynomial
//*-----------------*/
`define Fn_SUPoly4( y , x , xmax , dx ) begin \
    TMF1 = (x) / (xmax) ; \
    `Fn_DclPoly4( y , TMF1 , dx )  \
    y = (xmax) * ( 1.0 - y ) ; \
    dx = - dx ; \
end
`define Fn_SUPoly4m( y , x , xmax , dx , dxmax ) begin \
    TMF1 = (x) / (xmax) ; \
    `Fn_DclPoly4( TMF0 , TMF1 , dx )  \
    y = (xmax) * ( 1.0 - TMF0 ) ; \
    dxmax = 1.0 - TMF0 + TMF1 * dx ; \
    dx = - dx ; \
end
//VAMPyRE NOTICE//`define Fn_SUPoly6m( y , x , xmax , dx , dxmax ) begin \
//VAMPyRE NOTICE//    TMF1 = (x) / (xmax) ; \
//VAMPyRE NOTICE//    `Fn_DclPoly6( TMF0 , TMF1 , dx )  \
//VAMPyRE NOTICE//    y = (xmax) * ( 1.0 - TMF0 ) ; \
//VAMPyRE NOTICE//    dxmax = 1.0 - TMF0 + TMF1 * dx ; \
//VAMPyRE NOTICE//    dx = - dx ; \
//VAMPyRE NOTICE//end
//---------------------------------------------------*
//* "smoothUpper" using a power function
//*-----------------*/
`define Fn_SU_POW( y , x , xmax , delta ) begin \
    if ( (x) == 0 || (delta) <= 0 ) begin \
        y = x ; \
    end else begin \
        TMF3 = (x) < 0 ? -1 : 1 ; \
        TMF4 = TMF3 * (x) ; \
        TMF1 = 1.0  + pow( TMF4 / (xmax) , (delta) ) ; \
        TMF2 = pow( TMF1, 1/(delta) ) ; \
        y    = TMF3 * TMF4 / TMF2 ; \
    end \
end

//---------------------------------------------------*
//* SymAdd: evaluate additional term for symmetry.
//*-----------------*/
`define Fn_SymAdd( y , x , add0 , dx ) \
    begin \
        TMF1 = 2.0 * ( x ) / ( add0 ) ; \
        TMF2 = 1.0 + TMF1 * ( (1.0/2) + TMF1 * ( (1.0/6) \
               + TMF1 * ( (1.0/24) + TMF1 * ( (1.0/120) \
               + TMF1 * ( (1.0/720) + TMF1 * (1.0/5040) ) ) ) ) ) ; \
        TMF3 = (1.0/2) + TMF1 * ( (1.0/3) \
               + TMF1 * ( (1.0/8) + TMF1 * ( (1.0/30) \
               + TMF1 * ( (1.0/144) + TMF1 * (1.0/840) ) ) ) ) ; \
        y = (add0) / TMF2 ; \
        dx = - 2.0 * TMF3 / ( TMF2 * TMF2 ) ; \
    end
//---------------------------------------------------*
//* Sym4: 4th order additional term for symmetry.
//*-----------------*/
`define nSym4 2
`define Fn_Sym4( y , x , add0 ) \
    begin \
        TMF1 = pow( (x) , `nSym4 ) ; \
        TMF2 = pow( (add0) , `nSym4 ) ; \
        y = pow( (TMF1+TMF2) , 1.0/`nSym4 ) - pow(TMF2,1.0/`nSym4) ; \
    end

//===========================================================*
//* Sigmoid function
//*=================*/
//`ifdef _AGING_
`define Fn_Sigmoid( y , x ) y = 1.0 / ( 1.0 + exp(- (x)) );
//`endif //_AGING_

`define BINNING(UC_PARAM, PARAM, LPARAM, WPARAM, PPARAM) UC_PARAM = PARAM \
    + LPARAM / Lbin + WPARAM / Wbin \
    + PPARAM / LWbin ;

`define RANGECHECK(param, min, max, pname)          \
    if ( COERRREP && ((param) <(min) ||(param) >(max)) ) begin \
        $write("warning(HiSIM_HV(%m)): (%s = %g) range [%g , %g].\n", \
           pname, (param), (min*1.0), (max*1.0) );            \
    end
`define RANGERESET(param, min, max, pname)              \
    if ( COERRREP && ((param) >(max)) ) begin   \
        $write("reset(HiSIM_HV(%m)): (%s = %g to %g) range [%g , %g].\n", \
           pname, (param), (max*1.0), (min*1.0), (max*1.0) );     \
    end \
    if ( COERRREP && ((param) <(min)) ) begin   \
        $write("reset(HiSIM_HV(%m)): (%s = %g to %g) range [%g , %g].\n", \
           pname, (param), (min*1.0), (min*1.0), (max*1.0) );     \
    end \
    if ((param) <(min) ) begin  \
        param  =(min); \
    end    \
    if ((param) >(max) ) begin  \
        param  =(max); \
    end
`define MINCHECK(param, min, pname)                     \
    if ( COERRREP && ((param) <(min)) ) begin   \
        $write("warning(HiSIM_HV(%m)): (%s = %g) range [%g , %g].\n", \
           pname, (param), (min*1.0), (min*1.0) );                   \
    end
`define MINRESET(param, min, pname)                     \
    if ( COERRREP && ((param) <(min)) ) begin   \
        $write("reset(HiSIM_HV(%m)): (%s = %g to %g) range [%g , %g].\n",    \
           pname, (param), (min*1.0), (min*1.0), (min*1.0) );            \
    end \
    if ((param) <(min) ) begin  \
        param  =(min); \
    end

`define RANGECHECKFoo(param, min, max, pname)          \
    if ( ((param) <= (min) || (param) >= (max)) ) begin \
        $write("fatal(HiSIM_HV(%m)): (%s = %g) range (%g , %g).\n", \
           pname, (param), (min*1.0), (max*1.0) );            \
        FATAL_flag = 1; \
    end
`define RANGECHECKFco(param, min, max, pname)          \
    if ( ((param) <  (min) || (param) >= (max)) ) begin \
        $write("fatal(HiSIM_HV(%m)): (%s = %g) range [%g , %g).\n", \
           pname, (param), (min*1.0), (max*1.0) );            \
        FATAL_flag = 1; \
    end
//VAMPyRE NOTICE//`define RANGECHECKFoc(param, min, max, pname)          \
//VAMPyRE NOTICE//    if ( ((param) <= (min) || (param) >  (max)) ) begin \
//VAMPyRE NOTICE//        $write("fatal(HiSIM_HV(%m)): (%s = %g) range (%g , %g].\n", \
//VAMPyRE NOTICE//           pname, (param), (min*1.0), (max*1.0) );            \
//VAMPyRE NOTICE//        FATAL_flag = 1; \
//VAMPyRE NOTICE//    end
//VAMPyRE NOTICE//`define RANGECHECKFcc(param, min, max, pname)          \
//VAMPyRE NOTICE//    if ( ((param) <  (min) || (param) >  (max)) ) begin \
//VAMPyRE NOTICE//        $write("fatal(HiSIM_HV(%m)): (%s = %g) range [%g , %g].\n", \
//VAMPyRE NOTICE//           pname, (param), (min*1.0), (max*1.0) );            \
//VAMPyRE NOTICE//        FATAL_flag = 1; \
//VAMPyRE NOTICE//    end

//// limited exp function (lexp)
//`define CEXP_THRES 80.0
//`define CMAX_EXP 5.540622384e+34
//`define CMIN_EXP 1.804851387e-35
//analog function real lexp;
//       input x;
//       real x;
//       begin
//         if(x > `CEXP_THRES) begin
//                 lexp = `CMAX_EXP * ( 1.0 + (x) -`CEXP_THRES);
//         end else if(x < -`CEXP_THRES) begin
//                 lexp = `CMIN_EXP;
//         end else begin
//                 lexp = exp(x);
//         end
//       end
//endfunction

//===========================================================*
//* Exp() for large input value.
//*=================*/
`define D_EXP_THRESHOLD (500.0)                //exp(710)=inf
`define D_MAX_EXP       (1.403592217853e+217)  //exp(500.0)
`define C_UNIT_EXP_ARG  (60.0)                 //exp(60.0) may touch the Verilog-A limit
`define C_UNIT_EXP_RES  (1.14200738981568e+26) //exp(60.0)
`define Fn_DExp( y , x , dx) begin \
    if ((x) >= `D_EXP_THRESHOLD) begin \
        y  = `D_MAX_EXP * (1 + (x) - `D_EXP_THRESHOLD); \
        dx = `D_MAX_EXP ; \
    end else begin \
        TMF1 = (x); \
        y = 1.0; \
        while (TMF1 >= `C_UNIT_EXP_ARG ) begin \
            y = y * `C_UNIT_EXP_RES; \
            TMF1 = TMF1 - `C_UNIT_EXP_ARG; \
        end \
        y = y * exp(TMF1); \
        dx = y; \
    end \
end

//---------------------------------------------------*
//* Macros for aging model.
//*-----------------*/
//`ifdef _AGING_

`define SU_TRAP_delta 1e-3
`define Fn_calc_TRAP( N00 , N01 , N02, N03, N04, ps , pds ) begin \
    efn_ec = ps - ( - keT *ln(2.5e25/Nsub)+pds) - EG0 ; \
    TMF4 = lexp(efn_ec / MKS_TRAPES1 ) ; \
    y1 = N01 * TMF4 ; \
    `Fn_SLtemp( y1 , y1 , 1 , 1 ) \
    TMF4 = lexp(efn_ec / TRAPES2 ) ; \
    y2 = N02 * TMF4 ; \
    `Fn_SLtemp( y2 , y2 , 1 , 1 ) \
    TMF5 = log(y1) ;  \
    TMF4 = lexp(efn_ec / TRAPESLIM ) ; \
    y6 = N04 * TMF4 ;  TMF8 = log(y6) ; \
    if ( CODEGES0 ) begin \
        TMF4 = lexp(efn_ec / TRAPES0 ) ; \
        y3 = N03 * TMF4 ; \
        `Fn_SLtemp( y3 , y3 , 1 , 1 ) \
        TMF8 = log(y3) ; \
        `Fn_SUtemp( TMF6 , TMF8 , TMF5 , `SU_TRAP_delta )  \
    end else begin \
        `Fn_SUtemp( TMF6 , TMF5 , TMF8 , `SU_TRAP_delta*0.1 )  \
    end \
    y4 = pow(10,TMF6) ; \
    y5 = y4 * lexp( - Vtraplx_prv / TRAPLX ) ; \
    TMF5 = log(y5) ; TMF6 = log(y2) ; \
    `Fn_SLtemp( TMF7 , TMF6 , TMF5 , `SU_TRAP_delta*0.1 )  \
    N00 = pow(10,TMF7) ; \
end

`define Fn_calcNKT(NtK,gc,es) begin \
    delta = ( `C_Pi * keT ) / es ; \
    NtK   = abs( gc * es * ( delta / sin( delta ))) ; \
end

//`endif //_AGING_

//---------------------------------------------------*
//* Macros for body diode model.
//*-----------------*/
`define HSMHV_Idio_args1(js, JS0, XTI, NJ) begin \
    js = JS0 * exp((egtnom * betatnom - Eg * beta + XTI * log_Tratio) / NJ) ; \
end

`define HSMHV_Idio_args2(is_btm, is2_btm, is_sws, is2_sws, is_swg, is2_swg, PD, AD) begin \
    if ( PD > weff_nf ) begin \
        is_btm  = AD * js  ; \
        is2_btm = AD * js2 ; \
        is_sws  = (PD - weff_nf) * jssw  ; \
        is2_sws = (PD - weff_nf) * jssw2 ; \
        is_swg  = weff_nf * jsswg ; \
        is2_swg = weff_nf * jsswg2 ; \
    end else begin \
        is_btm  = AD * js  ; \
        is2_btm = AD * js2 ; \
        is_sws  = 0.0 ; \
        is2_sws = 0.0 ; \
        is_swg  = PD * jsswg ; \
        is2_swg = PD * jsswg2 ; \
    end \
end

`define HSMHV_Idio_args2_compat(is_btm, is2_btm, is_sws, is2_sws, is_swg, is2_swg, PD, AD) begin \
    is_btm  = AD * js  ; \
    is2_btm = AD * js2 ; \
    is_sws  = PD * jssw  ; \
    is2_sws = PD * jssw2 ; \
    is_swg  = 0.0 ; \
    is2_swg = 0.0 ; \
end

`define HSMHV_Qdio_args1(czbd, czbdsw, czbdswg, PD, AD, CJD, TCJBD, CJSWD, TCJBDSW, CJSWGD, TCJBDSWG, name) begin \
    czbd = CJD * AD * ( 1.0 + TCJBD * Tdiff) ; \
    if (PD > weff_nf) begin \
        czbdsw  = CJSWD  * ( PD - weff_nf ) * ( 1.0 + TCJBDSW  * Tdiff) ; \
        czbdswg = CJSWGD *        weff_nf   * ( 1.0 + TCJBDSWG * Tdiff) ; \
    end else begin \
        czbdsw  = 0.0 ; \
        czbdswg = CJSWGD *   PD             * ( 1.0 + TCJBDSWG * Tdiff) ; \
    end \
    if (czbd < 0.0) begin \
        if (COERRREP) begin \
            $write("reset(HiSIM_HV(%m)): The model parameter TCJB%s=%g is too large.  Effective total CJ%s is reset from %g to 0 (F).\n", name, TCJBD, name, czbd); \
        end \
        czbd  = 0.0 ; \
    end \
    if (czbdsw < 0.0) begin \
        if (COERRREP) begin \
            $write("reset(HiSIM_HV(%m)): The model parameter TCJB%sSW=%g is too large.  Effective total CJSW%s is reset from %g to 0 (F).\n", name, TCJBDSW, name, czbdsw); \
        end \
        czbdsw  = 0.0 ; \
    end \
    if (czbdswg < 0.0) begin \
        if (COERRREP) begin \
            $write("reset(HiSIM_HV(%m)): The model parameter TCJB%sSWG=%g is too large.  Effective total CJSWG%s is reset from %g to 0 (F).\n", name, TCJBDSWG, name, czbdswg); \
        end \
        czbdswg  = 0.0 ; \
    end \
end

`define HSMHV_Qdio_args2(pzbd, pzbdsw, pzbdswg, PD, AD, PBD, TPBBD, PBSWD, TPBBDSW, PBSWGD, TPBBDSWG, name) begin \
    pzbd    = PBD    - TPBBD    * Tdiff ; \
    pzbdsw  = PBSWD  - TPBBDSW  * Tdiff ; \
    pzbdswg = PBSWGD - TPBBDSWG * Tdiff ; \
    if (pzbd < 0.01 && AD > 0.0) begin \
        if (COERRREP) begin \
            $write("reset(HiSIM_HV(%m)): The model parameter TPBB%s=%g is too large.  Effective PB%s is reset from %g to 0.01 (V).\n", name, TPBBD, name, pzbd); \
        end \
        pzbd  = 0.01 ; \
    end \
    if (pzbdsw < 0.01 && PD > weff_nf) begin \
        if (COERRREP) begin \
            $write("reset(HiSIM_HV(%m)): The model parameter TPBB%sSW=%g is too large.  Effective PBSW%s is reset from %g to 0.01 (V).\n", name, TPBBDSW, name, pzbdsw); \
        end \
        pzbdsw  = 0.01 ; \
    end \
    if (pzbdswg < 0.01 && PD > 0.0) begin \
        if (COERRREP) begin \
            $write("reset(HiSIM_HV(%m)): The model parameter TPBB%sSWG=%g is too large.  Effective PBSWG%s is reset from %g to 0.01 (V).\n", name, TPBBDSWG, name, pzbdswg); \
        end \
        pzbdswg  = 0.01 ; \
    end \
end

`define HSMHV_Idio(Idio, Vdio, is, is2,  vt_X, jd_expc_X,  T10_X, T9_X, jd_nvtm_inv_X, UC_CISBK_X, DIVX_X) begin \
    if ( is > 0 ) begin \
        T0 = is2 * T9_X ; \
        TX = - Vdio * T10_X ; \
        T2 = exp ( TX ); \
        T3 = T2 ; \
        if ( Vdio < vt_X ) begin \
            TX = Vdio * jd_nvtm_inv_X ; \
            if ( TX < - 3*`EXP_THR ) begin \
                T1 = 0.0 ; \
            end else begin \
                T1 = exp ( TX ) ; \
            end \
            Idio = is * (T1 - 1.0) + T0 * (T2 - 1.0) + UC_CISBK_X * (T3 - 1.0); \
        end else begin \
            T1 = jd_expc_X ; \
            T4 = is * jd_nvtm_inv_X * T1 ; \
            Idio = is * (T1 - 1.0) + T4 * (Vdio - vt_X) + T0 * (T2 - 1.0) + UC_CISBK_X * (T3 - 1.0) ; \
        end \
    end else begin \
        Idio = 0.0 ; \
    end \
    T12 = DIVX_X * is2 ; \
    Idio = Idio + T12 * Vdio ; \
end

`define HSMHV_Qdio(Qdio, Capdio, Vdio, cz, PB, MJ) begin \
    if (cz > 0.0) begin \
        if (Vdio < 0.0) begin \
            arg = 1.0 - Vdio / PB ; \
            if (MJ == 0.5) sarg = 1.0 / sqrt(arg) ; \
            else sarg = `Fn_Pow( arg , -MJ ) ; \
            Qdio = PB * cz * (1.0 - arg * sarg) / (1.0 - MJ) ; \
            Capdio = cz * sarg ; \
        end else begin \
            T1 = cz ; \
            T2 = cz * MJ / PB ; \
            Qdio = Vdio * (T1 + Vdio * 0.5 * T2) ; \
            Capdio = T1 + Vdio * T2 ; \
        end \
    end else begin \
        Qdio = 0.0 ; \
        Capdio = 0.0 ; \
    end \
end

//imported from DIODE_CMC_macrodefs.include:
//diode reverse recovery model
`define C_Nin0_dio   (1.45e+16)                 // Intrinsic carrier density at 300K (m^-3)
`define C_MUEP       (500)                      // Hole mobility (cm^2/V/sec)
`define C_MUEN       (1450)                     // Electron mob. (cm^2/V/sec)
`define C_EXPCEIL    (1e20)                     // safety valve against carrier conc explosion (-)
`define C_PUNCH      (1.0e-7)                   // Delta for punch-through effect of depletion (m)
`define QN_INJ_SCALING   (NQS)                  // pre/post-scaling for node voltages of charge_A and charge_K
`define NQS_CAPACITOR    (NQS)                  // scaling for charge_A and charge_K
`define DEP_SCALING      (DEPNQS)               // pre/post-scaling for node voltage of depl_A
`define DEPNQS_CAPACITOR (DEPNQS)               // scaling for depl_A
`define C_MUETMP     (1.5)                      // temperature dependence of phonon scattering (-)
//End of diode reverse recovery model

//End of File: HSMHV_macrosAndDefs.inc
// ---- end `include "HSMHV_macrosAndDefs.inc" ----

// Module Definition
module hisimhv_va(d, g, s, b, sub, temp);
    inout      d, g, s, b, sub, temp ;
    electrical d, g, s, b, sub, temp                      ;  // External Nodes
    electrical dp, gp, sp, bp, db, sb, qi, qb             ;  // Internal Nodes
    electrical qbd ;  // Internal node for nov_nqs
    electrical n ;    // Internal node for induced gate noise
    electrical charge_A, charge_K, depl_A;  //internal nodes for diode recovery model
`ifdef _AGING_
    voltage    idtag1 , idtag2                ;  // Internal Nodes for Aging
    voltage   dVfb , idtag3 , idtag4          ;
    voltage    ps0 , vtraplx , vgc1 , ve1     ;
`endif
    //

// ---- begin `include "HSMHV_module.inc" ----
/***********************************************************************

 HiSIM (Hiroshima University STARC IGFET Model)
 Copyright (C) 2000-2016 Hiroshima University and STARC
 Copyright (C) 2016-2023 Hiroshima University
 HiSIM_HV (High-Voltage Model)
 Copyright (C) 2007-2016 Hiroshima University and STARC
 Copyright (C) 2016-2023 Hiroshima University

 MODEL NAME : HiSIM_HV
 ( VERSION : 2  SUBVERSION : 5  REVISION : 1 )
 Model Parameter 'VERSION' : 2.51
 FILE : HSMHV_module.inc

 Date : 2023.02.09

 released by Hiroshima University

***********************************************************************/
//
////////////////////////////////////////////////////////////////
//
//
//
//
//Licensed under the Educational Community License, Version 2.0
//(the "License"); you may not use this file except in
//compliance with the License.
//
//You may obtain a copy of the License at:
//
//      http://opensource.org/licenses/ECL-2.0
//
//Unless required by applicable law or agreed to in writing,
//software distributed under the License is distributed on an
//"AS IS" BASIS, WITHOUT WARRANTIES OR CONDITIONS OF ANY KIND,
//either express or implied. See the License for the specific
//language governing permissions and limitations under the
//License.
//
//
//The HiSIM_HV standard has been supported by the members of
//Silicon Integration Initiative's Compact Model Coalition. A
//link to the most recent version of this standard can be found
//at:
//
//http://www.si2.org/cmc
//
////////////////////////////////////////////////////////////////
//

// Branch Definitions

branch(sb,s ) BRsbs  ;
branch(db,d ) BRdbd  ;
branch(dp,sp) BRdpsp ;
branch(dp,bp) BRdpbp ;
branch(sp,bp) BRspbp ;
branch(gp,sp) BRgpsp ;
branch(gp,dp) BRgpdp ;
branch(gp,bp) BRgpbp ;
branch(g ,gp) BRggp  ;
branch(gp,s ) BRgps  ;
branch(gp,d ) BRgpd  ;
branch(d ,dp) BRddp  ;
branch(d ,s ) BRds   ;
branch(sp,s ) BRsps  ;
branch(bp,sp) BRbpsp ;
branch(bp,dp) BRbpdp ;
branch(bp,d ) BRbpd  ;
branch(bp,s ) BRbps  ;
branch(sb,bp) BRsbbp ;
branch(db,bp) BRdbbp ;
branch(b ,bp) BRbbp  ;
branch(b ,sb) BRbsb  ;
branch(b ,db) BRbdb  ;
branch(d ,bp) BRdbp  ;
branch(s ,bp) BRsbp  ;

//
// Parameter definitions

//******* Device Parameters *******//
`IPRco( L         , 2.0E-6     , "m"                 ,  1n , inf , "Gate length ")
`IPRco( W         , 5.0E-6     , "m"                 ,  1n , inf , "Gate width ")
`IPRco( NRD       , 1.0        , "-"                 ,   0 , inf , "Number of squares in drain ")
`IPRco( NRS       , 1.0        , "-"                 ,   0 , inf , "Number of squares in source ")
`IPRco( NGCON     , 1.0        , "-"                 ,   1 , inf , "Number of gate contacts ")
`IPRnb( XGW       , 0E0        , "m"                             , "Distance from gate contact to channel edge ")
`IPRnb( XGL       , 0E0        , "m"                             , "Offset of gate length due to variation in patterning ")
`IPRco( NF        , 1.0        , "-"                 ,   1 , inf , "Number of fingers ")
`IPRco( SA        , 0          , "m"                 ,   0 , inf , "Distance from STI edge to Gate edge  ")
`IPRco( SB        , 0          , "m"                 ,   0 , inf , "Distance from STI edge to Gate edge  ")
`IPRco( SD        , 0          , "m"                 ,   0 , inf , "Distance from Gate edge to Gate edge  ")
`IPRnb( DTEMP     , 0          , "K"                             , "Device temperature change")
`IPM
`IPRoo( NSUBCDFM  , 3E17       , "1/cm^3"            ,   0 , inf , "Substrate impurity concentration for DFM")

`ifdef COEXTDIO
    /* for Junction Diode Model */
`else
    `IPRco( AD        , 0.0        , "m^2"               ,   0 , inf , "Drain area ")
    `IPRco( AS        , 0.0        , "m^2"               ,   0 , inf , "Source area ")
    `IPRco( PD        , 0.0        , "m"                 ,   0 , inf , "Drain perimeter ")
    `IPRco( PS        , 0.0        , "m"                 ,   0 , inf , "Source perimeter ")
`endif /* End of COEXTDIO */

//******* Model Flags *******//
`MPIcc( CORSRD    , 3          , "-"                 ,  0  ,   3 , "Handling of Rs and Rd ") //HV1
`MPIcc( CORS      , 0          , "-"                 ,  0  ,   1 , "source side resistance OFF(0)/ON(1)")
`MPIcc( CORD      , 1          , "-"                 ,  0  ,   1 , "drain  side resistance OFF(0)/ON(1)")
`MPIsw( COIPRV    , 0          , "-"                             , "Use ids_prv as initial guess of Ids(internal flag) ")
`MPIsw( COPPRV    , 0          , "-"                             , "not supported ")
`MPIcc( COADOV    , 1          , "-"                 ,  0  ,   2 , "Add overlap to intrinsic (1)  No intrinsic (2) No overlap (0) ") //20171005
`MPIsw( COISUB    , 0          , "-"                             , "Calculate isub ")
`MPIsw( COIIGS    , 0          , "-"                             , "Calculate igate ")
`MPIsw( COGIDL    , 0          , "-"                             , "Calculate igidl ")
`MPIsw( COFLICK   , 0          , "-"                             , "Calculate 1/f noise ")
`MPIsw( COISTI    , 0          , "-"                             , "Calculate STI ")
`MPIsw( CONQS     , 0          , "-"                             , "Calculate in nqs mode or qs mode ")
`MPIsw( CONQSOV   , 0          , "-"                             , "Calculate in nqs mode or qs mode ")
`MPIsw( COTHRML   , 0          , "-"                             , "Calculate thermal noise ")
`MPIsw( COIGN     , 0          , "-"                             , "Calculate induced gate noise ")
`MPIsw( CODFM     , 0          , "-"                             , "Calculation of model for DFM ")
`MPIcc( COQOVSM   , 1          , "-"                 ,   0 ,   4 , "select solver mode of Ps0LD for Qover ")
`MPIsw( COSYM     , 0          , "-"                             , "Model selector for symmetry device ")
`MPIsw( COOVLP    , 1          , "-"                             , "Calculate overlap charge on the drain side ")
`MPIsw( COOVLPS   , (COSYM ? COOVLP : 0) , "-"                   , "Calculate overlap charge on the source side ")
`MPIsw( COVBSCL   , 1          , "-"                             , "Clamp Vbs (1; backward compat; default) No (0; new recommendation)")
`MPIsw( COQOVCL   , 1          , "-"                             , "Clamp Vxbgmt (1; backward compat; default) No (0; new recommendation)")
`MPIcc( COTEMP    , 0          , "-"                 ,   0 ,   3 , "Model flag for temperature dependence ")
`MPIsw( CORDRIFT  , 1          , "-"                             , "selector for drift resistance ")
`MPIsw( COERRREP  , 1          , "-"                             , "selector for error report ")
`MPIcc( CODEP     , 0          , "-"                 ,   0 ,   3 , "selector for depletion device ")
`MPIcc( COVDSRES  , 2          , "-"                 ,  -1 ,   3 , "Vdssatres, analytical Vdsres model switch: (-1) Vdsres=Vds; (2) Vdsatres  ln(cosh) equation  (3) Vdssatres ln(1+exp) depmos3")
`MPIsw( CODDLT    , 1          , "-"                             , "selector for DDLT model ")
`MPIcc( COHBD     , 0          , "-"                 ,  -1 ,   1 , "selector for Hard Breakdown Model ")
`MPIsw( COSNP     , 0          , "-"                             , "Calculate snapback (bjt effects) ")
`MPInb( INFO      , 0          , "-"                             , "")
`MPIsw( CODIO     , 0          , "-"                             , "selector for updated diode model ")
`MPIcc( COFIXCSS  , 0          , "-"                 ,   0 ,   1 , "Selector for Css problem ")
`MPIcc( COOVJUNC  , 0          , "-"                 ,   0 ,   1 , "Selector for Wjunc,ov model(0: phis,over, 1: Vds) ")

`ifdef _AGING_
    `MPIcc( COFIXAG   , 0          , "-"                 ,   0 ,   1 , "Selector for Aging problem 0=240 1=250 ")
    `BPIsw( CODEG     , 0          , "-"                             , "Selector for Aging model ")
    `BPIsw( CODEGES0  , 0          , "-"                             , "Selector for TRAPES0/TRAPGC0 ")
    `BPIcc( CODEGSTEP , 0          , "-"                 ,   0 ,   2 , "Selector for Aging model ")
`endif

//*** model and instance parameter ***
`BPIsw( CORG      , 0          , "-"                             , "Activate gate resistance(1) or not(0) ")
`BPIsw( CORBNET   , 0          , "-"                             , "Activate body resistance(1) or not(0) ")
`BPIcc( COSELFHEAT, 0          , "-"                 ,   0 ,   2 , "selector for self heating model ")
`BPIsw( COSUBNODE , 0          , "-"                             , "Switch tempNode to subNode ")
`BPIsw( COTRENCH  , 0          , "-"                             , "Trench overlap capacitance (1)") // 2.4.0
`BPRco( RBPB      , 50.0E0     , "ohm"               ,   0 , inf , "Substrate resistance network")
`BPRco( RBPD      , 50.0E0     , "ohm"               ,   0 , inf , "Substrate resistance network")
`BPRco( RBPS      , 50.0E0     , "ohm"               ,   0 , inf , "Substrate resistance network")
`BPRnb( RDOV13    , 1.0        , "-"                             , "Dependence coeff. for overlap length ")            //HV1
`BPRnb( RDSLP1    , 0.0        , "-"                             , "LDRIFT1 dependence of resistance for CORSRD=1")    //HV1
`BPRnb( RDVG11    , 0.0        , "-"                             , "Vgs dependence of RD for CORSRD=1,3")              //HV1
`BPRnb( RDICT1    , 1.0        , "-"                             , "LDRIFT1 dependence of resistance for CORSRD=1")    //HV1
`BPRco( LOVERLD   , 1.0E-6     , "m"                 ,   0 , inf , "Overlap length on drain side  ")
`BPRco( WTRENCH   , 1.0E-6     , "m"                 ,   0 , 10E-6,"Overlap length on drain side, trench bottom")
`BPRco( LOVER     , (COSYM ? LOVERLD : 30E-9) , "m"  ,   0 , inf , "Overlap length of the source region, if LOVERS is not determined.")
`BPRco( LOVERS    , (COSYM ? LOVERLD : LOVER) , "m"  ,   0 , inf , "Overlap length on source side  ")
`BPRco( LDRIFT1   , 1.0E-6     , "m"                 ,   0 , inf , "Parameter for drift region length-1  ")
`BPRco( LDRIFT2   , 1.0E-6     , "m"                 ,   0 , inf , "Parameter for drift region length-2  ")
`BPRco( LDRIFT1S  , (COSYM ? LDRIFT1 :  0.0) , "m"   ,   0 , inf , "Parameter for drift region length-1 on source side ")
`BPRco( LDRIFT2S  , (COSYM ? LDRIFT2 : 1E-6) , "m"   ,   0 , inf , "Parameter for drift region length-2 on source side ")
`BPRco( LDRIFTS   , (LDRIFT1S+LDRIFT2S) , "m"        ,   0 , inf , "Parameter for drift region on source side ")
`BPRnb( SUBLD1    , 0.0        , "-"                             , "Parameter for impact-ionization current in the drift region  ")
`BPRnb( SUBLD2    , 0.0        , "m^-1*V^3/2"                    , "Parameter for impact-ionization current in the drift region  ")
`BPRco( RD        , 0.0        , "ohm*m"             ,   0 , inf , "Drain contact resistance   ")  //HV1
`BPRco( RS        , (COSYM ? RD : 0) , "ohm*m"       ,   0 , inf , "Source contact resistance  ")  //HV1
`BPRoo( NPEXT     , 5.0E17     , "1/cm^3"            ,   0 , inf , "Pocket extension ")
`BPRnb( VOVER     , 0.3        , "-"                             , "Parameter for overshoot  ")
`BPRoo( FALPH     , 1.0        , ""                  ,   0 , inf , "Parameter for 1/f noise ")
`BPRco( CGBO      , 0.0        , "F/m"               ,   0 , inf , "Cgbo ")
`BPRco( RTH0      , 0.1        , "Kcm/W"             ,   0 , inf , "Thermal resistance ")
`BPRnb( POWRAT    , 1.0        , ""                              , "Thermal dissipation")
`BPRnb( RDVD      , 7.0E-2     , "ohm*cm/V"                      , "Vds dependence of RD for CORSRD=1,3")   //HV1
`BPRnb( RD23      , 5E-3       , ""                              , "modification of RD for CORSRD=2,3")     //HV1
`BPRnb( RD24      , 0.0        , ""                              , "Vgs dependence of RD for CORSRD=2,3")   //HV1
`BPRnb( RDVB      , 0.0        , ""                              , "Vbs dependence of RD for CORSRD=1,3")   //HV1
`BPRco( CVDSOVER  , 0.0        , ""                  ,   0 , inf , "Vds drop along the overlap ")

//******* Technology Model Parameters *******//
`MPIty( TYPE      , 1          , ""                              , "mosfet TYPE: 1=NMOS and -1=PMOS")
`MPRnb( VERSION   , 2.51       , ""                              , "Model version ")
`MPRoo( VMAX      , 1.0E7      , "cm/s"              ,   0 , inf , "Saturation velocity  ")
`MPRnb( VMAXT1    , 0.0        , "-"                             , "Saturation velocity coeff.  ")
`MPRnb( VMAXT2    , 0.0        , "-"                             , "Saturation velocity coeff.  ")
`MPRnb( BGTMP1    , 90.25E-6   , "V/K"                           , "First order temp. coeff. for band gap  ")
`MPRnb( BGTMP2    , 1.0E-7     , "V/K^2"                         , "Second order temp. coeff. for band gap  ")
`MPRnb( EG0       , 1.1785E0   , ""                              , "Bandgap")
`MPRoo( TOX       , 7E-9       , "m"                 ,   0 , inf , "Oxide thickness  ")
`MPRnb( TOXB      , TOX        , "m"                             , "Oxide thickness of gate-drain overlap region")
`MPRco( XLD       , 0          , "m"                 ,   0 , inf , "Lateral diffusion of S/D under the gate  ")
`MPRnb( RDOV11    , 0.0        , ""                              , "Dependence coeff. for overlap length ")           //HV1
`MPRnb( RDOV12    , 1.0        , ""                              , "Dependence coeff. for overlap length ")           //HV1
`MPRnb( RDSLP2    , 1.0        , ""                              , "LDRIFT2 dependence of resistance for CORSRD=1")   //HV1
`MPRnb( RDICT2    , 0.0        , ""                              , "LDRIFT2 dependence of resistance for CORSRD=1")   //HV1
`MPRnb( SUBLD1L   , 0.0        , "um^subld1l"                    , "Impact-ionization current in the drift region  ")
`MPRnb( SUBLD1LP  , 1.0        , "-"                             , "Impact-ionization current in the drift region  ")
`MPRnb( XPDV      , 0.0        , "m^-1"                          , "Impact-ionization current in the drift region  ")
`MPRnb( XPVDTH    , 0.0        , "V"                             , "Impact-ionization current in the drift region  ")
`MPRnb( XPVDTHG   , 0.0        , "V^-1"                          , "Impact-ionization current in the drift region  ")
`MPRco( DDLTMAX   , 10         , ""                  ,   1 , inf , "Smoothing coefficient for Vds")
`MPRco( DDLTSLP   , (`SUBVERSION<3 ?  0 : 10) , ""   ,   0 , inf , "Lgate dependence of smoothing coefficient")
`MPRnb( DDLTICT   , (`SUBVERSION<3 ? 10 :  0) , ""               , "Lgate dependence of smoothing coefficient")
`MPRnb( VFBOVER   , -0.5       , ""                              , "flat-band voltage in overlap region")
`MPRco( NOVER     , 3E16       , ""                  ,   0 , inf , "Impurity concentration in overlap region")
`MPRco( NOVERS    , (COSYM ? NOVER : 1E17) , ""      ,   0 , inf , "Impurity concentration in overlap region at source side")
`MPRcc( OLMDLT    , 5.0        , "-"                  ,  0,  100 , "smooth delta for Wjuncld ceiling upto Lover_func (COTRENCH=1)") // 2.4.0
`MPRnb( XWD       , 0.0        , "m"                             , "Lateral diffusion along the width dir.  ")
`MPRnb( XWDC      , XWD        , "m"                             , "Lateral diffusion along the width dir. for capacitance  ")
`MPRnb( XL        , 0.0        , "m"                             , "Gate length offset due to mask/etch effect  ")
`MPRnb( XW        , 0.0        , "m"                             , "Gate width offset due to mask/etch effect  ")
`MPRco( SAREF     , 1E-6       , "m"                 ,   0 , inf , "Reference distance from STI edge to Gate edge  ")
`MPRco( SBREF     , 1E-6       , "m"                 ,   0 , inf , "Reference distance from STI edge to Gate edge  ")
`MPRnb( LL        , 0.0        , ""                              , "Gate length parameter ")
`MPRnb( LLD       , 0.0        , ""                              , "Gate length parameter ")
`MPRnb( LLN       , 0.0        , ""                              , "Gate length parameter ")
`MPRnb( WL        , 0.0        , ""                              , "Gate width parameter ")
`MPRnb( WL1       , 0.0        , ""                              , "Gate width parameter ")
`MPRnb( WL1P      , 1.0        , ""                              , "Gate width parameter ")
`MPRnb( WL2       , 0.0        , ""                              , "Gate width parameter ")
`MPRnb( WL2P      , 1.0        , ""                              , "Gate width parameter ")
`MPRnb( WLD       , 0.0        , ""                              , "Gate width parameter ")
`MPRnb( WLN       , 0.0        , ""                              , "Gate width parameter ")
`MPRco( RSH       , 0.0        , "ohm"               ,   0 , inf , "drain diffusion sheet  resistance   ")
`MPRco( RSHS      , RSH        , "ohm"               ,   0 , inf , "Source diffusion sheet  resistance   ")
`MPRco( RSHG      , 0.0        , ""                  ,   0 , inf , "Gate-electrode sheet resistance ")
`MPRco( XQY       , 0.0        , "m"                 ,   0 , inf , "Distance from drain junction to maximum electric field point ")
`MPRnb( XQY1      , 0.0        , "F m^XQY2"                      , "Vbs dependence of Qy ")
`MPRnb( XQY2      , 2.0        , ""                              , "Lgate dependence of Qy ")
`MPRnb( VFBC      , (CODEP!=0 ? -0.2 : -1.0) , "V"               , "Constant part of Vfb  ")
`MPRnb( VBI       , 1.1        , "V"                             , "Built-in potential  ")
`MPRoo( NSUBC     , (CODEP!=0 ? 5e16 : 3E17) , "1/cm^3", 0 , inf , "Constant part of Nsub  ")
`MPRoo( PARL2     , 10.0E-9    , "m"                , -inf ,   L , "Under diffusion  ")
`MPRcc( LP       , (CODEP!=0 ? 0 : 1.5e-8 ) , "m" ,      0 ,   L , "Length of pocket potential  ")
`MPRoo( NSUBP    , (CODEP!=0 ? 1e17 : 1e18) , "1/cm^3" , 0 , inf , "Maximum pocket concentration ")
`MPRnb( NSUBP0    , 0.0        , ""                              , "Pocket implant parameter ")
`MPRnb( NSUBWP    , 1.0        , ""                              , "Pocket implant parameter ")
`MPRnb( SCP1      , 0.0        , "-"                             , "Parameter for pocket  ")
`MPRnb( SCP2      , 0.0        , "1/V"                           , "Parameter for pocket  ")
`MPRnb( SCP3      , 0.0        , "m/V"                           , "Parameter for pocket  ")
`MPRnb( SC1       , 0.0        , "-"                             , "Parameter for SCE  ")
`MPRnb( SC2       , 0.0        , "1/V"                           , "Parameter for SCE  ")
`MPRnb( SC3       , 0.0        , "m/V"                           , "Parameter for SCE  ")
`MPRnb( SC4       , 0.0        , "1/V"                           , "Parameter for SCE  ")
`MPRnb( PGD1      , 0.0        , "V"                             , "Parameter for gate-poly depletion  ")
`MPRnb( PGD2      , 1.0        , "V"                             , "Parameter for gate-poly depletion  ")
`MPRnb( PGD4      , 0.0        , "-"                             , "Parameter for gate-poly depletion  ")
`MPRnb( NDEP      , 1.0        , "-"                             , "Coeff. of Qbm for Eeff  ")
`MPRnb( NDEPL     , 0.0        , "-"                             , "Coeff. of Qbm for Eeff  ")
`MPRnb( NDEPLP    , 1.0        , "-"                             , "Coeff. of Qbm for Eeff  ")
`MPRnb( NINV      , 0.5        , "-"                             , "Coeff. of Qnm for Eeff  ")
`MPRnb( MUECB0    , 1.0E3     , "cm^2/Vs"                        , "Const. part of coulomb scattering  ")
`MPRnb( MUECB1    , 100.0     , "cm^2/Vs"                        , "Coeff. for coulomb scattering  ")
`MPRnb( MUEPH0    , 300.0E-3   , "-"                             , "Power of Eeff for phonon scattering  ")
`MPRoo( MUEPH1    , (TYPE>0 ? 20E3 : 9E3) , ""       ,   0 , inf , "Phonon scattering ")
`MPRnb( MUEPHW    , 0.0        , "-"                             , "Phonon related mobility reduction ")
`MPRnb( MUEPWP    , 1.0        , "-"                             , "Phonon scattering parameter ")
`MPRnb( MUEPHL    , 0.0        , "-"                             , "Phonon scattering parameter ")
`MPRnb( MUEPLP    , 1.0        , "-"                             , "Phonon scattering parameter ")
`MPRnb( MUEEFB    , 0.0        , "1/V"                           , "Vbs dependence of the phonon scattering ")
`MPRnb( MUEPHS    , 0.0        , "-"                             , "Mobility modification due to small size")
`MPRnb( MUEPSP    , 1.0        , "-"                             , "Mobility modification due to small size")
`MPRnb( VTMP      , 0.0        , "-"                             , "Temperature dependence of saturation velocity")
`MPRnb( WVTH0     , 0.0        , "V"                              , "Threshold voltage shift")
`MPRnb( MUESR0    , 2.0        , "-"                             , "Power of Eeff for S.R. scattering  ")
`MPRoo( MUESR1    , (CODEP!=0 ? 5E15 : 6e14 ) , "-"  ,   0 , inf , "Coeff. for S.R. scattering  ")
`MPRnb( MUESRL    , 0.0        , "-"                             , "Surface roughness parameter ")
`MPRnb( MUESRW    , 0.0        , "-"                             , "Change of surface roughness related mobility ")
`MPRnb( MUESWP    , 1.0        , "-"                             , "Change of surface roughness related mobility ")
`MPRnb( MUESLP    , 1.0        , "-"                             , "Surface roughness parameter ")
`MPRnb( MUETMP    , 1.5        , "-"                             , "Parameter for mobility  ")
`MPRco( BB        , (TYPE>0 ? 2 : 1) , "-"           , 0.1 , inf , "Empirical mobility model coefficient  ")
`MPRnb( SUB1      , 10         , "1/V"                           , "Parameter for Isub  ")
`MPRnb( SUB2      , 25         , "V"                             , "Parameter for Isub  ")
`MPRnb( SVGS      , 0.8E0      , ""                              , "Coefficient for Vg of Psislsat ")
`MPRnb( SVBS      , 0.5E0      , ""                              , "Coefficient for Vbs of Psislsat ")
`MPRnb( SVBSL     , 0E0        , ""                              , "Lgate dependence of SVBS ")
`MPRnb( SVBSLP    , 1.0        , ""                              , "Lgate dependence of SVBS ")
`MPRnb( SVDS      , 0.8E0      , ""                              , "Substrate current dependence on Vds ")
`MPRco( SLG       , 30E-9      , ""                  ,   0 , inf , "Substrate current dependence on Lgate ")
`MPRnb( SUB1SNP   , SUB1       , "1/V"                           , "Parameter for Isub (snapback) ")
`MPRnb( SUB2SNP   , 0.6*SUB2   , "V"                             , "Parameter for Isub (snapback) ")
`MPRnb( SVDSSNP   , SVDS       , ""                              , "Substrate current dependence on Vds (snapback)")
//`MPRnb( SVGSSNP   , SVGS       , ""                              , "Coefficient for Vg of Psislsat (snapback)")
//`MPRnb( SVBSSNP   , 0.5E0      , ""                              , "Coefficient for Vbs of Psislsat(snapback)")
`MPRnb( SUB1L     , 2.5E-3     , ""                              , "Lgate dependence of SUB1")
`MPRnb( SUB1LP    , 1.0        , ""                              , "Lgate dependence SUB1 ")
`MPRnb( SUB2L     , 2E-6       , ""                              , "Lgate dependence of SUB2")
`MPRnb( SUBTMP    , 0          , ""                              , "Temperature dependence of Isub  ")
`MPRnb( FN1       , 50E0       , ""                              , "Coefficient of Fowler-Nordheim-current contribution")
`MPRnb( FN2       , 170E-6     , ""                              , "Coefficient of Fowler-Nordheim-current contribution")
`MPRnb( FN3       , 0E0        , ""                              , "Coefficient of Fowler-Nordheim-current contribution")
`MPRnb( FVBS      , 12E-3      , ""                              , "Vbs dependence of Fowler-Nordheim current")
`MPRnb( SVGSL     , 0.0        , ""                              , "Lgate dependence of SVGS ")
`MPRnb( SVGSLP    , 1.0        , ""                              , "Lgate dependence of SVGS ")
`MPRnb( SVGSW     , 0.0        , ""                              , "Wgate dependence of SVGS ")
`MPRnb( SVGSWP    , 1.0        , ""                              , "Wgate dependence of SVGS ")
`MPRnb( SLGL      , 0.0        , ""                              , "Substrate current dependence on Lgate ")
`MPRnb( SLGLP     , 1.0        , ""                              , "Substrate current dependence on Lgate ")
`MPRoo( NSTI      , 5.0E17     , "1/cm^3"            ,   0 , inf , "Parameter for STI  ")
`MPRnb( WSTI      , 0.0        , "m"                             , "Parameter for STI  ")
`MPRnb( WSTIL     , 0.0        , "-"                             , "Parameter for STI  ")
`MPRnb( WSTILP    , 1.0        , "-"                             , "Parameter for STI  ")
`MPRnb( WSTIW     , 0.0        , "-"                             , "Parameter for STI  ")
`MPRnb( WSTIWP    , 1.0        , "-"                             , "Parameter for STI  ")
`MPRnb( SCSTI1    , 0.0        , "-"                             , "Parameter for STI  ")
`MPRnb( SCSTI2    , 0.0        , "1/V"                           , "Parameter for STI  ")
`MPRnb( VTHSTI    , 0.0        , ""                              , "Parameter for STI ")
`MPRnb( VDSTI     , 0.0        , "-"                             , "Parameter for STI  ")
`MPRco( MUESTI1   , 0.0        , ""                  ,   0 , inf , "STI Stress mobility parameter ")
`MPRoo( MUESTI2   , 0.0        , ""                  ,  -1 , inf , "STI Stress mobility parameter ")
`MPRnb( MUESTI3   , 1.0        , ""                              , "STI Stress mobility parameter ")
`MPRco( NSUBPSTI1 , 0.0        , ""                  ,   0 , inf , "STI Stress pocket implant parameter ")
`MPRoo( NSUBPSTI2 , 0.0        , ""                  ,  -1 , inf , "STI Stress pocket implant parameter ")
`MPRnb( NSUBPSTI3 , 1.0        , ""                              , "STI Stress pocket implant parameter ")
`MPRoo( LPEXT     , 1.0E-50    , ""                  ,   0 , inf , "Pocket extension ")
`MPRnb( SCP21     , 0.0        , ""                              , "Short-channel-effect modification for small Vds")
`MPRnb( SCP22     , 0.0        , ""                              , "Short-channel-effect modification for small Vds")
`MPRnb( BS1       , 0.0        , ""                              , "Body-coefficient modification due to impurity profile")
`MPRnb( BS2       , 0.9        , ""                              , "Body-coefficient modification due to impurity profile")
`MPRco( TPOLY     , 200E-9     , "m"                 ,   0 , inf , "Height of poly gate on the source side ")
`MPRnb( CLM1      , 50E-3      , "-"                             , "Parameter for CLM  ")
`MPRnb( CLM2      , 2.0        , "1/m"                           , "Parameter for CLM  ")
`MPRnb( CLM3      , 1.0        , "-"                             , "Parameter for CLM  ")
`MPRnb( CLM5      , 1.0        , "-"                             , "Parameter for CLM  ")
`MPRnb( CLM6      , 0.0        , "-"                             , "Parameter for CLM  ")
`MPRnb( VOVERP    , 0.3        , "-"                             , "Parameter for overshoot  ")
`MPRnb( WFC       , 0.0        , "F/m"                           , "Parameter for narrow channel effect  ")
`MPRnb( NSUBCW    , 0.0        , "-"                             , "Parameter for narrow channel effect  ")
`MPRnb( NSUBCWP   , 1.0        , "-"                             , "Parameter for narrow channel effect  ")
`MPRnb( QME1      , 0.0        , "mV"                            , "Parameter for quantum effect  ")
`MPRnb( QME2      , 2.0        , "V"                             , "Parameter for quantum effect  ")
`MPRnb( QME3      , 0.0        , "m"                             , "Parameter for quantum effect  ")
`MPRnb( VOVERS    , 0.0        , "-"                             , "Parameter for overshoot  ")
`MPRnb( VOVERSP   , 0.0        , "-"                             , "Parameter for overshoot  ")
`MPRnb( GIDL1     , 2E0        , "-"                             , "Parameter for GIDL  ")
`MPRnb( GIDL2     , 3E7        , "-"                             , "Parameter for GIDL  ")
`MPRnb( GIDL3     , 0.9E0      , "-"                             , "Parameter for GIDL  ")
`MPRnb( GIDL4     , 0.0        , "-"                             , "Parameter for GIDL  ")
`MPRnb( GIDL5     , 0.2E0      , "-"                             , "Parameter for GIDL  ")
`MPRnb( GLEAK1    , 50E0       , "A*V^(-3/2)/C"                  , "Parameter for gate current  ")
`MPRnb( GLEAK2    , 10E6       , "V^(-1/2)/m "                   , "Parameter for gate current  ")
`MPRnb( GLEAK3    , 60E-3      , "-"                             , "Parameter for gate current  ")
`MPRnb( GLEAK4    , 4E0        , "1/m"                           , "Parameter for gate current  ")
`MPRoo( GLEAK5    , 7.5E3      , "V/m"               ,   0 , inf , "Parameter for gate current  ")
`MPRnb( GLEAK6    , 250E-3     , "V"                             , "Parameter for gate current  ")
`MPRnb( GLEAK7    , 1E-6       , "m^2"                           , "Parameter for gate current  ")
`MPRnb( GLPART1   , 0.5        , "-"                             , "Parameter for gate current  ")
`MPRnb( GLKSD1    , 1.0E-15    , "A*m/V^2"                       , "Parameter for gate current  ")
`MPRnb( GLKSD2    , 1E3        , "1/(V*m)"                       , "Parameter for gate current  ")
`MPRnb( GLKSD3    , -1E3       , "1/m"                           , "Parameter for gate current  ")
`MPRnb( GLKB1     , 5E-16      , "A/V^2"                         , "Parameter for gate current  ")
`MPRnb( GLKB2     , 1E0        , "m/V"                           , "Parameter for gate current  ")
`MPRnb( GLKB3     , 0E0        , "V"                             , "Parameter for gate current  ")
`MPRnb( EGIG      , 0E0        , "V"                             , "Parameter for gate current  ")
`MPRnb( IGTEMP2   , 0E0        , "V*K"                           , "Parameter for gate current  ")
`MPRnb( IGTEMP3   , 0E0        , "V*K^2"                         , "Parameter for gate current  ")
`MPRoo( VZADD0    , 10.0E-3    , "V"                 ,   0 , inf , "Vzadd at Vds=0   ")
`MPRoo( PZADD0    , 5.0E-3     , "V"                 ,   0 , inf , "Pzadd at Vds=0   ")
`MPRnb( NFTRP     , 10E9       , ""                              , "Ratio of trap density to attenuation coefficient")
`MPRnb( NFALP     , 1.0E-19    , ""                              , "Contribution of the mobility fluctuation")
`MPRnb( CIT       , 0E0        , ""                              , "capacitance caused by the interface trapped carriers")
`MPRoo( KAPPA     , 3.90E0     , "-"                 ,   0 , inf , "Dielectric constant for high-k stacked gate ")
`MPRco( CGDO      , 0          , "F/m"               ,   0 , inf , "Cgso ")
`MPRco( CGSO      , (COSYM ? CGDO : 0) , "F/m"       ,   0 , inf , "Cgso ")
`MPRoo( DLY1      , 100.0E-12  , "-"                 ,   0 , inf , "Parameter for transit time  ")
`MPRnb( DLY2      , 0.7E0      , "-"                             , "Parameter for transit time  ")
`MPRoo( DLY3      , 0.8E-6     , "s/F"               ,   0 , inf , "Parameter for transforming bulk charge  ")
`MPRco( DLYOV     , 0.8E-4     , "cm^2/A"            ,   0 , inf , "Parameter for transforming overlap charge  ")
`MPRoo( TNOM      , 27.0       , "K"             , -273.15 , inf , "Nominal temperature  ")
`MPRnb( OVSLP     , 2.1E-7     , ""                              , "Coefficient for overlap capacitance")
`MPRnb( OVMAG     , 0.6        , ""                              , "Coefficient for overlap capacitance")
`MPRcc( GBMIN     , 1.0E-12    , ""                  ,   0 , 1E4 , "Minimum Substrate resistance network")
`MPRnb( IBPC1     , 0.0        , "V/A"                           , "Parameter for impact-ionization induced bulk potential change ")
`MPRnb( IBPC1L    , 0.0        , "-"                             , "Parameter for impact-ionization induced bulk potential change ")
`MPRnb( IBPC1LP   , -1.0       , "-"                             , "Parameter for impact-ionization induced bulk potential change ")
`MPRnb( IBPC2     , 0.0        , "1/V"                           , "Parameter for impact-ionization induced bulk potential change ")
`MPRnb( MPHDFM    , -0.3       , ""                              , "NSUBCDFM dependence of phonon scattering for DFM ")
`MPRnb( PTL       , 0.0        , "V"                             , "Strength of punchthrough effect")
`MPRnb( PTP       , 3.5        , "-"                             , "Strength of punchthrough effect")
`MPRnb( PT2       , 0.0        , "1/V"                           , "Vds dependence of punchthrough effect")
`MPRnb( PTLP      , 1.0        , "-"                             , "Channel-length dependence of punchthrough effect")
`MPRnb( GDL       , 0.0        , "-"                             , "Strength of high-field effect")
`MPRnb( GDLP      , 0.0        , "-"                             , "Channel-length dependence of high-field effect")
`MPRnb( GDLD      , 0.0        , "m"                             , "Channel-length dependence of high-field effect")
`MPRnb( PT4       , 0.0        , ""                              , "Vbs dependence of punchthrough effect")
`MPRnb( PT4P      , 1.0        , ""                              , "Vbs dependence of punchthrough effect")
`MPRnb( RDVG12    , 100.0      , ""                              , "Vgs dependence of RD for CORSRD=1,3") //HV1
`MPRco( CTH0      , 1.0E-7     , "Ws/(Kcm)"          ,   0 , inf , "Thermal capacitance ")
`MPRco( XLDLD     , 1.0E-6     , "m"                 ,   0 , inf , "Lateral diffusion of Drain under the gate  ")
`MPRnb( XWDLD     , XWD        , "m"                             , "Widening of drift width")
`MPRnb( RD20      , 0.0        , ""                              , "RD23 boundary for CORSRD=2,3")                        //HV1
`MPRnb( RD21      , 1.0        , ""                              , "Vds dependence of RD for CORSRD=2,3")           //HV1
`BPRnb( RD22      , 0.0        , ""                              , "Vbs dependence of RD for CORSRD=2,3")           //HV1
`MPRnb( RD22D     , 0.0        , ""                              , "Vbs dependence of RD for CORSRD=2,3 with large Vds")  //HV1
`MPRnb( RD25      , 0.0        , ""                              , "Vgs dependence of RD for CORSRD=2,3")           //HV1
`MPRnb( RDVDL     , 0.0        , ""                              , "Lgate dependence of RD for CORSRD=1,3")                 //HV1
`MPRnb( RDVDLP    , 1.0        , ""                              , "Lgate dependence of RD for CORSRD=1,3")                 //HV1
`MPRnb( RDVDS     , 0.0        , ""                              , "Small size dependence of RD for CORSRD=1,3")    //HV1
`MPRnb( RDVDSP    , 1.0        , ""                              , "Small size dependence of RD for CORSRD=1,3")    //HV1
`MPRnb( RD23L     , 0.0        , ""                              , "Lgate dependence of RD23 boundary for CORSRD=2,3")      //HV1
`MPRnb( RD23LP    , 1.0        , ""                              , "Lgate dependence of RD23 boundary for CORSRD=2,3")      //HV1
`MPRnb( RD23S     , 0.0        , ""                              , "Small size dependence of RD23 for CORSRD=2,3")          //HV1
`MPRnb( RD23SP    , 1.0        , ""                              , "Small size dependence of RD23 for CORSRD=2,3")          //HV1
`MPRnb( RDS       , 0.0        , ""                              , "Small size dependence of RD for CORSRD=1,3")    //HV1
`MPRnb( RDSP      , 1.0        , ""                              , "Small size dependence of RD for CORSRD=1,3")          //HV1
`MPRnb( RDTEMP1   , 0.0        , "ohm*cm/K"                      , "Temperature-dependence of Rd ")
`MPRnb( RDTEMP2   , 0.0        , "ohm*cm/K^2"                    , "Temperature-dependence of Rd ")
`MPRnb( RDVDTEMP1 , 0.0        , "ohm*cm/V/K"                    , "Temperature-dependence of RDVD ")                     //HV1
`MPRnb( RDVDTEMP2 , 0.0        , "ohm*cm/V/K^2"                  , "Temperature-dependence of RDVD ")                     //HV1
`MPRnb( RTH0W     , 0.0        , "-"                             , "Width-dependence of RTH0 ")
`MPRnb( RTH0WP    , 1.0        , "-"                             , "Width-dependence of RTH0 ")
`MPRnb( RTH0L     , 0.0        , "-"                             , "Length dependence of RTH0 ")
`MPRnb( RTH0LP    , 1.0        , "-"                             , "Length dependence of RTH0 ")
`MPRnb( NINVD     , 0.0        , "1/V"                           , "Modification of Vdse dependence on Eeff  ")
`MPRnb( NINVDL    , 0.0        , "-"                             , "Coeff of modification of Vdse dependence on Eeff  ")
`MPRnb( NINVDLP   , 1.0        , "-"                             , "Coeff of modification of Vdse dependence on Eeff  ")
`MPRnb( NINVDW    , 0.0        , "-"                             , "Coeff of modification of Vdse dependence on Eeff  ")
`MPRnb( NINVDWP   , 1.0        , "-"                             , "Coeff of modification of Vdse dependence on Eeff  ")
`MPRnb( NINVDT1   , 0.0        , "-"                             , "Coeff of modification of Vdse dependence on Eeff  ")
`MPRnb( NINVDT2   , 0.0        , "-"                             , "Coeff of modification of Vdse dependence on Eeff  ")
`MPRnb( VBSMIN    , -10.5      , "V"                             , "Minimum back bias voltage to be treated in hsmhveval ")
`MPRnb( RTH0NF    , 0.0        , "-"                             , "Nf-dependence of RTH0 ")
`MPRnb( RTHTEMP1  , 0.0        , "m/W"                           , "Thermal resistance ")
`MPRnb( RTHTEMP2  , 0.0        , "m/W/K"                         , "Thermal resistance ")
`MPRnb( PRATTEMP1 , 0.0        , "1/K"                           , "Temperature dependence of thermal dissipation")
`MPRnb( PRATTEMP2 , 0.0        , "1/k^2"                         , "Temperature dependence of thermal dissipation")
`MPRnb( RDVSUB    , 1.0        , ""                              , "Model parameter for the substrate effect ")
`MPRnb( RDVDSUB   , 0.3        , ""                              , "Model parameter for the substrate effect ")
`MPRoo( DDRIFT    , 1.0E-6     , ""                  ,   0 , inf , "Model parameter for the substrate effect ")
`MPRnb( VBISUB    , 0.7        , ""                              , "Model parameter for the substrate effect ")
`MPRoo( NSUBSUB   , 1.0E15     , ""                  ,   0 , inf , "Model parameter for the substrate effect ")
`MPRoo( SHEMAXDLT , 0.1        , ""                  ,   0 , inf , "Delta for the SHEMAX smoothing")
`MPRoo( VBFWDMX   , 0.8        , "V"                 ,   0 , inf , "VBS forward max (protection)")
`MPRoo( VBFWDBND  , 0.4        , "V"                 ,   0 , inf , "VBS forward boundary (protection)")

// Model parameters for depletion MOSFET
`MPRoo( NDEPM     , ((CODEP < 3) ? 1E17:4E16) ,"1/cm^3" , 0 ,inf , "Impurity concentration of the surface layer (resistor) (CODEP=1,2,3)")
//20170913 compatibility to hisim2
`MPRnb( NDEPML        , 0.0        , "-"                          , "Lgate dependence of impurity concentration of the surface N^- layer" )
`MPRnb( NDEPMLP       , 1.0        , "-"                          , "Lgate dependence of impurity concentration of the surface N^- layer" )
//
`MPRoo( TNDEP     , ((CODEP < 3) ? 200n:300n) ,"m"      , 0 ,inf , "Thickness of the surface layer (CODEP=1,2,3)")
`MPRoo( TNDEPMIN  , (TNDEP*1u) , "m"        , (TNDEP*1n) , TNDEP , "minumum thickness of the surface layer (CODEP=3)")
`MPRnb( TNDEPV    , 0          , "1/V"                           , "Vds dependence of TNDEP (CODEP=2,3)")
`MPRnb( DEPMUE0   , ((CODEP < 3) ? 1e3:1E8) , "cm^2/V/s"         , "Coulomb scattering in the resistor part (CODEP=1,2,3)")
`MPRnb( DEPMUE0L      , 0.0        , "-"                          , "Lgate dependence of the Coulomb scattering in the resistor region" )
`MPRnb( DEPMUE0LP     , 1.0        , "-"                          , "Lgate dependence of the Coulomb scattering in the resistor region" )
`MPRnb( DEPMUE1   , ((CODEP < 3) ?   0:100) , "cm^2/V/s"         , "Coulomb scattering in the resistor part (CODEP=1,  3)")
`MPRnb( DEPMUE1L      , 0.0        , "-"                          , "Lgate dependence of the Phonon scattering in the resistor region" )
`MPRnb( DEPMUE1LP     , 1.0        , "-"                          , "Lgate dependence of the Phonon scattering in the resistor region" )
`MPRoo( DEPMUE2   , 1e3        , "cm^2/V/s"          ,   0 , inf , "Coulomb scattering of the resistor part (CODEP=2)")
`MPRnb( DEPMUEA1  , 0.0        , "-"                             , "Modification of mures (CODEP=2)")
`MPRnb( DEPMUEBACK0 , 100      , "cm^2/V/s"                      , "Coulomb scattering in the back part (CODEP=1)")
`MPRnb( DEPMUEBACK1 , 0        , "cm^2/V/s"                      , "Coulomb scattering in the back part (CODEP=1)")
`MPRnb( DEPMUEBACK0L  , 0.0        , "-"                          , "Lgate dependence of the Coulomb scattering in the back region" ) //CODEP=1
`MPRnb( DEPMUEBACK0LP , 1.0        , "-"                          , "Lgate dependence of the Coulomb scattering in the back region" ) //CODEP=1
`MPRnb( DEPMUEBACK1L  , 0.0        , "-"                          , "Lgate dependence of the Phonon scattering in the back region" ) //CODEP=1
`MPRnb( DEPMUEBACK1LP , 1.0        , "-"                          , "Lgate dependence of the Phonon scattering in the back region" ) //CODEP=1
`MPRnb( DEPLEAK   , ((CODEP < 3) ? 0.5:0.1) , "V"                , "leakage current coefficient (CODEP=1,2,3)")
`MPRnb( DEPLEAKL      , 0.0        , "-"                          , "Lgate dependence of leakage current coefficient" )
`MPRnb( DEPLEAKLP     , 1.0        , "-"                          , "Lgate dependence of leakage current coefficient" )
`MPRco( DEPJLEAK  , 0          , "A/m2"              ,   0 , inf , "current density of the leak part (CODEP=3)")
`MPRnb( DEPWLP    , 0          , "A/m2"                          , "Coeff of the leak part (CODEP=3)")
`MPRnb( DEPWLPT   , 0          , "-"                             , "Temperature dependence of DEPWLP (CODEP=3)")
`MPRnb( DEPETA    , 0.0        , "-"                             , "Vds dependence of the threshold voltage shift (CODEP=1)")
`MPRoo( DEPVMAX   , ((CODEP < 3) ? 3e7:1e7) , "cm/s" ,   0 , inf , "Saturation velocity in the resistor part (CODEP=1,2,3)")
`MPRnb( DEPVMAXL      , 0.0        , "-"                          , "Lgate dependence of the saturation velocity in the resistor region" )
`MPRnb( DEPVMAXLP     , 1.0        , "-"                          , "Lgate dependence of the saturation velocity in the resistor region" )
`MPRnb( DEPVDSEF1 ,  2.0       , "V"            , "Effective drain potential coefficient-1 in the resistor part (CODEP=1)")
`MPRnb( DEPVDSEF2 ,  0.5       , "-"            , "Effective drain potential coefficient-2 in the resistor part (CODEP=1)")
`MPRnb( DEPVDSEF1L    , 0.0        , "-"                          , "Lgate dependence of the effective drain potential coefficient" ) //CODEP=1
`MPRnb( DEPVDSEF1LP   , 1.0        , "-"                          , "Lgate dependence of the effective drain potential coefficient" ) //CODEP=1
`MPRnb( DEPVDSEF2L    , 0.0        , "-"                          , "Lgate dependence of the effective drain potential coefficient" ) //CODEP=1
`MPRnb( DEPVDSEF2LP   , 1.0        , "-"                          , "Lgate dependence of the effective drain potential coefficient" ) //CODEP=1
`MPRnb( DEPMUEPH0 , ((CODEP < 3) ? 0.3:  0), "-"                 , "Phonon scattering in the resistor part (CODEP=1,3)")
`MPRoo( DEPMUEPH1 , ((CODEP < 3) ? 5e3:400), "cm^2/V/s", 0 , inf , "Phonon scattering in the resistor part (CODEP=1,3)")
`MPRco( DEPBB     , ((CODEP < 3) ? 1.0:2.0), "-"    , 0.01 , inf , "High-field-mobility degradation in the resistor part (CODEP=1,2,3)")
`MPRnb( DEPVTMP   , 0.0        , "-"                             , "Temperature dependence of DEPVMAX (CODEP=1,2,3)")
`MPRnb( DEPMUETMP , 1.5        , "-"                             , "Temperature dependence of the phonon scattering in the resistor part (CODEP=1,2,3)")
`MPRnb( DEPMUE0TMP , 0.0       , "-"                             , "Temperature dependence of DEPMUE0 (CODEP=1,3)")  //CODEP = 1, 3 Coulomb scat mobility
`MPRnb( DEPMUE2TMP , 0.0       , "-"                             , "temperature dependence of DEPMUE2 (CODEP=2)")    //CODEP = 2
`MPRcc( DEPDDLT   , ((CODEP < 3) ? 3.0:1.0) , "-"    , 0.1 ,  20 , "Smoothing coefficient for Vds,res (CODEP=2,3)") // 20171127 lower limit
`MPRnb( DEPNINVDC ,  100.0     , "1/V"                           , "Modification of Vdse dependence on Eeff (for Mu_res) (CODEP=3)")
`MPRnb( DEPNINVDH ,  10.0      , "1/V"                           , "Modification of Vdse dependence on Eeff (for Mu_res) (CODEP=3)")
`MPRnb( DEPNINVDL  , 0.0       , "-"                             , "Coeff of modification of Vdse dependence on Eeff; Mu_res (CODEP=3)")
`MPRnb( DEPNINVDLP , 1.0       , "-"                             , "Coeff of modification of Vdse dependence on Eeff; Mu_res (CODEP=3)")
`MPRnb( DEPNINVDW  , 0.0       , "-"                             , "Coeff of modification of Vdse dependence on Eeff; Mu_res (CODEP=3)")
`MPRnb( DEPNINVDWP , 1.0       , "-"                             , "Coeff of modification of Vdse dependence on Eeff; Mu_res (CODEP=3)")
`MPRnb( DEPNINVDT1 , 0.0       , "-"                             , "Coeff of modification of Vdse dependence on Eeff; Mu_res (CODEP=3)")
`MPRnb( DEPNINVDT2 , 0.0       , "-"                             , "Coeff of modification of Vdse dependence on Eeff; Mu_res (CODEP=3)")
`MPRnb( DEPVFBC   , VFBC       , "V"                             , "Flat-band voltage of the resistor part (CODEP=2)")          //CODEP = 2
`MPRnb( DEPDVFBC  , 0.1        , "V"                             , "delta of Flat-band voltage of the resistor part (CODEP=3)") //CODEP = 3
`MPRco( DEPSUBSL  , 2.0        , "-"                , 1e-8 , inf , "Factor of the sub-threshold sloop (CODEP=2,3)")             //CODEP = 2, 3
`MPRco( DEPSUBSL0 , DEPSUBSL   , "-"                , 1e-8 , inf , "Factor of the sub-threshold sloop (CODEP=2,3)")             //CODEP = 3
`MPRnb( DEPVSATR  , 0.0        , "-"                             , "Vbs dependence of subVds,sat of the resistor part (CODEP=2)") //CODEP = 2
`MPRnb( DEPVSATA  , 0.0        , "V", " Vdssat shift depmos3") // 20171004
`MPRcc( DEPRBR    , 1          , "-"                , 0    ,   1 , "parameter for resistance effect along substrate (for minority carrier) (CODEP=3)") //CODEP = 3
`MPRcc( DEPVLEAK    , 1          , "-"           , -0.5    ,   1 , "Vbs dependence of resistance leak current(CODEP=3)") //CODEP = 3
`MPRnb( DEPCAR    , 0.0        , "m/V"                           , "coefficient for Ndrift,res (CODEP=3)")            //CODEP = 3
`MPRnb( DEPRDRDL1 , 0.0        , "m"                             , "RDRDL1 for surface layer (CODEP=3)")              //CODEP = 3
`MPRnb( DEPRDRDL2 , 0.0        , "m"                             , "Pinch-off length in resistor layer (CODEP=3)")    //CODEP = 3
`MPRnb( DEPPS     , 0.01       , "V"                             , "Ps_delta for smoothing charge (CODEP=3)")         //CODEP = 3
`MPRcc( DEPQF     , 0.01       , "V"                , 1e-8 ,   8 , "smoothing param for Vdseff (CODEP=3)")            //CODEP = 3
`MPRcc( DEPQFRES  , 0.05       , "V"                , 1e-8 ,   8 , "smoothing param for Vdsres (CODEP=3)")            //CODEP = 3
`MPRcc( DEPFDPD   , 0.2        , "V"                , 1e-8 ,   4 , "smoothing param for FD/PD transition (CODEP=3)")  //CODEP = 3
`MPRco( DEPVGPSL  , ((CODEP < 3) ? 0.0:0.2) , "V"  ,     0 , inf , "Smoothing coefficient for gm (CODEP=2,3)")        //CODEP = 2, 3
`MPRcc( DEPPB0    ,0.5         , "V"                ,0     , 0.5 , "Flooring for Eeff for Mu_res depmos3") // HiSIM2 3.0.0 compatible

// Model parameters for drift resistance
`MPRoo( RDRMUE    , 1.0E3      , "cm^2/V/s"          ,   0 , inf , "Mobility in drift region")
`MPRnb( RDRMUEBS1  , 0.0        , "-"                             , "Vbs coefficient to Rdrmue")
`MPRnb( RDRMUEBS2  , 0.0        , "-"                             , "2nd order Vbs coefficient to Rdrmue")
`MPRoo( RDRVMAX   , 3.0E7      , "cm/s"              ,   0 , inf , "Saturation velocity in drift region")
`MPRoo( RDRMUES   , RDRMUE     , "cm^2/V/s"          ,   0 , inf , "Mobility in drift region (source)")
`MPRoo( RDRVMAXS  , RDRVMAX    , "cm/s"              ,   0 , inf , "Saturation velocity in drift region (source)")
`MPRnb( RDRMUETMP , 0.0        , ""                              , "Temperature dependence of resistance")
`MPRnb( RDRMUETMPS, RDRMUETMP  , ""                              , "Temperature dependence of resistance (source)")
`MPRnb( RDRVTMP   , 0.0        , ""                              , "Temperature dependence of resistance")
`MPRnb( RDRVTMPS  , RDRVTMP    , ""                              , "Temperature dependence of resistance (source)")
`MPRoo( RDRDJUNC  , 1.0E-6     , "m"                 ,   0 , inf , "Junction depth at channel/drift region")
`MPRnb( RDRCX     , 0.0        , ""                              , "Exude of current flow from Xov")
`MPRnb( RDRCAR    , 1.0E-8     , ""                              , "High field injection in drift region")
`MPRoo( RDRDL1    , 0.0        , "m"  , -(LDRIFT1+LDRIFT2) , inf , "Effective Ldrift of current in drift region")
`MPRco( RDRDL2    , 0.0        , "m"  ,    0 , (LDRIFT1+LDRIFT2) , "Pinch-off length in drift region")
`MPRnb( RDRVMAXW  , 0.0        , ""                              , "Wgate dependence of the saturation velocity in drift region")
`MPRnb( RDRVMAXWP , 1.0        , ""                              , "Wgate dependence of the saturation velocity in drift region")
`MPRnb( RDRVMAXL  , 0.0        , ""                              , "Lgate dependence of the saturation velocity in drift region")
`MPRnb( RDRVMAXLP , 1.0        , ""                              , "Lgate dependence of the saturation velocity in drift region")
`MPRnb( RDRMUEL   , 0.0        , ""                              , "Lgate dependence of the mobility in drift region ")
`MPRnb( RDRMUELP  , 1.0        , ""                              , "Lgate dependence of the mobility in drift region ")
`MPRco( RDRQOVER  , 1E5        , "-"                 ,   0 , inf , "Inclusion of the overlap charge into Rdrift")
`MPRco( QOVADD    , 0.0        , "-"                 ,   0 , inf , "Parameter for additional Qover Charge  ")
`MPRco( QOVJUNC   , 0.0        , "-"                 ,  -1 ,  50 , "Parameter for Qover capacitance with p-n junction ")
`MPRco( SHEMAX    , 500        , "K"                 ,   0 , inf , "Maximum rise temperature for SHE  ")
`MPRnb( VGSMIN   , -100 * TYPE , "V"                             , "Minimum/maximum expected Vgs(NMOS/PMOS)  ")
`MPRco( GDSLEAK   , 0.0        , "A/V"               ,   0 , 1E4 , "Channel leakage conductance  ")
`MPRco( RDRBB     , 1          , "-"                 , 0.1 , inf , "Degradation of the mobility in drift region ")
`MPRco( RDRBBS    , RDRBB      , "-"                 , 0.1 , inf , "degradation of the mobility in drift region (source)")
`MPRnb( RDRBBTMP  , 0          , "1/K"                           , "Temperature coefficient of RDRBB ")
`MPRnb( RDRBBTMPS , RDRBBTMP   , "1/K"                           , "temperature coefficient of RDRBBS (source) ")
`MPRco( NDRILIM ,  1         , "-"                 ,   0 , inf , "ceiling for Ndrift  ")
`MPRco( NDRIDLT ,  1         , "-"                 ,   0 , inf , "guardband for smoothing of Ndrift ")
`MPRoo( NDRIPW ,   1         , "-"                 ,   0 , inf , "power exponent for smoothing of Ndrift")
`MPRcc( GMIN      , 0          , ""                  ,   0 , 1E4 , "Minimum conductance")
`MPRoo( RMIN      , 1E-4       , ""                  ,   0 , inf , "Minimum resistance for RS / RD")
// Model parameters for break-down model
`MPRnb( HBDA      , 0.0        , ""                              , "Coeff. for Hard Breakdown Voltage ")
`MPRnb( HBDB      , 0.0        , ""                              , "Coeff. for Hard Breakdown Voltage ")
`MPRnb( HBDC      , 100        , ""                              , "Coeff. for Hard Breakdown Voltage ")
`MPRnb( HBDCTMP   , 0.0        , ""                              , "Temperature Coeff. for HBDC")
`MPRnb( HBDF      , 1.0        , ""                              , "Coeff. for Hard Breakdown Voltage ")

// Model parameters for newest punchthrough model
`MPIcc( COPT      , 0          , "-"                  ,   0 ,   1 , "flag punchthrough ")
`MPIsw( COPSPT    , 0          , "-"                             , "flag Ps0 method for new punchthrough ")
`MPRco( XJPT      , 3E-8       , "m"                 ,   0 ,   1 , "Junction depth; new Punchthrough ")
`MPRoo( NJUNC     , 1e20       , "cm-3"              ,   0 , inf , "Junction doping conc; new Punchthrough  ")
`MPRco( MUPT      , 0.0        , "m^2/Vs"            ,   0 , inf , "mobility for new Punchthrough ")
`MPRnb( VFBPT     , 0.0        , "V"                             , "dVfb for new punchthrough ")
`MPRnb( PSLIMPT   , 0.0        , "V"                             , "Ps0 limit for new punchthrough ")
`MPRco( PS0PT     , 0.0        , "V"                 ,   0 , inf , "Constant Ps0 & revised eq. for new punchthrough if >0")
`ifdef _AGING_
    /////////////// Parameter for Aging model ///////////////
    `BPRco( DEGTIME0   , 0.0        , "s"                ,   0 , inf , "aging simulation time ")
    `BPRco( DEGTIME    , 0          , "s"                ,   0 , inf , "degradation time ")
    `BPRnb( TRAPN      , 1.0        , "-"                            , "trap charge contribution to Eeff  ")
    `BPRnb( TRAPP      , 1.0        , "-"                            , "BTI trap charge contribution to Eeff")
    /////////////// Parameter for HC model //////////////////
    `BPRnb( TRAPGC0    , 1.0E30    , "cm^-3eV^-1"                    , "coefficient of deep trap ")
    `BPRoo( TRAPES0    , 0.01      , "eV"                            ,   0 , inf  , "coefficient of deep trap ")
    `BPRnb( TRAPGC1    , 1.0E15    , "cm^-3eV^-1"                    , "coefficient of deep trap ")
    `BPRoo( TRAPES1    , 0.2       , "eV"               ,   0 , inf  , "coefficient of deep trap ")
    `BPRnb( TRAPGC2    , 5.0e13    , "cm^-3eV^-1"                    , "coefficient of shallow trap ")
    `BPRoo( TRAPES2    , 0.03      , "eV"               ,   0 , inf  , "coefficient of shallow trap ")
    `BPRoo( TRAPLX     , 1         , "V"                ,   0 , inf  , "Vds dependence of deep trap position")
    `BPRnb( TRAPGCLIM  , 1E30      , "cm^-3eV^-1"                    , "coefficient of deep trap ")
    `BPRnb( TRAPESLIM  , 5         , "eV"                            , "coefficient of deep trap ")
    `BPRnb( TRAPTAUCAP  , 1e-6     , "s"                             , "Time constant of trap capture")
    `BPRnb( TRAPGC1MAX  , 5E19     , "cm^-3eV^-1"                    , "GC1 aging coefficient ")
    `BPRnb( TRAPES1MAX  , 1        , "eV"                            , "ES1 aging coefficient ")
    `BPRnb( TRAPGCTIME1 , 30       , "s"                             , "starting stress duration of GC1 aging ")
    `BPRnb( TRAPGCTIME2 , 1E8      , "s"                             , "saturating stress duration of GC1 aging ")
    `BPRnb( TRAPESTIME1 , 100      , "s"                             , "starting stress duration of ES1 aging ")
    `BPRnb( TRAPESTIME2 , 1E8      , "s"                             , "saturating stress duration of ES1 aging ")
    `MPRnb( TRAPDTIME1 , 1000      , "s"                             , "starting stress duration of D1 aging")
    `MPRnb( TRAPDTIME2 , 2E10      , "s"                             , "saturating stress duration of D1 aging")
    `MPRnb( TRAPD1MAX  , 30.0      , "V"                             , "D1 aging coefficient")
    `BPRoo( TRAPDVDDP  , 0.0       , "V"                , -inf , inf , "Ntrap in Rdrift")
    `BPRnb( TRAPDLX    , 1.0       , "V"                             , "Vds dependence of trap position")
    `BPRnb( TRAPTEMP1  , 0.0       , ""                              , "temperature dependence of trap")
    `BPRnb( TRAPTEMP2  , 0.0       , ""                              , "temperature dependence of trap")
    /////////////// Parameter for BTI model ///////////////
    `BPRnb( TRAPDVTH   , 0.0        , "V"                            , "Vfb shift dut to interface trap density")
    `MPRnb( TRAPA      , 0.0        , "V"                            , "coefficient of existing interface trap density")
    `MPRnb( TRAPB      , 4E-9       , "m/V"                          , "coefficient of existing interface trap density")
    `BPRnb( TRAPBTI    , 1e7        , "s"                            , "coefficient for duration time dependence")
`endif

`ifdef COEXTDIO
    /* for Junction Diode Model */
`else
    `MPRnb( JS0       , 0.5E-6     , "A/m^2"                         , "Saturation current density  ")
    `MPRnb( JS0SW     , 0.0        , "A/m"                           , "Side wall saturation current density  ")
    `MPRnb( JS0SWG    , 0.0        , "A/m"                           , "Gate side wall saturation current density  ")
    `MPRoo( NJ        , 1.0        , "-"                 ,   0 , inf , "Emission coefficient  ")
    `MPRoo( NJSW      , 1.0        , "-"                 ,   0 , inf , "Sidewall emission coefficient ")
    `MPRoo( NJSWG     , 1.0        , "-"                 ,   0 , inf , "Gate sidewall emission coefficient ")
    `MPRnb( XTI       , 2.0        , "-"                             , "Junction current temperature exponent coefficient  ")
    `MPRnb( CJ        , 5.0E-04    , "F/m^2"                         , "Bottom junction capacitance per unit area at zero bias  ")
    `MPRnb( CJSW      , 5.0E-10    , "F/m"                           , "Source/drain sidewall junction capacitance grading coefficient per unit length at zero bias  ")
    `MPRnb( CJSWG     , 5.0E-10    , "F/m"                           , "Source/drain gate sidewall junction capacitance per unit length at zero bias  ")
    `MPRoo( MJ        , 0.5E0      , "-"                , -inf ,   1 , "Bottom junction capacitance grading coefficient ")
    `MPRoo( MJSW      , 0.33E0     , "-"                , -inf ,   1 , "Source/drain sidewall junction capacitance grading coefficient ")
    `MPRoo( MJSWG     , 0.33E0     , "-"                , -inf ,   1 , "Source/drain gate sidewall junction capacitance grading coefficient ")
    `MPRoo( PB        , 1.0E0      , "V"                 ,   0 , inf , "Bottom junction build-in potential   ")
    `MPRoo( PBSW      , 1.0E0      , "V"                 ,   0 , inf , "Source/drain sidewall junction build-in potential  ")
    `MPRoo( PBSWG     , 1.0E0      , "V"                 ,   0 , inf , "Source/drain gate sidewall junction build-in potential  ")
    `MPRnb( XTI2      , 0.0E0      , "-"                             , "Temperature coefficient  ")
    `MPRnb( CISB      , 0.0E0      , "-"                             , "Reverse bias saturation current  ")
    `MPRnb( CVB       , 0.0E0      , "-"                             , "Bias dependence coefficient of cisb  ")
    `MPRnb( CTEMP     , 0.0E0      , "-"                             , "Temperature coefficient  ")
    `MPRnb( CISBK     , 0.0E0      , "A"                             , "Reverse bias saturation current  ")
    //`MPRnb( CVBK      , CVB        , "-"                             , "Inactivated by CVB ")
    `MPRnb( DIVX      , 0.0        , "1/V"                           , "Reverse current coefficient")
    `MPRnb( VDIFFJ    , 0.6E-3     , "V"                             , "Threshold voltage for S/D junction diode  ")
    `MPRnb( TCJBD     , 0.0        , "1/K"                           , "Temperature dependence of cjbd ")
    `MPRnb( TCJBS     , 0.0        , "1/K"                           , "Temperature dependence of cjbs ")
    `MPRnb( TCJBDSW   , 0.0        , "1/K"                           , "Temperature dependence of cjbdsw ")
    `MPRnb( TCJBSSW   , 0.0        , "1/K"                           , "Temperature dependence of cjbssw ")
    `MPRnb( TCJBDSWG  , 0.0        , "1/K"                           , "Temperature dependence of cjbdswg ")
    `MPRnb( TCJBSSWG  , 0.0        , "1/K"                           , "Temperature dependence of cjbsswg ")
    `MPRnb( TPBBD     , 0.0        , "V/K"                           , "Temperature dependence of pzbd ")
    `MPRnb( TPBBS     , 0.0        , "V/K"                           , "Temperature dependence of pzbs ")
    `MPRnb( TPBBDSW   , 0.0        , "V/K"                           , "Temperature dependence of pzbdsw ")
    `MPRnb( TPBBSSW   , 0.0        , "V/K"                           , "Temperature dependence of pzbssw ")
    `MPRnb( TPBBDSWG  , 0.0        , "V/K"                           , "Temperature dependence of pzbdswg ")
    `MPRnb( TPBBSSWG  , 0.0        , "V/K"                           , "Temperature dependence of pzbsswg ")
    `MPRnb( JS0D      , JS0        , "A/m^2"                         , "Saturation current density for drain junction  ")
    `MPRnb( JS0SWD    , JS0SW      , "A/m"                           , "Side wall saturation current density for drain junction  ")
    `MPRnb( JS0SWGD   , JS0SWG     , "A/m"                           , "Gate side wall saturation current density for drain junction  ")
    `MPRoo( NJD       , NJ         , "-"                 ,   0 , inf , "Emission coefficient for drain junction  ")
    `MPRoo( NJSWD     , NJSW       , "-"                 ,   0 , inf , "Sidewall emission coefficient for drain junction  ")
    `MPRoo( NJSWGD    , NJSWG      , "-"                 ,   0 , inf , "Gate sidewall emission coefficient for drain junction  ")
    `MPRnb( XTID      , XTI        , "-"                             , "Junction current temperature exponent coefficient for drain junction  ")
    `MPRnb( CJD       , CJ         , "F/m^2"                         , "Bottom junction capacitance per unit area at zero bias for drain junction  ")
    `MPRnb( CJSWD     , CJSW       , "F/m"                           , "Sidewall junction capacitance grading coefficient per unit length at zero bias for drain junction  ")
    `MPRnb( CJSWGD    , CJSWG      , "F/m"                           , "Gate sidewall junction capacitance per unit length at zero bias for drain junction  ")
    `MPRoo( MJD       , MJ         , "-"                , -inf ,   1 , "Bottom junction capacitance grading coefficient for drain junction  ")
    `MPRoo( MJSWD     , MJSW       , "-"                , -inf ,   1 , "Sidewall junction capacitance grading coefficient for drain junction  ")
    `MPRoo( MJSWGD    , MJSWG      , "-"                , -inf ,   1 , "Gate sidewall junction capacitance grading coefficient for drain junction  ")
    `MPRoo( PBD       , PB         , "V"                ,   0  , inf , "Bottom junction build-in potential  for drain junction   ")
    `MPRoo( PBSWD     , PBSW       , "V"                ,   0  , inf , "Sidewall junction build-in potential for drain junction  ")
    `MPRoo( PBSWGD    , PBSWG      , "V"                ,   0  , inf , "Gate sidewall junction build-in potential for drain junction  ")
    `MPRnb( XTI2D     , XTI2       , "-"                             , "Temperature coefficient for drain junction  ")
    `MPRnb( CISBD     , CISB       , "-"                             , "Reverse bias saturation current for drain junction  ")
    `MPRnb( CVBD      , CVB        , "-"                             , "Bias dependence coefficient of cisb for drain junction   ")
    `MPRnb( CTEMPD    , CTEMP      , "-"                             , "Temperature coefficient for drain junction  ")
    `MPRnb( CISBKD    , CISBK      , "A"                             , "Reverse bias saturation current for drain junction  ")
    `MPRnb( DIVXD     , DIVX       , "1/V"                           , "Reverse coefficient coefficient for drain junction  ")
    `MPRnb( VDIFFJD   , VDIFFJ     , "V"                             , "Threshold voltage for junction diode for drain junction  ")

    `MPRnb( JS0S      , JS0D       , "A/m^2"                         , "Saturation current density for source junction  ")
    `MPRnb( JS0SWS    , JS0SWD     , "A/m"                           , "Side wall saturation current density for source junction  ")
    `MPRnb( JS0SWGS   , JS0SWGD    , "A/m"                           , "Gate side wall saturation current density for source junction  ")
    `MPRoo( NJS       , NJD        , "-"                 ,   0 , inf , "Emission coefficient for source junction  ")
    `MPRoo( NJSWS     , NJSWD      , "-"                  ,   0 , inf , "Sidewall emission coefficient for source junction  ")
    `MPRoo( NJSWGS    , NJSWGD     , "-"                  ,   0 , inf , "Gate sidewall emission coefficient for source junction  ")
    `MPRnb( XTIS      , XTID       , "-"                             , "Junction current temperature exponent coefficient for source junction  ")
    `MPRnb( CJS       , CJD        , "F/m^2"                         , "Bottom junction capacitance per unit area at zero bias for source junction  ")
    `MPRnb( CJSWS     , CJSWD      , "F/m"                           , "Sidewall junction capacitance grading coefficient per unit length at zero bias for source junction  ")
    `MPRnb( CJSWGS    , CJSWGD     , "F/m"                           , "Gate sidewall junction capacitance per unit length at zero bias for source junction  ")
    `MPRoo( MJS       , MJD        , "-"                 , -inf ,   1 , "Bottom junction capacitance grading coefficient for source junction  ")
    `MPRoo( MJSWS     , MJSWD      , "-"                 , -inf ,   1 , "Sidewall junction capacitance grading coefficient for source junction  ")
    `MPRoo( MJSWGS    , MJSWGD     , "-"                 , -inf ,   1 , "Gate sidewall junction capacitance grading coefficient for source junction  ")
    `MPRoo( PBS       , PBD        , "V"                 ,   0 , inf , "Bottom junction build-in potential  for source junction   ")
    `MPRoo( PBSWS     , PBSWD      , "V"                 ,   0 , inf , "Sidewall junction build-in potential for source junction  ")
    `MPRoo( PBSWGS    , PBSWGD     , "V"                 ,   0 , inf , "Gate sidewall junction build-in potential for source junction  ")
    `MPRnb( XTI2S     , XTI2D      , "-"                             , "Temperature coefficient for source junction  ")
    `MPRnb( CISBS     , CISBD      , "-"                             , "Reverse bias saturation current for source junction  ")
    `MPRnb( CVBS      , CVBD       , "-"                             , "Bias dependence coefficient of cisb for source junction   ")
    `MPRnb( CTEMPS    , CTEMPD     , "-"                             , "Temperature coefficient for source junction  ")
    `MPRnb( CISBKS    , CISBKD     , "A"                             , "Reverse bias saturation current for source junction  ")
    `MPRnb( DIVXS     , DIVXD      , "1/V"                           , "Reverse coefficient coefficient for source junction  ")
    `MPRnb( VDIFFJS   , VDIFFJD    , "V"                             , "Threshold voltage for junction diode for source junction  ")

    //imported from DIODE_CMC_parlist.include:
    //diode reverse recovery model
    `MPRnb( CORECOVERY , 0.0       , "-"                             , "Flag for recovery equations; 0=original, 1=Hiroshima")    //`from(0.0    , 1.0 )
    `MPRnb( NDIBOT    , 1e16       , "cm^-3"                         , "Doping concentration of drift region")                    //`from(1      , 1e23 )
    `MPRnb( INJ1      , 1.0        , "-"                             , "For carrier density")                                     //`from(0      , 3 )
    `MPRnb( INJ2      , 10.0       , "-"                             , "For carrier density in high-injection condition")         //`from(0      , 20 )
    `MPRnb( NQS       , 5e-9       , "sec"                           , "Carrier delay time")                                      //`from(0      , 1e-3 )
    `MPRnb( TAU       , 2e-7       , "sec"                           , "Carrier lifetime")                                        //`from(0      , 1e-3 )
    `MPRnb( WI        , 5e-6       , "m"                             , "Length of drift region")                                  //`from(0      , 1.0 )
    `MPRnb( DEPNQS    , 0.0        , "sec"                           , "Depletion delay time")                                    //`from(0      , 1e-3 )
    `MPRnb( TAUT      , 0.0        , "-"                             , "Temp. co of carrier lifetime")                            //`from(0.0    , 1.0e2 )
    `MPRnb( INJT      , 0.0        , "-"                             , "Temp. co of carrier density in high-injection condition") //`from(0      , 20 )
    //End of diode reverse recovery model

`endif /* End of COEXTDIO */

//*** Binning Parameters ***
`MPRnb( LMIN      , 0.0        , "m"                             , "Minimum length for the model ")
`MPRnb( LMAX      , 1.0        , "m"                             , "Maximum length for the model ")
`MPRnb( WMIN      , 0.0        , "m"                             , "Minimum width for the model ")
`MPRnb( WMAX      , 1.0        , "m"                             , "Maximum width for the model ")
`MPRnb( LBINN     , 1.0        , "-"                             , "L modulation coefficient for binning ")
`MPRnb( WBINN     , 1.0        , "-"                             , "W modulation coefficient for binning ")
`MPRnb( LVMAX     , 0.0        , "-"                             , "Length dependence of vmax ")
`MPRnb( LBGTMP1   , 0.0        , "-"                             , "Length dependence of bgtmp1 ")
`MPRnb( LBGTMP2   , 0.0        , "-"                             , "Length dependence of bgtmp2 ")
`MPRnb( LEG0      , 0.0        , "-"                             , "Length dependence of eg0 ")
`MPRnb( LVFBOVER  , 0.0        , "-"                             , "Length dependence of vfbover ")
`MPRnb( LNOVER    , 0.0        , "-"                             , "Length dependence of nover ")
`MPRnb( LNOVERS   , 0.0        , "-"                             , "Length dependence of nover on source side ")
`MPRnb( LWL2      , 0.0        , "-"                             , "Length dependence of wl2 ")
`MPRnb( LVFBC     , 0.0        , "-"                             , "Length dependence of vfbc ")
`MPRnb( LNSUBC    , 0.0        , "-"                             , "Length dependence of nsubc ")
`MPRnb( LNSUBP    , 0.0        , "-"                             , "Length dependence of nsubp ")
`MPRnb( LSCP1     , 0.0        , "-"                             , "Length dependence of scp1 ")
`MPRnb( LSCP2     , 0.0        , "-"                             , "Length dependence of scp2 ")
`MPRnb( LSCP3     , 0.0        , "-"                             , "Length dependence of scp3 ")
`MPRnb( LSC1      , 0.0        , "-"                             , "Length dependence of sc1 ")
`MPRnb( LSC2      , 0.0        , "-"                             , "Length dependence of sc2 ")
`MPRnb( LSC3      , 0.0        , "-"                             , "Length dependence of sc3 ")
`MPRnb( LPGD1     , 0.0        , "-"                             , "Length dependence of pgd1 ")
`MPRnb( LNDEP     , 0.0        , "-"                             , "Length dependence of ndep ")
`MPRnb( LNINV     , 0.0        , "-"                             , "Length dependence of ninv ")
`MPRnb( LMUECB0   , 0.0        , "-"                             , "Length dependence of muecb0 ")
`MPRnb( LMUECB1   , 0.0        , "-"                             , "Length dependence of muecb1 ")
`MPRnb( LMUEPH1   , 0.0        , "-"                             , "Length dependence of mueph1 ")
`MPRnb( LVTMP     , 0.0        , "-"                             , "Length dependence of vtmp ")
`MPRnb( LWVTH0    , 0.0        , "-"                             , "Length dependence of wvth0 ")
`MPRnb( LMUESR1   , 0.0        , "-"                             , "Length dependence of muesr1 ")
`MPRnb( LMUETMP   , 0.0        , "-"                             , "Length dependence of muetmp ")

`MPRnb( LSUB1     , 0.0        , "-"                             , "Length dependence of sub1 ")
`MPRnb( LSUB2     , 0.0        , "-"                             , "Length dependence of sub2 ")
`MPRnb( LSVDS     , 0.0        , "-"                             , "Length dependence of svds ")
`MPRnb( LSVBS     , 0.0        , "-"                             , "Length dependence of svbs ")
`MPRnb( LSVGS     , 0.0        , "-"                             , "Length dependence of svgs ")
`MPRnb( LSUB1SNP  , LSUB1      , "-"                             , "Length dependence of sub1 ")
`MPRnb( LSUB2SNP  , LSUB2      , "-"                             , "Length dependence of sub2 ")
`MPRnb( LSVDSSNP  , LSVDS      , "-"                             , "Length dependence of svds ")
//`MPRnb( LSVGSSNP  , LSVGS      , "-"                             , "Length dependence of svgssnp ")
//`MPRnb( LSVBSSNP  , LSVBS      , "-"                             , "Length dependence of svbssnp ")

`MPRnb( LFN1      , 0.0        , "-"                             , "Length dependence of fn1 ")
`MPRnb( LFN2      , 0.0        , "-"                             , "Length dependence of fn2 ")
`MPRnb( LFN3      , 0.0        , "-"                             , "Length dependence of fn3 ")
`MPRnb( LFVBS     , 0.0        , "-"                             , "Length dependence of fvbs ")
`MPRnb( LNSTI     , 0.0        , "-"                             , "Length dependence of nsti ")
`MPRnb( LWSTI     , 0.0        , "-"                             , "Length dependence of wsti ")
`MPRnb( LSCSTI1   , 0.0        , "-"                             , "Length dependence of scsti1 ")
`MPRnb( LSCSTI2   , 0.0        , "-"                             , "Length dependence of scsti2 ")
`MPRnb( LVTHSTI   , 0.0        , "-"                             , "Length dependence of vthsti ")
`MPRnb( LMUESTI1  , 0.0        , "-"                             , "Length dependence of muesti1 ")
`MPRnb( LMUESTI2  , 0.0        , "-"                             , "Length dependence of muesti2 ")
`MPRnb( LMUESTI3  , 0.0        , "-"                             , "Length dependence of muesti3 ")
`MPRnb( LNSUBPSTI1, 0.0        , "-"                             , "Length dependence of nsubpsti1 ")
`MPRnb( LNSUBPSTI2, 0.0        , "-"                             , "Length dependence of nsubpsti2 ")
`MPRnb( LNSUBPSTI3, 0.0        , "-"                             , "Length dependence of nsubpsti3 ")
`MPRnb( LCGSO     , 0.0        , "-"                             , "Length dependence of cgso ")
`MPRnb( LCGDO     , 0.0        , "-"                             , "Length dependence of cgdo ")
`MPRnb( LCLM1     , 0.0        , "-"                             , "Length dependence of clm1 ")
`MPRnb( LCLM2     , 0.0        , "-"                             , "Length dependence of clm2 ")
`MPRnb( LCLM3     , 0.0        , "-"                             , "Length dependence of clm3 ")
`MPRnb( LWFC      , 0.0        , "-"                             , "Length dependence of wfc ")
`MPRnb( LGIDL1    , 0.0        , "-"                             , "Length dependence of gidl1 ")
`MPRnb( LGIDL2    , 0.0        , "-"                             , "Length dependence of gidl2 ")
`MPRnb( LGLEAK1   , 0.0        , "-"                             , "Length dependence of gleak1 ")
`MPRnb( LGLEAK2   , 0.0        , "-"                             , "Length dependence of gleak2 ")
`MPRnb( LGLEAK3   , 0.0        , "-"                             , "Length dependence of gleak3 ")
`MPRnb( LGLEAK6   , 0.0        , "-"                             , "Length dependence of gleak6 ")
`MPRnb( LGLKSD1   , 0.0        , "-"                             , "Length dependence of glksd1 ")
`MPRnb( LGLKSD2   , 0.0        , "-"                             , "Length dependence of glksd2 ")
`MPRnb( LGLKB1    , 0.0        , "-"                             , "Length dependence of glkb1 ")
`MPRnb( LGLKB2    , 0.0        , "-"                             , "Length dependence of glkb2 ")
`MPRnb( LNFTRP    , 0.0        , "-"                             , "Length dependence of nftrp ")
`MPRnb( LNFALP    , 0.0        , "-"                             , "Length dependence of nfalp ")
`MPRnb( LIBPC1    , 0.0        , "-"                             , "Length dependence of ibpc1 ")
`MPRnb( LIBPC2    , 0.0        , "-"                             , "Length dependence of ibpc2 ")
`MPRnb( LCGBO     , 0.0        , "-"                             , "Length dependence of cgbo ")
`MPRnb( LCVDSOVER , 0.0        , "-"                             , "Length dependence of cvdsover ")
`MPRnb( LFALPH    , 0.0        , "-"                             , "Length dependence of falph ")
`MPRnb( LNPEXT    , 0.0        , "-"                             , "Length dependence of npext ")
`MPRnb( LPOWRAT   , 0.0        , "-"                             , "Length dependence of powrat ")
`MPRnb( LRD       , 0.0        , "-"                             , "Length dependence of rd ")        //HV1
`MPRnb( LRD22     , 0.0        , "-"                             , "Length dependence of rd22 ")      //HV1
`MPRnb( LRD23     , 0.0        , "-"                             , "Length dependence of rd23 ")      //HV1
`MPRnb( LRD24     , 0.0        , "-"                             , "Length dependence of rd24 ")      //HV1
`MPRnb( LRDICT1   , 0.0        , "-"                             , "Length dependence of rdict1 ")    //HV1
`MPRnb( LRDOV13   , 0.0        , "-"                             , "Length dependence of rdov13 ")    //HV1
`MPRnb( LRDSLP1   , 0.0        , "-"                             , "Length dependence of rdslp1 ")    //HV1
`MPRnb( LRDVB     , 0.0        , "-"                             , "Length dependence of rdvb ")      //HV1
`MPRnb( LRDVD     , 0.0        , "-"                             , "Length dependence of rdvd ")      //HV1
`MPRnb( LRDVG11   , 0.0        , "-"                             , "Length dependence of rdvg11 ")    //HV1
`MPRnb( LRS       , 0.0        , "-"                             , "Length dependence of rs ")        //HV1
`MPRnb( LRTH0     , 0.0        , "-"                             , "Length dependence of rth0 ")
`MPRnb( LVOVER    , 0.0        , "-"                             , "Length dependence of vover ")
`MPRnb( WVMAX     , 0.0        , "-"                             , "Width dependence of vmax ")
`MPRnb( WBGTMP1   , 0.0        , "-"                             , "Width dependence of bgtmp1 ")
`MPRnb( WBGTMP2   , 0.0        , "-"                             , "Width dependence of bgtmp2 ")
`MPRnb( WEG0      , 0.0        , "-"                             , "Width dependence of eg0 ")
`MPRnb( WVFBOVER  , 0.0        , "-"                             , "Width dependence of vfbover ")
`MPRnb( WNOVER    , 0.0        , "-"                             , "Width dependence of nover ")
`MPRnb( WNOVERS   , 0.0        , "-"                             , "Width dependence of novers on source side ")
`MPRnb( WWL2      , 0.0        , "-"                             , "Width dependence of wl2 ")
`MPRnb( WVFBC     , 0.0        , "-"                             , "Width dependence of vfbc ")
`MPRnb( WNSUBC    , 0.0        , "-"                             , "Width dependence of nsubc ")
`MPRnb( WNSUBP    , 0.0        , "-"                             , "Width dependence of nsubp ")
`MPRnb( WSCP1     , 0.0        , "-"                             , "Width dependence of scp1 ")
`MPRnb( WSCP2     , 0.0        , "-"                             , "Width dependence of scp2 ")
`MPRnb( WSCP3     , 0.0        , "-"                             , "Width dependence of scp3 ")
`MPRnb( WSC1      , 0.0        , "-"                             , "Width dependence of sc1 ")
`MPRnb( WSC2      , 0.0        , "-"                             , "Width dependence of sc2 ")
`MPRnb( WSC3      , 0.0        , "-"                             , "Width dependence of sc3 ")
`MPRnb( WPGD1     , 0.0        , "-"                             , "Width dependence of pgd1 ")
`MPRnb( WNDEP     , 0.0        , "-"                             , "Width dependence of ndep ")
`MPRnb( WNINV     , 0.0        , "-"                             , "Width dependence of ninv ")
`MPRnb( WMUECB0   , 0.0        , "-"                             , "Width dependence of muecb0 ")
`MPRnb( WMUECB1   , 0.0        , "-"                             , "Width dependence of muecb1 ")
`MPRnb( WMUEPH1   , 0.0        , "-"                             , "Width dependence of mueph1 ")
`MPRnb( WVTMP     , 0.0        , "-"                             , "Width dependence of vtmp ")
`MPRnb( WWVTH0    , 0.0        , "-"                             , "Width dependence of wvth0 ")
`MPRnb( WMUESR1   , 0.0        , "-"                             , "Width dependence of muesr1 ")
`MPRnb( WMUETMP   , 0.0        , "-"                             , "Width dependence of muetmp ")
`MPRnb( WSUB1     , 0.0        , "-"                             , "Width dependence of sub1 ")
`MPRnb( WSUB2     , 0.0        , "-"                             , "Width dependence of sub2 ")
`MPRnb( WSVDS     , 0.0        , "-"                             , "Width dependence of svds ")
`MPRnb( WSVBS     , 0.0        , "-"                             , "Width dependence of svbs ")
`MPRnb( WSVGS     , 0.0        , "-"                             , "Width dependence of svgs ")
`MPRnb( WSUB1SNP  , WSUB1      , "-"                             , "Width dependence of sub1 ")
`MPRnb( WSUB2SNP  , WSUB2      , "-"                             , "Width dependence of sub2 ")
`MPRnb( WSVDSSNP  , WSVDS      , "-"                             , "Width dependence of svds ")
//`MPRnb( WSVGSSNP  , WSVGS      , "-"                             , "Width dependence of svgssnp ")
//`MPRnb( WSVBSSNP  , WSVBS      , "-"                             , "Width dependence of svbssnp ")
`MPRnb( WFN1      , 0.0        , "-"                             , "Width dependence of fn1 ")
`MPRnb( WFN2      , 0.0        , "-"                             , "Width dependence of fn2 ")
`MPRnb( WFN3      , 0.0        , "-"                             , "Width dependence of fn3 ")
`MPRnb( WFVBS     , 0.0        , "-"                             , "Width dependence of fvbs ")
`MPRnb( WNSTI     , 0.0        , "-"                             , "Width dependence of nsti ")
`MPRnb( WWSTI     , 0.0        , "-"                             , "Width dependence of wsti ")
`MPRnb( WSCSTI1   , 0.0        , "-"                             , "Width dependence of scsti1 ")
`MPRnb( WSCSTI2   , 0.0        , "-"                             , "Width dependence of scsti2 ")
`MPRnb( WVTHSTI   , 0.0        , "-"                             , "Width dependence of vthsti ")
`MPRnb( WMUESTI1  , 0.0        , "-"                             , "Width dependence of muesti1 ")
`MPRnb( WMUESTI2  , 0.0        , "-"                             , "Width dependence of muesti2 ")
`MPRnb( WMUESTI3  , 0.0        , "-"                             , "Width dependence of muesti3 ")
`MPRnb( WNSUBPSTI1, 0.0        , "-"                             , "Width dependence of nsubpsti1 ")
`MPRnb( WNSUBPSTI2, 0.0        , "-"                             , "Width dependence of nsubpsti2 ")
`MPRnb( WNSUBPSTI3, 0.0        , "-"                             , "Width dependence of nsubpsti3 ")
`MPRnb( WCGSO     , 0.0        , "-"                             , "Width dependence of cgso ")
`MPRnb( WCGDO     , 0.0        , "-"                             , "Width dependence of cgdo ")
`MPRnb( WCLM1     , 0.0        , "-"                             , "Width dependence of clm1 ")
`MPRnb( WCLM2     , 0.0        , "-"                             , "Width dependence of clm2 ")
`MPRnb( WCLM3     , 0.0        , "-"                             , "Width dependence of clm3 ")
`MPRnb( WWFC      , 0.0        , "-"                             , "Width dependence of wfc ")
`MPRnb( WGIDL1    , 0.0        , "-"                             , "Width dependence of gidl1 ")
`MPRnb( WGIDL2    , 0.0        , "-"                             , "Width dependence of gidl2 ")
`MPRnb( WGLEAK1   , 0.0        , "-"                             , "Width dependence of gleak1 ")
`MPRnb( WGLEAK2   , 0.0        , "-"                             , "Width dependence of gleak2 ")
`MPRnb( WGLEAK3   , 0.0        , "-"                             , "Width dependence of gleak3 ")
`MPRnb( WGLEAK6   , 0.0        , "-"                             , "Width dependence of gleak6 ")
`MPRnb( WGLKSD1   , 0.0        , "-"                             , "Width dependence of glksd1 ")
`MPRnb( WGLKSD2   , 0.0        , "-"                             , "Width dependence of glksd2 ")
`MPRnb( WGLKB1    , 0.0        , "-"                             , "Width dependence of glkb1 ")
`MPRnb( WGLKB2    , 0.0        , "-"                             , "Width dependence of glkb2 ")
`MPRnb( WNFTRP    , 0.0        , "-"                             , "Width dependence of nftrp ")
`MPRnb( WNFALP    , 0.0        , "-"                             , "Width dependence of nfalp ")
`MPRnb( WIBPC1    , 0.0        , "-"                             , "Width dependence of ibpc1 ")
`MPRnb( WIBPC2    , 0.0        , "-"                             , "Width dependence of ibpc2 ")
`MPRnb( WCGBO     , 0.0        , "-"                             , "Width dependence of cgbo ")
`MPRnb( WCVDSOVER , 0.0        , "-"                             , "Width dependence of cvdsover ")
`MPRnb( WFALPH    , 0.0        , "-"                             , "Width dependence of falph ")
`MPRnb( WNPEXT    , 0.0        , "-"                             , "Width dependence of npext ")
`MPRnb( WPOWRAT   , 0.0        , "-"                             , "Width dependence of powrat ")
`MPRnb( WRD       , 0.0        , "-"                             , "Width dependence of rd ")         //HV1
`MPRnb( WRD22     , 0.0        , "-"                             , "Width dependence of rd22 ")         //HV1
`MPRnb( WRD23     , 0.0        , "-"                             , "Width dependence of rd23 ")         //HV1
`MPRnb( WRD24     , 0.0        , "-"                             , "Width dependence of rd24 ")         //HV1
`MPRnb( WRDICT1   , 0.0        , "-"                             , "Width dependence of rdict1 ")     //HV1
`MPRnb( WRDOV13   , 0.0        , "-"                             , "Width dependence of rdov13 ")     //HV1
`MPRnb( WRDSLP1   , 0.0        , "-"                             , "Width dependence of rdslp1 ")     //HV1
`MPRnb( WRDVB     , 0.0        , "-"                             , "Width dependence of rdvb ")         //HV1
`MPRnb( WRDVD     , 0.0        , "-"                             , "Width dependence of rdvd ")         //HV1
`MPRnb( WRDVG11   , 0.0        , "-"                             , "Width dependence of rdvg11 ")     //HV1
`MPRnb( WRS       , 0.0        , "-"                             , "Width dependence of rs ")         //HV1
`MPRnb( WRTH0     , 0.0        , "-"                             , "Width dependence of rth0 ")
`MPRnb( WVOVER    , 0.0        , "-"                             , "Width dependence of vover ")
`MPRnb( PVMAX     , 0.0        , "-"                             , "Cross-term dependence of vmax ")
`MPRnb( PBGTMP1   , 0.0        , "-"                             , "Cross-term dependence of bgtmp1 ")
`MPRnb( PBGTMP2   , 0.0        , "-"                             , "Cross-term dependence of bgtmp2 ")
`MPRnb( PEG0      , 0.0        , "-"                             , "Cross-term dependence of eg0 ")
`MPRnb( PVFBOVER  , 0.0        , "-"                             , "Cross-term dependence of vfbover ")
`MPRnb( PNOVER    , 0.0        , "-"                             , "Cross-term dependence of nover ")
`MPRnb( PNOVERS   , 0.0        , "-"                             , "Cross-term dependence of nover on source side ")
`MPRnb( PWL2      , 0.0        , "-"                             , "Cross-term dependence of wl2 ")
`MPRnb( PVFBC     , 0.0        , "-"                             , "Cross-term dependence of vfbc ")
`MPRnb( PNSUBC    , 0.0        , "-"                             , "Cross-term dependence of nsubc ")
`MPRnb( PNSUBP    , 0.0        , "-"                             , "Cross-term dependence of nsubp ")
`MPRnb( PSCP1     , 0.0        , "-"                             , "Cross-term dependence of scp1 ")
`MPRnb( PSCP2     , 0.0        , "-"                             , "Cross-term dependence of scp2 ")
`MPRnb( PSCP3     , 0.0        , "-"                             , "Cross-term dependence of scp3 ")
`MPRnb( PSC1      , 0.0        , "-"                             , "Cross-term dependence of sc1 ")
`MPRnb( PSC2      , 0.0        , "-"                             , "Cross-term dependence of sc2 ")
`MPRnb( PSC3      , 0.0        , "-"                             , "Cross-term dependence of sc3 ")
`MPRnb( PPGD1     , 0.0        , "-"                             , "Cross-term dependence of pgd1 ")
`MPRnb( PNDEP     , 0.0        , "-"                             , "Cross-term dependence of ndep ")
`MPRnb( PNINV     , 0.0        , "-"                             , "Cross-term dependence of ninv ")
`MPRnb( PMUECB0   , 0.0        , "-"                             , "Cross-term dependence of muecb0 ")
`MPRnb( PMUECB1   , 0.0        , "-"                             , "Cross-term dependence of muecb1 ")
`MPRnb( PMUEPH1   , 0.0        , "-"                             , "Cross-term dependence of mueph1 ")
`MPRnb( PVTMP     , 0.0        , "-"                             , "Cross-term dependence of vtmp ")
`MPRnb( PWVTH0    , 0.0        , "-"                             , "Cross-term dependence of wvth0 ")
`MPRnb( PMUESR1   , 0.0        , "-"                             , "Cross-term dependence of muesr1 ")
`MPRnb( PMUETMP   , 0.0        , "-"                             , "Cross-term dependence of muetmp ")
`MPRnb( PSUB1     , 0.0        , "-"                             , "Cross-term dependence of sub1 ")
`MPRnb( PSUB2     , 0.0        , "-"                             , "Cross-term dependence of sub2 ")
`MPRnb( PSVDS     , 0.0        , "-"                             , "Cross-term dependence of svds ")
`MPRnb( PSVBS     , 0.0        , "-"                             , "Cross-term dependence of svbs ")
`MPRnb( PSVGS     , 0.0        , "-"                             , "Cross-term dependence of svgs ")
`MPRnb( PSUB1SNP  , PSUB1      , "-"                             , "Cross-term dependence of sub1 ")
`MPRnb( PSUB2SNP  , PSUB2      , "-"                             , "Cross-term dependence of sub2 ")
`MPRnb( PSVDSSNP  , PSVDS      , "-"                             , "Cross-term dependence of svds ")
//`MPRnb( PSVGSSNP  , PSVGS      , "-"                             , "Cross-term dependence of svgssnp ")
//`MPRnb( PSVBSSNP  , PSVBS      , "-"                             , "Cross-term dependence of svbssnp ")
`MPRnb( PFN1      , 0.0        , "-"                             , "Cross-term dependence of fn1 ")
`MPRnb( PFN2      , 0.0        , "-"                             , "Cross-term dependence of fn2 ")
`MPRnb( PFN3      , 0.0        , "-"                             , "Cross-term dependence of fn3 ")
`MPRnb( PFVBS     , 0.0        , "-"                             , "Cross-term dependence of fvbs ")
`MPRnb( PNSTI     , 0.0        , "-"                             , "Cross-term dependence of nsti ")
`MPRnb( PWSTI     , 0.0        , "-"                             , "Cross-term dependence of wsti ")
`MPRnb( PSCSTI1   , 0.0        , "-"                             , "Cross-term dependence of scsti1 ")
`MPRnb( PSCSTI2   , 0.0        , "-"                             , "Cross-term dependence of scsti2 ")
`MPRnb( PVTHSTI   , 0.0        , "-"                             , "Cross-term dependence of vthsti ")
`MPRnb( PMUESTI1  , 0.0        , "-"                             , "Cross-term dependence of muesti1 ")
`MPRnb( PMUESTI2  , 0.0        , "-"                             , "Cross-term dependence of muesti2 ")
`MPRnb( PMUESTI3  , 0.0        , "-"                             , "Cross-term dependence of muesti3 ")
`MPRnb( PNSUBPSTI1, 0.0        , "-"                             , "Cross-term dependence of nsubpsti1 ")
`MPRnb( PNSUBPSTI2, 0.0        , "-"                             , "Cross-term dependence of nsubpsti2 ")
`MPRnb( PNSUBPSTI3, 0.0        , "-"                             , "Cross-term dependence of nsubpsti3 ")
`MPRnb( PCGSO     , 0.0        , "-"                             , "Cross-term dependence of cgso ")
`MPRnb( PCGDO     , 0.0        , "-"                             , "Cross-term dependence of cgdo ")
`MPRnb( PCLM1     , 0.0        , "-"                             , "Cross-term dependence of clm1 ")
`MPRnb( PCLM2     , 0.0        , "-"                             , "Cross-term dependence of clm2 ")
`MPRnb( PCLM3     , 0.0        , "-"                             , "Cross-term dependence of clm3 ")
`MPRnb( PWFC      , 0.0        , "-"                             , "Cross-term dependence of wfc ")
`MPRnb( PGIDL1    , 0.0        , "-"                             , "Cross-term dependence of gidl1 ")
`MPRnb( PGIDL2    , 0.0        , "-"                             , "Cross-term dependence of gidl2 ")
`MPRnb( PGLEAK1   , 0.0        , "-"                             , "Cross-term dependence of gleak1 ")
`MPRnb( PGLEAK2   , 0.0        , "-"                             , "Cross-term dependence of gleak2 ")
`MPRnb( PGLEAK3   , 0.0        , "-"                             , "Cross-term dependence of gleak3 ")
`MPRnb( PGLEAK6   , 0.0        , "-"                             , "Cross-term dependence of gleak6 ")
`MPRnb( PGLKSD1   , 0.0        , "-"                             , "Cross-term dependence of glksd1 ")
`MPRnb( PGLKSD2   , 0.0        , "-"                             , "Cross-term dependence of glksd2 ")
`MPRnb( PGLKB1    , 0.0        , "-"                             , "Cross-term dependence of glkb1 ")
`MPRnb( PGLKB2    , 0.0        , "-"                             , "Cross-term dependence of glkb2 ")
`MPRnb( PNFTRP    , 0.0        , "-"                             , "Cross-term dependence of nftrp ")
`MPRnb( PNFALP    , 0.0        , "-"                             , "Cross-term dependence of nfalp ")
`MPRnb( PIBPC1    , 0.0        , "-"                             , "Cross-term dependence of ibpc1 ")
`MPRnb( PIBPC2    , 0.0        , "-"                             , "Cross-term dependence of ibpc2 ")
`MPRnb( PCGBO     , 0.0        , "-"                             , "Cross-term dependence of cgbo ")
`MPRnb( PCVDSOVER , 0.0        , "-"                             , "Cross-term dependence of cvdsover ")
`MPRnb( PFALPH    , 0.0        , "-"                             , "Cross-term dependence of falph ")
`MPRnb( PNPEXT    , 0.0        , "-"                             , "Cross-term dependence of npext ")
`MPRnb( PPOWRAT   , 0.0        , "-"                             , "Cross-term dependence of powrat ")
`MPRnb( PRD       , 0.0        , "-"                             , "Cross-term dependence of rd ")      //HV1
`MPRnb( PRD22     , 0.0        , "-"                             , "Cross-term dependence of rd22 ")      //HV1
`MPRnb( PRD23     , 0.0        , "-"                             , "Cross-term dependence of rd23 ")      //HV1
`MPRnb( PRD24     , 0.0        , "-"                             , "Cross-term dependence of rd24 ")      //HV1
`MPRnb( PRDICT1   , 0.0        , "-"                             , "Cross-term dependence of rdict1 ")    //HV1
`MPRnb( PRDOV13   , 0.0        , "-"                             , "Cross-term dependence of rdov13 ")    //HV1
`MPRnb( PRDSLP1   , 0.0        , "-"                             , "Cross-term dependence of rdslp1 ")    //HV1
`MPRnb( PRDVB     , 0.0        , "-"                             , "Cross-term dependence of rdvb ")      //HV1
`MPRnb( PRDVD     , 0.0        , "-"                             , "Cross-term dependence of rdvd ")      //HV1
`MPRnb( PRDVG11   , 0.0        , "-"                             , "Cross-term dependence of rdvg11 ")    //HV1
`MPRnb( PRS       , 0.0        , "-"                             , "Cross-term dependence of rs ")      //HV1
`MPRnb( PRTH0     , 0.0        , "-"                             , "Cross-term dependence of rth0 ")
`MPRnb( PVOVER    , 0.0        , "-"                             , "Cross-term dependence of vover ")

`ifdef COEXTDIO
    /* for Junction Diode Model */
`else
    `MPRnb( LJS0      , 0.0        , "-"                             , "Length dependence of js0 ")
    `MPRnb( LJS0SW    , 0.0        , "-"                             , "Length dependence of js0sw ")
    `MPRnb( LNJ       , 0.0        , "-"                             , "Length dependence of nj ")
    `MPRnb( LCISBK    , 0.0        , "-"                             , "Length dependence of cisbk ")
    `MPRnb( LVDIFFJ   , 0.0        , "-"                             , "Length dependence of vdiffj ")
    `MPRnb( LJS0D     , LJS0       , "-"                             , "Length dependence of js0d ")
    `MPRnb( LJS0SWD   , LJS0SW     , "-"                             , "Length dependence of js0swd ")
    `MPRnb( LNJD      , LNJ        , "-"                             , "Length dependence of njd ")
    `MPRnb( LCISBKD   , LCISBK     , "-"                             , "Length dependence of cisbkd ")
    `MPRnb( LVDIFFJD  , LVDIFFJ    , "-"                             , "Length dependence of vdiffjd ")
    `MPRnb( LJS0S     , LJS0D      , "-"                             , "Length dependence of js0s ")
    `MPRnb( LJS0SWS   , LJS0SWD    , "-"                             , "Length dependence of js0sws ")
    `MPRnb( LNJS      , LNJD       , "-"                             , "Length dependence of njs ")
    `MPRnb( LCISBKS   , LCISBKD    , "-"                             , "Length dependence of cisbks ")
    `MPRnb( LVDIFFJS  , LVDIFFJD   , "-"                             , "Length dependence of vdiffjs ")
    `MPRnb( WJS0      , 0.0        , "-"                             , "Width dependence of js0 ")
    `MPRnb( WJS0SW    , 0.0        , "-"                             , "Width dependence of js0sw ")
    `MPRnb( WNJ       , 0.0        , "-"                             , "Width dependence of nj ")
    `MPRnb( WCISBK    , 0.0        , "-"                             , "Width dependence of cisbk ")
    `MPRnb( WVDIFFJ   , 0.0        , "-"                             , "Width dependence of vdiffj ")
    `MPRnb( WJS0D     , WJS0       , "-"                             , "Wength dependence of js0d ")
    `MPRnb( WJS0SWD   , WJS0SW     , "-"                             , "Wength dependence of js0swd ")
    `MPRnb( WNJD      , WNJ        , "-"                             , "Wength dependence of njd ")
    `MPRnb( WCISBKD   , WCISBK     , "-"                             , "Wength dependence of cisbkd ")
    `MPRnb( WVDIFFJD  , WVDIFFJ    , "-"                             , "Wength dependence of vdiffjd ")
    `MPRnb( WJS0S     , WJS0D      , "-"                             , "Wength dependence of js0s ")
    `MPRnb( WJS0SWS   , WJS0SWD    , "-"                             , "Wength dependence of js0sws ")
    `MPRnb( WNJS      , WNJD       , "-"                             , "Wength dependence of njs ")
    `MPRnb( WCISBKS   , WCISBKD    , "-"                             , "Wength dependence of cisbks ")
    `MPRnb( WVDIFFJS  , WVDIFFJD   , "-"                             , "Wength dependence of vdiffjs ")
    `MPRnb( PJS0      , 0.0        , "-"                             , "Cross-term dependence of js0 ")
    `MPRnb( PJS0SW    , 0.0        , "-"                             , "Cross-term dependence of js0sw ")
    `MPRnb( PNJ       , 0.0        , "-"                             , "Cross-term dependence of nj ")
    `MPRnb( PCISBK    , 0.0        , "-"                             , "Cross-term dependence of cisbk ")
    `MPRnb( PVDIFFJ   , 0.0        , "-"                             , "Cross-term dependence of vdiffj ")
    `MPRnb( PJS0D     , PJS0       , "-"                             , "Cross-term dependence of js0d ")
    `MPRnb( PJS0SWD   , PJS0SW     , "-"                             , "Cross-term dependence of js0swd ")
    `MPRnb( PNJD      , PNJ        , "-"                             , "Cross-term dependence of njd ")
    `MPRnb( PCISBKD   , PCISBK     , "-"                             , "Cross-term dependence of cisbkd ")
    `MPRnb( PVDIFFJD  , PVDIFFJ    , "-"                             , "Cross-term dependence of vdiffjd ")
    `MPRnb( PJS0S     , PJS0D      , "-"                             , "Cross-term dependence of js0s ")
    `MPRnb( PJS0SWS   , PJS0SWD    , "-"                             , "Cross-term dependence of js0sws ")
    `MPRnb( PNJS      , PNJD       , "-"                             , "Cross-term dependence of njs ")
    `MPRnb( PCISBKS   , PCISBKD    , "-"                             , "Cross-term dependence of cisbks ")
    `MPRnb( PVDIFFJS  , PVDIFFJD   , "-"                             , "Cross-term dependence of vdiffjs )")
`endif /* End of COEXTDIO */

// Output Physical Values in operating point analysis //
`OPM( idse      , "A"   , "Drain-Source current")
`OPM( IdsAcc    , "A"   , "Accumlation current of Depletion mode MOSFET")
`OPM( IdsRes    , "A"   , "Resistor current of Depletion mode MOSFET")
`OPM( IresLeak  , "A"   , "Leak current of Depletion mode MOSFET")
`OPD( Rdd       , "Ohm" , " Drift Resistance on Drain side")
`OPD( Rsd       , "Ohm" , " Drift Resistance on Source side")
`OPM( Isuba     , "A"   , "Substrate current")
`OPM( igidle    , "A"   , "Gate-Induced Drain Leakage current")
`OPM( igisle    , "A"   , "Gate-Induced Source Leakage current")
`OPM( igde      , "A"   , "Gate-Drain current")
`OPM( igse      , "A"   , "Gate-Source current")
`OPM( igbe      , "A"   , "Gate-Substrate current")
`OPM( gme       , "S"   , "Transconductance")
`OPM( gdse      , "S"   , "Channel conductance")
`OPM( gmbse     , "S"   , "Body effect(Back gate) transconductance")
`OPM( gmte      , "S"   , "Temperature transconductance")
`OPP( Von       , "V"   , "Threshold voltage")
`OPP( Vdsat     , "V"   , "Saturation voltage")
`OPM( Qg        , "C"   , "Gate charge")
`OPM( Qd        , "C"   , "Drain charge")
`OPM( Qb        , "C"   , "Bulk charge")
`OPM( cggbd     , "F"   , " g-g MOSFET capacitance")
`OPM( cgdbd     , "F"   , " g-d MOSFET capacitance")
`OPM( cgsbd     , "F"   , " g-s MOSFET capacitance")
`OPM( cgbbd     , "F"   , " g-b MOSFET capacitance")
`OPM( cbgbd     , "F"   , " b-g MOSFET capacitance")
`OPM( cbsbd     , "F"   , " b-s MOSFET capacitance")
`OPM( cbdbd     , "F"   , " b-d MOSFET capacitance")
`OPM( cbbbd     , "F"   , " b-b MOSFET capacitance")
`OPM( cdgbd     , "F"   , " d-g MOSFET capacitance")
`OPM( cddbd     , "F"   , " d-d MOSFET capacitance")
`OPM( cdsbd     , "F"   , " d-s MOSFET capacitance")
`OPM( cdbbd     , "F"   , " d-b MOSFET capacitance")
`OPM( csgbd     , "F"   , " s-g MOSFET capacitance")
`OPM( csdbd     , "F"   , " s-d MOSFET capacitance")
`OPM( cssbd     , "F"   , " s-s MOSFET capacitance")
`OPM( csbbd     , "F"   , " s-b MOSFET capacitance")
`OPM( cgdobd    , "F"   , " g-d MOSFET overlap capacitance")
`OPM( cgsobd    , "F"   , " g-s MOSFET overlap capacitance")
`OPM( cgbobd    , "F"   , " g-b MOSFET overlap capacitance")
`OPP( TK        , "K"   , "Actual device temperature")
`OPP( DTSH      , "K"   , "Temperature increase due to self-heating")
`OPP( RS_Ps0LD  , "V"    , "source side overlap region surface potential")
`OPP( RS_QbuLD  , "C/m^2", "source side overlap region arial charge")
`OPM( IdsPT     , "A"    , "Punchthrough current ")
`OPM( IdsPT0    , "A"    , "Punchthrough current (surface) ")
`OPM( IdsPT1    , "A"    , "Punchthrough current (deep) ")
`OPP( OP_mode   , "-"    , "Drain/Source flipping mode")
`OPP( OP_Vdsi   , "V"    , "Internal drain-source voltage")
`OPP( OP_Vbscl  , "V"    , "Clamped bulk-source voltage")
`OPP( OP_Vdseff , "V"    , "Vdseff for Psl calculation")
`OPP( OP_Pds_ini, "V"    , "Initial guess of Pds (=Psl-Ps0)")
`OPP( OP_lp_s0  , "-"    , "Ps0 iteration count")
`OPP( OP_lp_sl  , "-"    , "Psl iteration count")
`OPP( OP_lp_ld  , "-"    , "Ps0LD iteration count (Qovd component)")

`ifdef _AGING_
    `OPP( DVTBTI    , "C"   , "threshold voltage shift of trap")
    `OPP( NTRAP0    , "C"   , "trap charge on source side")
    `OPP( NTRAPL    , "C"   , "trap charge on drain side")
`endif

`ifdef COEXTDIO
    /* for Junction Diode Model */
`else
    `OPM( ibdb      , "A"   , " b-d Diode current")
    `OPM( ibsb      , "A"   , " b-s Diode current")
    `OPM( ibdbi     , "A"   , " b-dp Diode current")
    `OPM( ibsbi     , "A"   , " b-sp Diode current")
    `OPM( Gbd       , "S"   , " b-d Diode conductance")
    `OPM( Gbs       , "S"   , " b-s Diode conductance")
    `OPM( capbdb    , "F"   , " b-d Diode capacitance")
    `OPM( capbsb    , "F"   , " b-s Diode capacitance")
    `OPM( capbdbi   , "F"   , " b-dp Diode capacitance")
    `OPM( capbsbi   , "F"   , " b-sp Diode capacitance")
    `OPM( Qbd       , "C"   , " b-d Diode charge")
    `OPM( Qbs       , "C"   , " b-s Diode charge")
    `OPM( Qbdi      , "C"   , " b-dp Diode charge")
    `OPM( Qbsi      , "C"   , " b-sp Diode charge")
`endif /* End of COEXTDIO */

// End of Output Physical Values //

//--------------------------------------------------
// Local Variables
//
// Constants ----------------------- //
// initial guess *//
real Vbs_max ;
real Vbs_bnd, Gjmin ;
real Vbs_max_local, Vbs_bnd_local; // new protective boundary and threshold against forward (positive) Vbs
// Internal flags --------------------//
integer flg_rsrd ; //HV1
integer flg_rd, flg_rs; // node collaps
integer flg_pprv ;
integer flg_noqi ;
integer flg_conv ;
integer flg_qme ;
integer flg_nqs ;
integer flg_qy ;
// Important Variables in HiSIM -------//
// confined bias //
real Vbscl, VbscldVbs, Vgp, Vgs_fb ;
//   real Vbscl_org, VbscldVbs_org ;
// Ps0 : surface potential at the source side //
real Ps0, Ps0_ini, Ps0_iniA, Ps0_iniB ;
// Psl : surface potential at the drain side //
real Psl, Psl_lim, dPlim ;
// Pds :=Psl - Ps0 //
real Pds, Pds_ini, Pds_max ;
// iteration numbers of Ps0 and Psl equations. //
integer lp_s0, lp_sl ;
//integer lp_s0_LD ;
// Xi0 :=beta * ( Ps0 - Vbs ) - 1. //
real Xi0, Xi0p12, Xi0p32 ;
// Xil :=beta * ( Psl - Vbs ) - 1. //
real Xil, Xilp12, Xilp32 ;
// modified bias and potential for sym.//
real Vbsz, Vdsz, Vgsz, Vzadd, Ps0z, Pzadd ;
// IBPC //
real dVbsIBPC, dG3, dG4, dIdd, betaWL ;
// Chi :=beta * ( Ps{0/l} - Vbs ) //
real Chi ;
// Rho :=beta * ( Psl - Vds ) //
real Rho ;
// threshold voltage //
real Vth, Vth0 ;
// variation of threshold voltage //
real dVth, dVth0, dVthSC, Pb20b, dVthW ;

// Alpha and related parameters //
real Alpha, Achi, VgVt, Pslsat, VdsatS, Delta ;
// Q_B and capacitances //
real Qbu ;
// Q_I and capacitances //
real Qi, Qiu ;
// Q_D and capacitances //
// channel current //
real Ids, Ids0 , Idsorg ;
// STI //
real dVthSCSTI, Vgssti, costi0, costi1, costi3, costi4, costi5, costi6 ;
real costi7, Psasti, Psbsti, Psab, Psti, sq1sti, sq2sti, Qn0sti, Idssti ;
// constants //
real beta, beta_inv, beta2, Pb2, Pb20, Pb2c, Vfb, c_eox, Leff, Weff ;
real WeffLD_nf, Ldrift0, q_Nsub ;
// PART-1 //
// Accumulation zone //
real Psa ;
// CLM//
real Psdl, Lred, Lch, Wd, Aclm ;
// Pocket Implant //
real Vthp, dVthLP, bs12, Qbmm, dqb, Vdx, Vdx2, Pbsum, sqrt_Pbsum ;
// Poly-Depletion Effect //
real dPpg ;
// Quantum Effect //
real Toxe, dTox, Cox, Cox_inv, Tox0, Cox0, Cox0_inv, Vthq ;
// Igate , Igidl , Igisl //
real Psdlz, Egp12, Egp32, E1, Etun, Vdsp, Egidl, Egisl, Igate, Igs ;
real Igd, Igb, Igidl, Igisl, Vdb, Vsb ;
// connecting function //
real FD2, FMDVDS, cnst0, cnst1, cnstCoxi, fac1, fac1p2, fs01, fs01_dPs0 ;
real fs02, fs02_dPs0, fsl1, fsl1_dPsl, fsl2, fsl2_dPsl, cfs1, fb, fb_dChi ;
real fi, fi_dChi, exp_Chi, exp_Rho, exp_bVbs, exp_bVbsVds, exp_bPs0 ;
real Fs0, Fs0_dPs0, Fsl, Fsl_dPsl, dPs0, dPsl, Qn0, Qb0, Qbnm, DtPds ;
real Qinm, Qidn, Qdnm, Qddn, Quot, Qdrat, Idd, Idd1, Fdd, Eeff, Rns ;
real Mu, Muun, Ey, Em, Vmaxe, Eta, Eta1, Eta1p12, Eta1p32, Eta1p52, Zeta12 ;
real Zeta32, Zeta52, F00, F10, F30, F11, Vgs_min, Ps0_min, Acn, Acd ;
real Ac1, Ac2, Ac3, Ac4, Ac31, Ac41 ;
// PART-2 (Isub) //
real Isub, IsubLD, Psislsat, Psisubsat, Ifn, Eg12, Eg32 ;
real IsubIBPC; // 20180413 additive contribution to Isub
real wk_ii; // 20180413 stow impact ionization coeff for later use at IsubIBPC
// PART-3 (overlap) //
// const double cov_dlt=1.0e-1 ; //
// const double covvgmax=5.0 ; //
real cov_slp, cov_mag, Qgos, Qgod, Qgbo, Cgdoe, Cgsoe, Cgbo_loc, Qgso ;
real Qgdo ;
// fringe capacitance //
real Qfd, Cfd, Qfs, Cfs ;
// Cqy //
real Ec, Pslk, Qy ;
// PART-5 (NQS) //
real tau, taub , tauov ;
// PART-6 (noise) //
// 1/f //
real NFalpe, NFtrpe, Cite, Nflic ;
// thermal //
real Eyd, Mu_Ave, Nthrml, Mud_hoso ;
// induced gate noise ( Part 0/3 ) //
real kusai00, kusaidd, kusaiL, kusai00L ;
integer flg_ign ;
real sqrtkusaiL, kusai_ig, gds0_ign, gds0_h2, GAMMA, crl_f ;
real Nign0, MuModA, MuModB, correct_w1 ;
// usage of previously calculated values //
// temporary vars. & derivatives//
real TX, TY, T0, T1, T2, T3, T4, T5, T6, T7, T8, T9, T10, T11, T12 ;
integer flg_zone ;
// Vdseff //
real Vdseff, Vdsorg ;
// D/S Overlap Charges: Qovd/Qovs //
real Qovdext, Qovsext, Qovd, Qovs, QbuLD, QbdLD, QbsLD, QodAD ;
real QbdLDext, QbsLDext ;
real Qovd_ADD, QbdLD_ADD ;
real Qovs_ADD, QbsLD_ADD ;
// Vgsz for SCE and PGD //
real Vbsz2 ;
// Multiplication factor * number of gate fingers //
real Mfactor ;
//
// HiSIM-HV
//
// bias-dependent Rd , Rs //
real Rdrift, Rsdrift, Ra ;
real Vdse_eff, VdseModeNML, VdseModeRVS, Vbsegmt, Vdsegmt, Vgsegmt ;
real Vbserev, Vdserev, Vgserev, Ra_alpha, Ra_beta ;
// modified external biases for symmetry //
real Vdserevz, Vgserevz, Vbserevz ;
// Substrate Effect //
real Vsubsrev, Wdep , ddriftld , ddriftldc;
// temperature-dependent variables for SHE model //
real TTEMP, TTEMP0, Tdiff0, Tdiff0_2, Tdiff, Tdiff_2, Eg, Nin ;
// Qover 5/1 ckt-bias use //
real Vgbgmt, Vxbgmt, Vxbgmtcl ;
// for Clamping Vxbgmt //
real QsuLD, QiuLD ;
// IBPC //
real IdsIBPC ;
// Qover //
integer flg_ovzone ;
real VgpLD, Vgb_fb_LD, Ps0LD, cnst1over ;
integer flg_never_reach_vfbover ;
real Lover_func, Noverd, Nover_func, cnst0over_func ;
//real WTRE_lim,
real Wdep_func;
real Coxb0, Cox0_func ;
// Qover DD Model //
// real Ps0LD0 ;
real Ps0LD_Vxb, Chib, phi_b, phi_b_dPss, dphi_sb, c_sb, fb_dPss ;
integer lp_s0_max ;
// Break Down Model
real Ibreake;
real Ibreakhe , Ibreak, Ibreaks ; // revived 20161012
real HBdv , HBDCeff ;  //removed 20160414; revived 20161012
real iiFac; // 20160217
real wIbjt, Ibjte, Ibjt, Ibjts; // , Ibjte, IdsBJT, IdsBJTs; // 20160218, 20160414
integer lp_ld ;
real Ta, Tb, Tc, Td, Tv, Tu, Tp, Tq, VgpLD_shift, gammaChi, psi, Chi_A ;
real Chi_B, Chi_1 ;
// UC_*** Vars. for Device and Model Parameters
integer UC_CORSRD  ;  //HV1
integer UC_CORDRIFT ; //HV1
real UC_XPDV     , UC_XLDLD    , UC_SCP22    , UC_RDRCX    , UC_VMAX     ;
real UC_BGTMP1   , UC_BGTMP2   , UC_EG0      , UC_VFBOVER  , UC_NOVER    ;
real UC_NOVERS   , UC_WL2      , UC_VFBC     , UC_NSUBC    , UC_NSUBP    ;
real UC_SCP1     , UC_SCP2     , UC_SCP3     , UC_SC1      , UC_SC2      ;
real UC_SC3      , UC_PGD1     , UC_NDEP     , UC_NINV     , UC_MUECB0   ;
real UC_MUECB1   , UC_MUEPH1   , UC_VTMP     , UC_WVTH0    , UC_MUESR1   ;
real UC_MUETMP   , UC_SUB1     , UC_SUB2     , UC_SVDS     , UC_SVBS     ;
real UC_SVGS     ;
real UC_SUB1SNP  , UC_SUB2SNP  , UC_SVDSSNP  ; //, UC_SVGSSNP  , UC_SVBSSNP  ;
real UC_NJUNC ;
real UC_FN1      , UC_FN2      , UC_FN3      , UC_FVBS     ;
real UC_NSTI     , UC_WSTI     , UC_SCSTI1   , UC_SCSTI2   , UC_VTHSTI   ;
real UC_MUESTI1  , UC_MUESTI2  , UC_MUESTI3  , UC_NSUBPSTI1 , UC_NSUBPSTI2 ;
real UC_NSUBPSTI3 , UC_CGSO     , UC_CGDO     , UC_CLM1     , UC_CLM2     ;
real UC_CLM3     , UC_WFC      , UC_GIDL1    , UC_GIDL2    , UC_GLEAK1   ;
real UC_GLEAK2   , UC_GLEAK3   , UC_GLEAK6   , UC_GLKSD1   , UC_GLKSD2   ;
real UC_GLKB1    , UC_GLKB2    , UC_NFTRP    , UC_NFALP    , UC_IBPC1    ;
real UC_IBPC2    , UC_CGBO     , UC_CVDSOVER , UC_FALPH    , UC_NPEXT    ;
real UC_POWRAT   ;
real UC_RD       , UC_RD22     , UC_RD23     , UC_RD24     ;                //HV1
real UC_RDICT1   , UC_RDOV13   , UC_RDSLP1   , UC_RDVB     , UC_RDVD     ;  //HV1
real UC_RDVG11   , UC_RS       ;                                            //HV1
real UC_RTH0     , UC_VOVER    ;
real UC_TOXB     ; //not for unit change but for range reset
// MKS_*** Vars. for Device and Model Parameters
real MKS_NSUBSUB , MKS_LL      , MKS_WL      , MKS_SVGSL   , MKS_SVGSW   ;
real MKS_SVBSL   , MKS_SLGL    , MKS_SUB1L   , MKS_SLG     , MKS_SUB2L   ;
real MKS_SUBLD2  ;
real MKS_RDTEMP1 , MKS_RDTEMP2 , MKS_RDVDTEMP1 , MKS_RDVDTEMP2 ;            //HV1
real MKS_GLKSD3  , MKS_GLEAK4  , MKS_GLEAK5  , MKS_GLEAK7  , MKS_CIT     ;
real MKS_OVSLP   , MKS_DLY3    , MKS_CTH0    , MKS_RDRMUE  , MKS_RDRVMAX , MKS_RDRMUES, MKS_RDRVMAXS;
real MKS_NSUBCDFM;
real MKS_DLYOV    ;
// Vars. for hsmhvtemp.c
real mueph  , dL     , dLLD   , LG     , dW     , dWLD   , dWCV   , WG     ;
real WLG    , Lgate  , Wgate  , Nsubpp , Nsubps , Nsub   , Nsubb  , Lod_half ;
real Lod_half_ref , log_Tratio , Edri   , Vdri   , Mu0    , Cx     , Car    , Xov    ;
real Carr   , Vddpz  , Wdepl  , Wjunc0 , Wrdrdjunc , Wjunc  , Wjuncld ;
//eval_rdrifts.inc
real Ldrifte_s, Novers, Mu0_s, Vmaxe_s, Edri_s, Vdri_s;
real Mu_s, Carr_s, Xov_s, GD_s, Xmax_s;
//
integer flg_pgd ;
real egtnom , cecox  , msc    , clmmod , EF_MUEPH1 , EF_NSUBP;
real EF_NSUBC , NSUBCDFM_GIVEN , muesr  , ndep_o_esi , ninv_o_esi;
real ninvd0 , lgatesm , dVthsm , weff_ld , weff_cv , weff_nf;
real ninvd0cRES , ninvd0hRES ;
real weffcv_nf , qnsub_esi , qnsub_esi2 , ptovr0 , costi00 , nsti_p2;
real vmax0  , cnstpgd , grg    , Rd0;
real Rdtemp0 , Rdvdtemp0;  //HV1
real Rd23e  ;              //HV1
real Rs0    , Xmax   , kdep   , kjunc  ;
real Rdrvmaxle , Rdrmuele , RdrmueVbs , grbpb  , grbps  , grbpd  , DDLTe  ;
real vg2const , xvbs   , xgate  , xsub1  , xsub2  , UC_SUBLD1;
real vg2const_, xvbs_  , xgate_  , xsub1_ , xsub2_ ;
real cfrng  , cqyb0  , ptl0   , pt40   , gdl0   , rthtemp0;
real Tratio , sqrt_eg , betatnom , mphn0  , ptovr  , VMAXeff;
real Ninvde , powratio , wdpl   , wdplp  , cnst0over , cnst0overs;
real NinvdecRES , NinvdehRES ;
real Rde    , Rse    , Rdvde  , Rsvde  ; //HV1
real costi0_p2;
real drainConductance , sourceConductance , RD_Ps0LD , RD_QbuLD ;
real IdsIBPCe , qge     , qde     , qse     , qdp   ;
real qsp    , qgexte  , qdexte  , qsexte  , Xd     , isube  ;
real IsubLDe , noiflick , noithrml , noiigate , noicross , Rdde  ;
real Rsde  ;
real Carr1 , Carr2 ;
// Local Vars. for hsmhveval.c
integer m0     , mm     , i     ;
real x2     , xmax2  , xp     , xmp    , dnm    , vbd    , Vbsi    ;
real Vdsi    , vgd    , Vgsi    , deltemp , Vdsei   , Vgsei   , Vbsei   , Isubs  ;
real IsubLDs , IdsIBPCs , GD     , Gth    , Qs     , Qdext  , Qgext  , Qbext  ;
real Veffpower , P      , Qi_nqs , Qb_nqs , Iqi_nqs , Iqb_nqs , Qd_nqs , Qs_nqs ;
real Qg_nqs , Qbulk  , cgdb   , cggb   , cgsb   , cbdb   , cbgb   , cbsb   ;
real cddb   , cdgb   , cdsb   , KTNOM  , flg_qmetemp , RTH    , CTH    , CGSO_GIVEN ;
real CGDO_GIVEN;
real arg    , ggds   , ggdss  , Npexte , Lbin   , Wbin   , LWbin  , UC_GDLD ;
real mMod   , gminMod ,TMF0   , TMF1   , TMF2   , TMF3   , TMF4   , Ldrifte ;
real Rdrvmaxwe , RRDRMUE , RRDRVMAX , Rd_Xldld  , Vds    , Vgs    , Vbs    , Vdse   ;
real RRDRMUES, RRDRVMAXS; // 20160518 source resistance
real Vgse   , Vbse   , Vsubs  , Vddp   , Cqi    , Cqb    , Itemp  , gbbs   ;
real Vsps ; // 20160516 source resistance effects
real gbds   , gbgs   , whi_noise ;
real gbdsd  , gbdss  , qdov   , qgov   , qsov   ;
real cgdobe , cgsobe ;
real Ibd_nqs , Qbd_qs , Qbd_nqs ;
`ifdef COEXTDIO
    /* for External Diode Model */
`else
    real UC_JS0D     , UC_JS0SWD   , UC_NJD      , UC_CISBKD   , UC_VDIFFJD  ;
    real UC_JS0S     , UC_JS0SWS   , UC_NJS      , UC_CISBKS   , UC_VDIFFJS  ;
    real js     , jssw   , js2    , jssw2  , czbd   , czbdsw , czbdswg , czbs   ;
    real jsswg, jsswg2 ;
    real czbssw , czbsswg , sarg  ;
    real pzbd   , pzbdsw , pzbdswg , pzbs , pzbssw , pzbsswg ;
    real isbd   , vbdt   , exptempd , jd_nvtm_invd , jd_expcd;
    real isbs   , vbst   , exptemps , jd_nvtm_invs , jd_expcs;
    real vsbs   , vdbd   , vbs_jct , vbd_jct , Ibd    , Ibs    , Capbs , Capbd  ;
    real vbpsp  , vbpdp  , vbsi_jct, vbdi_jct, Ibdi   , Ibsi   , Capbsi, Capbdi ;
    real isbd_btm, isbd2_btm, isbd_sws, isbd2_sws, isbd_swg, isbd2_swg ;
    real isbs_btm, isbs2_btm, isbs_sws, isbs2_sws, isbs_swg, isbs2_swg ;
    real Ibd_btm, Ibs_btm, Ibd_sws, Ibs_sws, Ibd_swg, Ibs_swg ;
    real Qbd_btm, Qbs_btm, Qbd_sws, Qbs_sws, Qbd_swg, Qbs_swg ;
    real Capbd_btm, Capbs_btm, Capbd_sws, Capbs_sws, Capbd_swg, Capbs_swg ;

    //imported from DIODE_CMC_varlist2.include:
    //diode reverse recovery model
    // for unit conversion
    real NDI_i;
    real MUEN_i, MUEP_i;
    real NJL;
    // bias-dependent variables for the recovery model
    real Pn0, Nin_dio;
    real Dn, Dp, Da, La, tau_HL;
    real Vjunc_A, W_depA;
    real Q_n0, Q_nexA_nqs, Q_nexK_nqs, Qrr;
    //, Q_depA;
    real q_pexA, q_pexK, Q_qs_A, Q_qs_K, Q_nqs_A, Q_nqs_K;
    real Inqs0_A, Inqs0_K, q_pexA_nqs, q_pexK_nqs;
    real W_qs_A, W_nqs_A, IWnqs0_A, W_depA_nqs;
    real V_HA, V_HK;
    real nj_K;
    real exp_A, exp_K, p_nA, p_nK;
    real exp_A2, exp_K2;
    // fixed parameters
    real JUNCDLT; //Smoothness of depletion width around zero bias (minor) [V]
    //End of diode reverse recovery model

`endif
// Others
integer flg_brk1, flg_brk2 ;
integer end_of_part_1, start_of_loopl, start_of_mobility ;
integer mode , FATAL_flag ;
real ci, sid, sigrat, sigrat_s, sigrat_d ;

real UC_RDRBB , UC_SUBTMP , xsubtmp ;
real UC_RDRBB_s; // 20160518 source resistance

//* for depletion mode MOS *
real Vbipn, Pb2n, kjuncpn ;
integer UC_CODEP ;
real UC_NDEPM, UC_DEPTHN ;
real UC_DEPMUE0, UC_DEPMUEBACK0 ;
real UC_DEPMUE1, UC_DEPMUEBACK1 ;
real UC_DEPMUE2 , UC_DEPMUEPH1 ;
real UC_DEPLEAK, UC_DEPVMAX ;
real UC_DEPVDSEF1, UC_DEPVDSEF2 ;
real UC_DEPWLP ;
real depmphn0 ;
real Qiu_noi, Qi_noi ;

real Pdsz , Ws , C_W_LD , Ps0DEP ;
real Mu_acc , Mu_res ;
real Ids_acc , Ids_res , Ires_leak , Vds_res , W_res , Qn_res ;
real Vdssat_res;
//* depletion mos end */

/* new pt */
real dphi_vds , phim , WK_JNPT_A ;//, Qn0npt ;
//`define dbgpt
`ifdef dbgpt
    real Vbspt , Ps0pt , Ecpt , Vgppt , TYpt , wkpt , Wdeppt ;
`endif

`ifdef _AGING_
    // ** Aging model ***************//
`define pretime  1e-12
    integer fno;
    real pretime0 , ivbs , ivds , ivgs ;
    real TMF5, TMF6, TMF7, TMF8 ;
    real MKS_TRAPGC1 , MKS_TRAPGC2 , MKS_TRAPES1 , MKS_GC1MAX ;
    real MKS_TRAPGCLIM ;
    real MKS_TRAPGC0, delta, NtK30, y1, y2, y3, y4, y5, y6 ;
    real keT, NtK10, NtK20 , NtK40 ;
    real efn_ec ;
    real gc1 , e1 , Isub_trap , Ids_trap , abstime ;

    real nt0s , ntls ;
    real Nt0s_temp ;
    real dVth_bti , ts_bti , tcycle , Eox ;
    real ontime , Vgsonave , Vgpon ;
    real ftr0_qs, ftr0_qs_dPs0 ;
    real ftrl_qs, ftrl_qs_dPsl ;
    real exp_time , Nt_max0 , Nt_maxl ;
    real Ps0_prv , Vtraplx_prv ;
    real Qt0;

    real DVddp , Vdseeff , AVddp ;
`endif
// eval_loverLim (2.4.0)
real Vxb_lim ;

// limited exp function (lexp)
`define CEXP_THRES 80.0
`define CMAX_EXP 5.540622384e+34
`define CMIN_EXP 1.804851387e-35
analog function real lexp;
    input x;
    real x;
    begin
        if (x > `CEXP_THRES) begin
            lexp = `CMAX_EXP * ( 1.0 + (x) -`CEXP_THRES);
        end else if (x < -`CEXP_THRES) begin
            lexp = `CMIN_EXP;
        end else begin
            lexp = exp(x);
        end
    end
endfunction

//================ Start of executable code.=================//

analog begin

`ifdef _4_PORTS_CONNECTED_
        if ( COSUBNODE == 1 ) begin
            $error(" *** Fatal(HiSIM_HV:%M): COSUBNODE = 1 but terminal 'sub' is not connected.\n" );
            //$finish(0);
        end
`else
`ifdef _5_PORTS_CONNECTED_
            if ($port_connected(sub) == 0) begin // 4 nodes
                if ( COSUBNODE == 1 )  begin
                    $error(" *** Fatal(HiSIM_HV:%M): 'sub' is not connected but COSUBNODE = 1.\n" );
                    //$finish(0);
                end
            end
`else
            //   _6_PORTS_CONNECTED_
            if ($port_connected(temp) == 1) begin
                if ( COSUBNODE == 0 ) begin
                    $error(" *** Fatal(HiSIM_HV:%M): 6 nodes are connected but COSUBNODE = 0.\n" );
                    //$finish(0);
                end
            end
            else begin
                if ($port_connected(sub) == 0) begin // 4 nodes
                    if ( COSUBNODE == 1 )  begin
                        $error(" *** Fatal(HiSIM_HV:%M): 'sub' is not connected but COSUBNODE = 1.\n" );
                        //$finish(0);
                    end
                end
            end
`endif
        if (COSUBNODE == 0) begin
            V(sub,temp) <+ 0.0;
        end
`endif

    // Initial Settings
    NSUBCDFM_GIVEN = ($param_given(NSUBCDFM));
    CGDO_GIVEN = ($param_given(CGDO));
    CGSO_GIVEN = ($param_given(CGSO));

    Cgdoe      = 0.0;
    Cgsoe      = 0.0;
    Xd         = 0.0;
    Rdd        = 0.0;
    Rsd        = 0.0;
    flg_ign    = 0;
    flg_noqi   = 0;
    flg_rsrd   = 0;
    flg_zone   = 0;
    RD_Ps0LD   = 0.0;
    RD_QbuLD   = 0.0;
    Vbs_max    = 0.8e0;
    Vbs_bnd    = 0.4e0;
    flg_pprv   = 0;
    flg_conv   = 0;
    flg_qme    = 0;
    flg_nqs    = 0;
    FATAL_flag = 0;
    Vbscl      = 0.0;
    VbscldVbs = 0.0;
    Vgp        = 0.0;
    Vgs_fb     = 0.0;
    Ps0        = 0.0;
    Ps0_ini    = 0.0;
    Ps0_iniA   = 0.0;
    Ps0_iniB   = 0.0;
    Psl        = 0.0;
    Psl_lim    = 0.0;
    dPlim      = 0.0;
    Pds        = 0.0;
    Pds_ini    = 0.0;
    Pds_max    = 0.0;
    lp_s0      = 0;
    lp_sl      = 0;
    Xi0        = 0.0;
    Xi0p12     = 0.0;
    Xi0p32     = 0.0;
    Xil        = 0.0;
    Xilp12     = 0.0;
    Xilp32     = 0.0;
    Vbsz       = 0.0;
    Vdsz       = 0.0;
    Vgsz       = 0.0;
    Vzadd      = 0.0;
    Ps0z       = 0.0;
    Pzadd      = 0.0;
    dVbsIBPC   = 0.0;
    dG3        = 0.0;
    dG4        = 0.0;
    dIdd       = 0.0;
    betaWL     = 0.0;
    Chi        = 0.0;
    Chib       = 0.0;
    Rho        = 0.0;
    Vth        = 0.0;
    Vth0       = 0.0;
    dVth       = 0.0;
    dVth0      = 0.0;
    dVthSC     = 0.0;
    Pb20b      = 0.0;
    dVthW      = 0.0;
    Alpha      = 0.0;
    Achi       = 0.0;
    VgVt       = 0.0;
    Pslsat     = 0.0;
    Vdsat      = 0.0;
    VdsatS     = 0.0;
    Delta      = 0.0;
    Qb         = 0.0;
    Qbu        = 0.0;
    Qi         = 0.0;
    Qiu        = 0.0;
    Qd         = 0.0;
    Ids        = 0.0;
    Ids0       = 0.0;
    dVthSCSTI  = 0.0;
    Vgssti     = 0.0;
    costi0     = 0.0;
    costi1     = 0.0;
    costi3     = 0.0;
    costi4     = 0.0;
    costi5     = 0.0;
    costi6     = 0.0;
    costi7     = 0.0;
    Psasti     = 0.0;
    Psbsti     = 0.0;
    Psab       = 0.0;
    Psti       = 0.0;
    sq1sti     = 0.0;
    sq2sti     = 0.0;
    Qn0sti     = 0.0;
    Idssti     = 0.0;
    beta       = 0.0;
    beta_inv   = 0.0;
    beta2      = 0.0;
    Pb2        = 0.0;
    Pb20       = 0.0;
    Pb2c       = 0.0;
    Vfb        = 0.0;
    c_eox      = 0.0;
    Leff       = 0.0;
    Weff       = 0.0;
    WeffLD_nf  = 0.0;
    Ldrift0    = 0.0;
    q_Nsub     = 0.0;
    Psa        = 0.0;
    Psdl       = 0.0;
    Lred       = 0.0;
    Lch        = 0.0;
    Wd         = 0.0;
    Aclm       = 0.0;
    Vthp       = 0.0;
    dVthLP     = 0.0;
    bs12       = 0.0;
    Qbmm       = 0.0;
    dqb        = 0.0;
    Vdx        = 0.0;
    Vdx2       = 0.0;
    Pbsum      = 0.0;
    sqrt_Pbsum = 0.0;
    dPpg       = 0.0;
    dTox       = 0.0;
    Cox        = 0.0;
    Cox_inv    = 0.0;
    Tox0       = 0.0;
    Cox0       = 0.0;
    Coxb0      = 0.0;
    Cox0_inv   = 0.0;
    Vthq       = 0.0;
    Psdlz      = 0.0;
    Egp12      = 0.0;
    Egp32      = 0.0;
    E1         = 0.0;
    Etun       = 0.0;
    Vdsp       = 0.0;
    Egidl      = 0.0;
    Egisl      = 0.0;
    Igate      = 0.0;
    Igs        = 0.0;
    Igd        = 0.0;
    Igb        = 0.0;
    Igidl      = 0.0;
    Igisl      = 0.0;
    Vdb        = 0.0;
    Vsb        = 0.0;
    FD2        = 0.0;
    FMDVDS     = 0.0;
    cnst0      = 0.0;
    cnst1      = 0.0;
    cnstCoxi   = 0.0;
    fac1       = 0.0;
    fac1p2     = 0.0;
    fs01       = 0.0;
    fs01_dPs0  = 0.0;
    fs02       = 0.0;
    fs02_dPs0  = 0.0;
    fsl1       = 0.0;
    fsl1_dPsl  = 0.0;
    fsl2       = 0.0;
    fsl2_dPsl  = 0.0;
    cfs1       = 0.0;
    fb         = 0.0;
    fb_dChi    = 0.0;
    fi         = 0.0;
    fi_dChi    = 0.0;
    exp_Chi    = 0.0;
    exp_Rho    = 0.0;
    exp_bVbs   = 0.0;
    exp_bVbsVds = 0.0;
    exp_bPs0   = 0.0;
    Fs0        = 0.0;
    Fs0_dPs0   = 0.0;
    Fsl        = 0.0;
    Fsl_dPsl   = 0.0;
    dPs0       = 0.0;
    dPsl       = 0.0;
    Qn0        = 0.0;
    Qb0        = 0.0;
    Qbnm       = 0.0;
    DtPds      = 0.0;
    Qinm       = 0.0;
    Qidn       = 0.0;
    Qdnm       = 0.0;
    Qddn       = 0.0;
    Quot       = 0.0;
    Qdrat      = 0.5;
    Idd        = 0.0;
    Idd1       = 0.0;
    Fdd        = 0.0;
    Eeff       = 0.0;
    Rns        = 0.0;
    Mu         = 0.0;
    Muun       = 0.0;
    Ey         = 0.0;
    Em         = 0.0;
    Eta        = 0.0;
    Eta1       = 0.0;
    Eta1p12    = 0.0;
    Eta1p32    = 0.0;
    Eta1p52    = 0.0;
    Zeta12     = 0.0;
    Zeta32     = 0.0;
    Zeta52     = 0.0;
    F00        = 0.0;
    F10        = 0.0;
    F30        = 0.0;
    F11        = 0.0;
    Vgs_min    = 0.0;
    Ps0_min    = 0.0;
    Acn        = 0.0;
    Acd        = 0.0;
    Ac1        = 0.0;
    Ac2        = 0.0;
    Ac3        = 0.0;
    Ac4        = 0.0;
    Ac31       = 0.0;
    Ac41       = 0.0;
    Isub       = 0.0;
    IsubLD     = 0.0;
    Psislsat   = 0.0;
    Psisubsat  = 0.0;
    Ifn        = 0.0;
    Eg12       = 0.0;
    Eg32       = 0.0;
    cov_slp    = 0.0;
    cov_mag    = 0.0;
    Qgos       = 0.0;
    Qgod       = 0.0;
    Qgbo       = 0.0;
    Cgbo_loc   = 0.0;
    Qgso       = 0.0;
    Qgdo       = 0.0;
    Qfd        = 0.0;
    Cfd        = 0.0;
    Qfs        = 0.0;
    Cfs        = 0.0;
    Ec         = 0.0;
    Pslk       = 0.0;
    Qy         = 0.0;
    tau        = 0.0;
    taub       = 0.0;
    Nflic      = 0.0;
    Eyd        = 0.0;
    Mu_Ave     = 0.0;
    Nthrml     = 0.0;
    Mud_hoso   = 0.0;
    kusai00    = 0.0;
    kusaidd    = 0.0;
    kusaiL     = 0.0;
    kusai00L   = 0.0;
    sqrtkusaiL = 0.0;
    kusai_ig   = 0.0;
    gds0_ign   = 0.0;
    gds0_h2    = 0.0;
    GAMMA      = 0.0;
    crl_f      = 0.0;
    Nign0      = 0.0;
    MuModA     = 0.0;
    MuModB     = 0.0;
    correct_w1 = 0.0;
    TX         = 0.0;
    TY         = 0.0;
    T0         = 0.0;
    T1         = 0.0;
    T2         = 0.0;
    T3         = 0.0;
    T4         = 0.0;
    T5         = 0.0;
    T6         = 0.0;
    T7         = 0.0;
    T8         = 0.0;
    T9         = 0.0;
    T10        = 0.0;
    T11        = 0.0;
    T12        = 0.0;
    Vdseff     = 0.0;
    Vdsorg     = 0.0;
    Qovdext    = 0.0;
    Qovsext    = 0.0;
    Qovd       = 0.0;
    Qovs       = 0.0;
    QbuLD      = 0.0;
    QbdLD      = 0.0;
    QbsLD      = 0.0;
    QodAD      = 0.0;
    QbdLDext   = 0.0;
    QbsLDext   = 0.0;
    Vbsz2      = 0.0;
    Rdrift     = 0.0; //HV1
    Rsdrift    = 0.0; //HV1
    Ra         = 0.0; //HV1
    Vdse_eff   = 0.0; //HV1
    VdseModeNML = 0.0;//HV1
    VdseModeRVS = 0.0;//HV1
    Vbsegmt    = 0.0; //HV1
    Vdsegmt    = 0.0;
    Vgsegmt    = 0.0; //HV1
    Vbserev    = 0.0; //HV1
    Vdserev    = 0.0; //HV1
    Vgserev    = 0.0; //HV1
    Vdserevz   = 0.0;
    Vgserevz   = 0.0; //HV1
    Vbserevz   = 0.0; //HV1
    Vsubsrev   = 0.0;
    TTEMP      = 0.0;
    TTEMP0     = 0.0;
    Tdiff0     = 0.0;
    Tdiff0_2   = 0.0;
    Tdiff      = 0.0;
    Tdiff_2    = 0.0;
    Eg         = 0.0;
    Nin        = 0.0;
    Vgbgmt     = 0.0;
    Vxbgmt     = 0.0;
    Vxbgmtcl   = 0.0;
    QsuLD      = 0.0;
    QiuLD      = 0.0;
    IdsIBPC    = 0.0;
    flg_ovzone = 0;
    VgpLD      = 0.0;
    Vgb_fb_LD  = 0.0;
    Ps0LD      = 0.0;
    cnst1over  = 0.0;
    ddriftld   = `DDRIFT ;
    ddriftldc  = `DDRIFT ;
    Nover_func = 0.0;
    cnst0over_func = 0.0;
    Ta         = 9.3868e-3;
    Tb         = -0.1047839;
    Chi_1      = 0.0;
    mueph      = 0.0;
    dL         = 0.0;
    dLLD       = 0.0;
    LG         = 0.0;
    dW         = 0.0;
    dWLD       = 0.0;
    dWCV       = 0.0;
    WG         = 0.0;
    WLG        = 0.0;
    Lgate      = 0.0;
    Wgate      = 0.0;
    Nsubpp     = 0.0;
    Nsubps     = 0.0;
    Nsub       = 0.0;
    Nsubb      = 0.0;
    Lod_half   = 0.0;
    Lod_half_ref = 0.0;
    log_Tratio = 0.0;
    Edri       = 0.0;
    Vdri       = 0.0;
    Mu0        = 0.0;
    Cx         = 0.0;
    Car        = 0.0;
    Xov        = 0.0;
    Carr       = 0.0;
    GD         = 0.0;
    Vddpz      = 0.0;
    arg        = 0.0;
    vbd        = 0.0;
    Vbsi        = 0.0;
    Vdsi        = 0.0;
    vgd        = 0.0;
    Vgsi        = 0.0;
    deltemp    = 0.0;
    Vdsei       = 0.0;
    Vgsei       = 0.0;
    Vbsei       = 0.0;
    Isubs      = 0.0;
    IsubLDs    = 0.0;
    IdsIBPCs   = 0.0;
    Gth        = 0.0;
    Qg         = 0.0;
    Qs         = 0.0;
    Veffpower  = 0.0;
    P          = 0.0;
    Qi_nqs     = 0.0;
    Qb_nqs     = 0.0;
    Iqi_nqs    = 0.0;
    Iqb_nqs    = 0.0;
    Qd_nqs     = 0.0;
    Qs_nqs     = 0.0;
    Qg_nqs     = 0.0;
    Qbulk      = 0.0;
    cgdb       = 0.0;
    cggb       = 0.0;
    cgsb       = 0.0;
    cbdb       = 0.0;
    cbgb       = 0.0;
    cbsb       = 0.0;
    cddb       = 0.0;
    cdgb       = 0.0;
    cdsb       = 0.0;
    Von        = 0.0;
    Ninvde     = 0.0;
    NinvdecRES = 0.0; // CODEP=3
    NinvdehRES = 0.0; // CODEP=3
    RRDRMUE    = 0.0;
    RRDRMUES   = 0.0;
    RRDRVMAX   = 0.0;
    Rde        = 0.0; //HV1
    Rdvde      = 0.0; //HV1
    Rse        = 0.0; //HV1
    Rsvde      = 0.0; //HV1
    RRDRVMAXS  = 0.0;
    Tratio     = 0.0;
    VMAXeff    = 0.0;
    betatnom   = 0.0;
    cnst0over  = 0.0;
    cnst0overs = 0.0;
    costi0_p2  = 0.0;
    mphn0      = 0.0;
    powratio   = 0.0;
    ptovr      = 0.0;
    sqrt_eg    = 0.0;
    wdpl       = 0.0;
    wdplp      = 0.0;
    UC_RDRBB   = RDRBB ;
    UC_RDRBB_s   = RDRBBS ;
    Ids_acc    = 0.0 ;
    Ids_res    = 0.0 ;
    Ires_leak  = 0.0 ;
    Pb2n       = 0.0 ;
    Vbipn      = 0.0 ;
    HBDCeff    = HBDC ;
    UC_SUBTMP  = SUBTMP ;
    depmphn0   = 0.0 ;
    Qiu_noi    = 0.0 ;
    lp_s0_max  = `lp_s0_max ;

`ifdef COEXTDIO
        /* for Junction Diode Model */
`else
        js         = 0.0;
        jssw       = 0.0;
        js2        = 0.0;
        jssw2      = 0.0;
        Ibs        = 0.0;
        Gbs        = 0.0;
        Ibd        = 0.0;
        Gbd        = 0.0;
        Ibsi       = 0.0;
        Ibdi       = 0.0;
        Qbs        = 0.0;
        Qbd        = 0.0;
        Qbsi       = 0.0;
        Qbdi       = 0.0;
        czbd       = 0.0;
        czbdsw     = 0.0;
        czbdswg    = 0.0;
        czbs       = 0.0;
        czbssw     = 0.0;
        czbsswg    = 0.0;
        pzbd       = 0.0;
        pzbdsw     = 0.0;
        pzbdswg    = 0.0;
        pzbs       = 0.0;
        pzbssw     = 0.0;
        pzbsswg    = 0.0;
        sarg       = 0.0;
        vsbs       = 0.0;
        vdbd       = 0.0;
        vbs_jct    = 0.0;
        vbd_jct    = 0.0;
        vbpsp      = 0.0;
        vbpdp      = 0.0;
        vbsi_jct   = 0.0;
        vbdi_jct   = 0.0;
        Capbd      = 0.0;
        Capbs      = 0.0;
        exptempd   = 0.0;
        exptemps   = 0.0;
        isbd       = 0.0;
        isbs       = 0.0;
        jd_expcd   = 0.0;
        jd_expcs   = 0.0;
        vbdt       = 0.0;
        vbst       = 0.0;
        jd_nvtm_invd  = 0.0;
        jd_nvtm_invs  = 0.0;
`endif /* End of COEXTDIO */

    end_of_part_1 = 0;
    flg_brk1   = 0;
    start_of_loopl = 0;
    flg_brk2   = 0;
    start_of_mobility = 0;

    //*  initialize for hidden state
    RS_Ps0LD    = 0.0 ;
    RS_QbuLD    = 0.0 ;
    Qbd_qs      = 0.0 ;
    Ibd_nqs     = 0.0 ;
    isbd_btm    = 0.0 ;
    isbd2_btm   = 0.0 ;
    isbd_sws    = 0.0 ;
    isbd2_sws   = 0.0 ;
    isbd_swg    = 0.0 ;
    isbd2_swg   = 0.0 ;
    isbs_btm    = 0.0 ;
    isbs2_btm   = 0.0 ;
    isbs_sws    = 0.0 ;
    isbs2_sws   = 0.0 ;
    isbs_swg    = 0.0 ;
    isbs2_swg   = 0.0 ;
    Qovd_ADD    = 0.0 ;
    Qovs_ADD    = 0.0 ;
    QbdLD_ADD   = 0.0 ;
    QbsLD_ADD   = 0.0 ;
    Wjuncld     = 0.0 ;

    IdsPT       = 0.0 ;
    IdsPT0      = 0.0 ;
    IdsPT1      = 0.0 ;

    Cox0_func   = 0.0 ;
    IWnqs0_A    = 0.0 ;
    Inqs0_A     = 0.0 ;
    Inqs0_K     = 0.0 ;
    IsubIBPC    = 0.0 ;
    Lover_func  = 0.0 ;
    Q_nqs_A     = 0.0 ;
    Q_nqs_K     = 0.0 ;
    W_nqs_A     = 0.0 ;
    W_res       = 0.0 ;
    Wdep_func   = 0.0 ;
    wIbjt       = 0.0 ;
    wk_ii       = 0.0 ;
    tauov       = 0.0 ;

    OP_mode     = 0.0 ;
    OP_Vdsi     = 0.0 ;
    OP_Vbscl    = 0.0 ;
    OP_Vdseff   = 0.0 ;
    OP_Pds_ini  = 0.0 ;
    OP_lp_s0    = 0.0 ;
    OP_lp_sl    = 0.0 ;
    OP_lp_ld    = 0.0 ;
    begin : initializeModel

        if ( COQOVSM == 3 ) begin
            $write("fatal(HiSIM_HV(%m)): COQOVSM = %g is not available.\n", COQOVSM );
            FATAL_flag = 1;
        end

        UC_CORSRD  = ((CORDRIFT) ? 0 : CORSRD); //HV1

        UC_XPDV    = XPDV;
        UC_XLDLD   = XLDLD;
        UC_SCP22   = SCP22;
        UC_RDRCX   = RDRCX;

        `GMIN          //
        Gjmin = gminMod ;
        `MFACTOR_DEC   //
        Mfactor = `MFACTOR_USE ;

        if ( Gjmin > 0.0 ) begin
            Gjmin = 0.0 ;
        end

        //-----------------------------------------------------------*
        //* Range check of model parameters
        //*-----------------//
        if (COERRREP) begin
            if ( TOX <= 0 ) begin
                $write("warning(HiSIM_HV(%m)): TOX = %e\n ", TOX);
                $write("warning(HiSIM_HV(%m)): The model parameter TOX must be positive.\n");
            end
        end
        `RANGERESET(UC_SCP22,      0.0,      0.0, "SCP22")
        `MINRESET(UC_XLDLD  ,      0.0,           "XLDLD")
        `RANGERESET(UC_RDRCX,      0.0,      1.0, "RDRCX" )

        if (COERRREP) begin
            if ( SHEMAX  < 300   || SHEMAX  > 900 ) $write("warning(HiSIM_HV(%m)): (SHEMAX = %g) range [300 , 900].\n",SHEMAX);
            if ( XLD     < 0.0   || XLD     > 50.0e-9 ) $write("warning(HiSIM_HV(%m)): (XLD = %g) range [0.0 , 50.0e-9].\n",XLD);
            if ( XWD     < -100.0e-9 || XWD     > 300.0e-9 ) $write("warning(HiSIM_HV(%m)): (XWD = %g) range [-100.0e-9 , 300.0e-9].\n",XWD);
            if ( XWDC    < -500.0e-9 || XWDC    > 500.0e-9 ) $write("warning(HiSIM_HV(%m)): (XWDC = %g) range [-500.0e-9 , 500.0e-9].\n",XWDC);
            if ( RSH     < 0.0   || RSH     > 500.0 ) $write("warning(HiSIM_HV(%m)): (RSH = %g) range [0.0 , 500.0].\n",RSH);
            if ( RSHS     < 0.0   || RSHS     > 500.0 ) $write("warning(HiSIM_HV(%m)): (RSHS = %g) range [0.0 , 500.0].\n",RSHS);
            if ( RSHG    < 0.0   || RSHG    > 100.0 ) $write("warning(HiSIM_HV(%m)): (RSHG = %g) range [0.0 , 100.0].\n",RSHG);
            if (XQY != 0.0) `RANGECHECK(XQY,        10.0e-9,  50.0e-9, "XQY")
                `MINCHECK(XQY1,       0.0,           "XQY1")
            `MINCHECK(XQY2,       0.0,           "XQY2")
            if ( VBI     < 1.0   || VBI     > 1.2  ) $write("warning(HiSIM_HV(%m)): (VBI = %g) range [1.0 , 1.2].\n",VBI);
            if ( PARL2   < 0.0   || PARL2   > 50.0e-9 ) $write("warning(HiSIM_HV(%m)): (PARL2 = %g) range [0.0 , 50.0e-9].\n",PARL2);
            if ( LP      < 0.0   || LP      > 300.0e-9 ) $write("warning(HiSIM_HV(%m)): (LP = %g) range [0.0 , 300.0e-9].\n",LP);
            if ( PGD2    < 0.0   || PGD2    > 1.5  ) $write("warning(HiSIM_HV(%m)): (PGD2 = %g) range [0.0 , 1.5].\n",PGD2);
            if ( PGD4    < 0.0   || PGD4    > 3.0 ) $write("warning(HiSIM_HV(%m)): (PGD4 = %g) range [0.0 , 3.0].\n",PGD4);
            if ( MUEPH0  < 0.25  || MUEPH0  > 0.35 ) $write("warning(HiSIM_HV(%m)): (MUEPH0 = %g) range [0.25 , 0.35].\n",MUEPH0);
            if ( MUESR0  < 1.8   || MUESR0  > 2.2  ) $write("warning(HiSIM_HV(%m)): (MUESR0 = %g) range [1.8 , 2.2].\n",MUESR0);
            if ( LPEXT   < 1.0e-50 || LPEXT   > 10.0e-6 ) $write("warning(HiSIM_HV(%m)): (LPEXT = %g) range [1.0e-50 , 10.0e-6].\n",LPEXT);
            `MINCHECK(SC4,        0.0,           "SC4")
            if ( SCP21   < 0.0   || SCP21   > 5.0 ) $write("warning(HiSIM_HV(%m)): (SCP21 = %g) range [0.0 , 5.0].\n",SCP21);
            if ( BS1     < 0.0   || BS1     > 50.0e-3 ) $write("warning(HiSIM_HV(%m)): (BS1 = %g) range [0.0 , 50.0e-3].\n",BS1);
            if ( BS2     < 0.5   || BS2     > 1.0  ) $write("warning(HiSIM_HV(%m)): (BS2 = %g) range [0.5 , 1.0].\n",BS2);
            `MINCHECK(PTL,        0.0,           "PTL")
            if ( PTP     < 3.0   || PTP     > 4.0 ) $write("warning(HiSIM_HV(%m)): (PTP = %g) range [3.0 , 4.0].\n",PTP);
            `MINCHECK(PT2,        0.0,           "PT2")
            `MINCHECK(PT4,        0.0,           "PT4")
            `MINCHECK(PT4P,       0.0,           "PT4P")
            if ( GDL     < 0.0   || GDL     > 220e-9 ) $write("warning(HiSIM_HV(%m)): (GDL = %g) range [0.0 , 220e-9].\n",GDL);
            `MINCHECK(NINVD,      0.0,           "NINVD")
            `MINCHECK(NINVDW,     0.0,           "NINVDW")
            `MINCHECK(NINVDWP,    0.0,           "NINVDWP")
            if ( CLM5    < 0.0   || CLM5    > 2.0 ) $write("warning(HiSIM_HV(%m)): (CLM5 = %g) range [0.0 , 2.0].\n",CLM5);
            if ( CLM6    < 0.0   || CLM6    > 20.0 ) $write("warning(HiSIM_HV(%m)): (CLM6 = %g) range [0.0 , 20.0].\n",CLM6);
            if ( SUB2L   < 0.0   || SUB2L   > 1.0 ) $write("warning(HiSIM_HV(%m)): (SUB2L = %g) range [0.0 , 1.0].\n",SUB2L);
            if ( VOVERP  < 0.0   || VOVERP  > 2.0 ) $write("warning(HiSIM_HV(%m)): (VOVERP = %g) range [0.0 , 2.0].\n",VOVERP);
            if ( QME1    < 0.0   || QME1    > 1e-9 ) $write("warning(HiSIM_HV(%m)): (QME1 = %g) range [0.0 , 1e-9].\n",QME1);
            if ( QME2    < 1.0   || QME2    > 3.0 ) $write("warning(HiSIM_HV(%m)): (QME2 = %g) range [1.0 , 3.0].\n",QME2);
            if ( QME3    < 0.0   || QME3    > 500e-12 ) $write("warning(HiSIM_HV(%m)): (QME3 = %g) range [0.0 , 500e-12].\n",QME3);
            if ( GLPART1 < 0.0   || GLPART1 > 1.0 ) $write("warning(HiSIM_HV(%m)): (GLPART1 = %g) range [0.0 , 1.0].\n",GLPART1);
            if ( TNOM    < 22.0  || TNOM    > 32.0 ) $write("warning(HiSIM_HV(%m)): (TNOM = %g) range [22.0 , 32.0].\n",TNOM);
            if ( DDLTMAX < 1.0   || DDLTMAX > 10.0 ) $write("warning(HiSIM_HV(%m)): (DDLTMAX = %g) range [1.0 , 10.0].\n",DDLTMAX);
            if ( DDLTICT < -3.0  || DDLTICT > 20.0 ) $write("warning(HiSIM_HV(%m)): (DDLTICT = %g) range [-3.0 , 20.0].\n",DDLTICT);
            if ( DDLTSLP < 0.0   || DDLTSLP > 20.0 ) $write("warning(HiSIM_HV(%m)): (DDLTSLP = %g) range [0.0 , 20.0].\n",DDLTSLP);
            if ( MPHDFM  < -3.0  || MPHDFM  > 3.0 ) $write("warning(HiSIM_HV(%m)): (MPHDFM = %g) range [-3.0 , 3.0].\n",MPHDFM);
            if ( RD20    < 0.0   || RD20    > 30.0 ) $write("warning(HiSIM_HV(%m)): (RD20 = %g) range [0.0 , 30.0].\n",RD20);     //HV1
            if ( RD21    < 0.0   || RD21    > 1.0  ) $write("warning(HiSIM_HV(%m)): (RD21 = %g) range [0.0 , 1.0].\n",RD21);      //HV1
            if ( RD22D   < 0.0   || RD22D   > 2.0 ) $write("warning(HiSIM_HV(%m)): (RD22D = %g) range [0.0 , 2.0].\n",RD22D);     //HV1
            `MINCHECK(  RD25,       0.0,           "RD25")
            if ( RDTEMP1 < -1e-1 || RDTEMP1 > 2e0 ) $write("warning(HiSIM_HV(%m)): (RDTEMP1 = %g) range [-0.1 , 2].\n",RDTEMP1);
            if ( RDTEMP2 < -1e-3 || RDTEMP2 > 1e-3 ) $write("warning(HiSIM_HV(%m)): (RDTEMP2 = %g) range [-1e-3 , 1e-3].\n",RDTEMP2);
            if ( RDVDTEMP1 < -1e-1 || RDVDTEMP1 > 1e0 ) $write("warning(HiSIM_HV(%m)): (RDVDTEMP1 = %g) range [-0.1 , 1].\n",RDVDTEMP1);
            if ( RDVDTEMP2 < -1e-3 || RDVDTEMP2 > 1e-3 ) $write("warning(HiSIM_HV(%m)): (RDVDTEMP2 = %g) range [-1e-3 , 1e-3].\n",RDVDTEMP2);
            `MINCHECK(  RDVG12,     0.0,           "RDVG12")
            if ( RTHTEMP1 < -1.0  || RTHTEMP1 > 1.0 ) $write("warning(HiSIM_HV(%m)): (RTHTEMP1 = %g) range [-1.0 , 1.0].\n",RTHTEMP1);
            if ( RTHTEMP2 < -1.0  || RTHTEMP2 > 1.0 ) $write("warning(HiSIM_HV(%m)): (RTHTEMP2 = %g) range [-1.0 , 1.0].\n",RTHTEMP2);
            if ( RTH0W   < -100  || RTH0W   > 100 ) $write("warning(HiSIM_HV(%m)): (RTH0W  = %g) range [-100 , 100].\n",RTH0W);
            if ( RTH0WP  < -10   || RTH0WP  > 10  ) $write("warning(HiSIM_HV(%m)): (RTH0WP = %g) range [ -10 ,  10].\n",RTH0WP);
            if ( RTH0L   < -100  || RTH0L   > 100 ) $write("warning(HiSIM_HV(%m)): (RTH0L  = %g) range [-100 , 100].\n",RTH0L);
            if ( RTH0LP  < -10   || RTH0LP  > 10  ) $write("warning(HiSIM_HV(%m)): (RTH0LP = %g) range [ -10 ,  10].\n",RTH0LP);
            if ( RTH0NF  < -5.0  || RTH0NF  > 5.0 ) $write("warning(HiSIM_HV(%m)): (RTH0NF = %g) range [-5.0 , 5.0].\n",RTH0NF);
            if ( PRATTEMP1 < -1.0  || PRATTEMP1 > 1.0 ) $write("warning(HiSIM_HV(%m)): (PRATTEMP1 = %g) range [-1.0 , 1.0].\n",PRATTEMP1);
            if ( PRATTEMP2 < -1.0  || PRATTEMP2 > 1.0 ) $write("warning(HiSIM_HV(%m)): (PRATTEMP2 = %g) range [-1.0 , 1.0].\n",PRATTEMP2);
            `MINCHECK(  LDRIFT1,    0.0,           "LDRIFT1")
            `MINCHECK(  LDRIFT1S,   0.0,           "LDRIFT1S")
            `MINCHECK(  LDRIFT2,    0.0,           "LDRIFT2")
            `MINCHECK(  LDRIFT2S,   0.0,           "LDRIFT2S")
            if ( RDS     < -100  || RDS     > 100 ) $write("warning(HiSIM_HV(%m)): (RDS = %g) range [-100 , 100].\n",RDS);           //HV1
            if ( RDSP    < -10   || RDSP    > 10 ) $write("warning(HiSIM_HV(%m)): (RDSP = %g) range [-10 , 10].\n",RDSP);            //HV1
            if ( RDVDL   < -100  || RDVDL   > 100 ) $write("warning(HiSIM_HV(%m)): (RDVDL = %g) range [-100 , 100].\n",RDVDL);       //HV1
            if ( RDVDLP  < -10   || RDVDLP  > 10 ) $write("warning(HiSIM_HV(%m)): (RDVDLP = %g) range [-10 , 10].\n",RDVDLP);        //HV1
            if ( RDVDS   < -100  || RDVDS   > 100 ) $write("warning(HiSIM_HV(%m)): (RDVDS = %g) range [-100 , 100].\n",RDVDS);       //HV1
            if ( RDVDSP  < -10   || RDVDSP  > 10 ) $write("warning(HiSIM_HV(%m)): (RDVDSP = %g) range [-10 , 10].\n",RDVDSP);        //HV1
            if ( RD23L   < -100  || RD23L   > 100 ) $write("warning(HiSIM_HV(%m)): (RD23L = %g) range [-100 , 100].\n",RD23L);       //HV1
            if ( RD23LP  < -10   || RD23LP  > 10 ) $write("warning(HiSIM_HV(%m)): (RD23LP = %g) range [-10 , 10].\n",RD23LP);        //HV1
            if ( RD23S   < -100  || RD23S   > 100 ) $write("warning(HiSIM_HV(%m)): (RD23S = %g) range [-100 , 100].\n",RD23S);       //HV1
            if ( RD23SP  < -10   || RD23SP  > 10 ) $write("warning(HiSIM_HV(%m)): (RD23SP = %g) range [-10 , 10].\n",RD23SP);        //HV1
            if ( RDOV11  < 0.0   || RDOV11  > 10 ) $write("warning(HiSIM_HV(%m)): (RDOV11 = %g) range [0.0 , 10].\n",RDOV11);        //HV1
            if ( RDOV12  < 0.0   || RDOV12  > 2.0 ) $write("warning(HiSIM_HV(%m)): (RDOV12 = %g) range [0.0 , 2.0].\n",RDOV12);      //HV1
            if ( RDSLP2  < -10.0 || RDSLP2  > 10.0 ) $write("warning(HiSIM_HV(%m)): (RDSLP2 = %g) range [-10.0 , 10.0].\n",RDSLP2);  //HV1
            if ( RDICT2  < -10.0 || RDICT2  > 10.0 ) $write("warning(HiSIM_HV(%m)): (RDICT2 = %g) range [-10.0 , 10.0].\n",RDICT2);  //HV1
            if ( RDRVMAX < 1e6   || RDRVMAX > 100e6 ) $write("warning(HiSIM_HV(%m)): (RDRVMAX = %g) range [1e6 , 100e6].\n",RDRVMAX);
            if ( RDRMUE  < 1e2   || RDRMUE  > 3e3  ) $write("warning(HiSIM_HV(%m)): (RDRMUE = %g) range [1e2 , 3e3].\n",RDRMUE);
            if ( RDRQOVER < 0.0  || RDRQOVER > 1e7 ) $write("warning(HiSIM_HV(%m)): (RDRQOVER = %g) range [0.0 , 1e7].\n",RDRQOVER);

            if ( RDRCAR  < 0.0   || RDRCAR  > 50e-9 ) $write("warning(HiSIM_HV(%m)): (RDRCAR = %g) range [0.0 , 50e-9].\n",RDRCAR);
            if ( RDRMUETMP < 0.0   || RDRMUETMP > 2.0 ) $write("warning(HiSIM_HV(%m)): (RDRMUETMP = %g) range [0.0 , 2.0].\n",RDRMUETMP);
            if ( RDRVTMP < -2.0  || RDRVTMP > 1.0 ) $write("warning(HiSIM_HV(%m)): (RDRVTMP = %g) range [-2.0 , 1.0].\n",RDRVTMP);
            `MINCHECK(  UC_XPDV,       0.0,           "XPDV"      )
            `MINCHECK(  XPVDTH,     0.0,           "XPVDTH"    )
            if ( XPVDTHG < -1.0  || XPVDTHG > 1.0  ) $write("warning(HiSIM_HV(%m)): (XPVDTHG = %g) range [-1.0 , 1.0].\n",XPVDTHG);
            `MINCHECK(  IBPC1L,     0.0,           "IBPC1L"    )

`ifdef COEXTDIO
                /* for Junction Diode Model */
`else
                if ( CVB     < -0.1  || CVB     > 0.2 ) $write("warning(HiSIM_HV(%m)): (CVB = %g) range [-0.1 , 0.2].\n",CVB);
                if ( CVBD    < -0.1  || CVBD    > 0.2 ) $write("warning(HiSIM_HV(%m)): (CVBD = %g) range [-0.1 , 0.2].\n",CVBD);
                if ( CVBS    < -0.1  || CVBS    > 0.2 ) $write("warning(HiSIM_HV(%m)): (CVBS = %g) range [-0.1 , 0.2].\n",CVBS);
`endif

        end

        UC_NDEPM = NDEPM ;
        UC_DEPTHN = TNDEP ;
        UC_CODEP = CODEP ;
        UC_DEPMUEBACK0 = DEPMUEBACK0 ;
        UC_DEPMUEBACK1 = DEPMUEBACK1 ;
        UC_DEPMUE0 = DEPMUE0 ;
        UC_DEPMUE1 = DEPMUE1 ;
        UC_DEPMUE2 = DEPMUE2 ;
        UC_DEPLEAK = DEPLEAK ;
        UC_DEPVMAX = DEPVMAX ;
        UC_DEPWLP  = DEPWLP  ; // protection against hidden state
        UC_DEPMUEPH1 = DEPMUEPH1 ;
        UC_DEPVDSEF1 = DEPVDSEF1 ;
        UC_DEPVDSEF2 = DEPVDSEF2 ;

        //
        //if( UC_CODEP != 0 )  begin
        if ( UC_CODEP < 3 && UC_CODEP > 0 ) begin //{
            `RANGERESET(UC_NDEPM,      5e15,      1e18,   "NDEPM" )
            `RANGERESET(UC_DEPTHN,     1e-8,      1.0e-6, "TNDEP" )
            `RANGERESET(UC_DEPMUE0,       1,      1.0e5,  "DEPMUE0" )
            `RANGERESET(UC_DEPMUEBACK0,   1,      1.0e5,  "DEPMUEBACK0" )
            `RANGERESET(UC_DEPMUEPH1,     1,      1.0e5,  "DEPMUEPH1" )
            `RANGERESET(UC_DEPVDSEF2,   0.1,          4,  "DEPVDSEF2" )
            `RANGERESET(UC_DEPLEAK,     0.0,          5,  "DEPLEAK" )
        end //}
        else if ( UC_CODEP == 3 ) begin //{
            `RANGERESET(UC_NDEPM,      5e15,      1e18,   "NDEPM" )
            `RANGERESET(UC_DEPTHN,     1e-8,      1e-6,   "TNDEP" )
            `RANGERESET(UC_DEPMUE0,       1,      1e10,   "DEPMUE0" )
            //`RANGERESET(UC_DEPMUEPH1,   100,      2.0e4,  "DEPMUEPH1" ) // original
            //`RANGERESET(UC_DEPMUEPH1,   100,      2.0e6,  "DEPMUEPH1" )
            `RANGERESET(UC_DEPMUEPH1,   100,      2.0e9,  "DEPMUEPH1" )
            `RANGERESET(UC_DEPLEAK,     0.0,          5,  "DEPLEAK" )
        end //}

        if ( UC_CODEP != 0 && COERRREP ) begin

            if ( COISTI == 1 ) begin
                $write("warning(HiSIM_HV(%m)): STI leak model is not supported yet in Depletion mode model, skipped\n");
            end
            if ( COTHRML == 1 ) begin
                $write("warning(HiSIM_HV(%m)): Thermal noise model is not supported yet in Depletion mode model, skipped\n");
            end
            if ( COIGN == 1 ) begin
                $write("warning(HiSIM_HV(%m)): Induced gate noise model is not supported yet in Depletion mode model, skipped\n");
            end

        end

        if ( UC_XPDV * UC_XLDLD > 1 && COERRREP ) begin
            $write("warning(HiSIM_HV(%m)): The model parameter XPDV (= %e) must be Smaller than 1/XLDLD (= %e).\n",
                 UC_XPDV, 1/UC_XLDLD );
            $write("warning(HiSIM_HV(%m)): The model parameter XPDV (= %e) has been changed to %e.\n",
                 UC_XPDV, 1/UC_XLDLD );
        end

        if ( COPPRV == 1 ) begin
            $write("warning(HiSIM_HV(%m)): COPPRV is not supported yet in VA code, reset to 0.\n");
        end

        UC_TOXB = TOXB ;
        `RANGERESET(UC_TOXB,      TOX,       5e-7, "TOXB")

        //-----------------------------------------------------------*
        //* Change units into MKS.
        //*-----------------//
        MKS_LL        = LL        / pow( `C_m2cm , LLN ) ;
        MKS_WL        = WL        / pow( `C_m2cm , WLN ) ;
        MKS_SVGSL     = SVGSL     / pow( `C_m2cm , SVGSLP ) ;
        MKS_SVGSW     = SVGSW     / pow( `C_m2cm , SVGSWP ) ;
        MKS_SVBSL     = SVBSL     / pow( `C_m2cm , SVBSLP ) ;
        MKS_SLGL      = SLGL      / pow( `C_m2cm , SLGLP ) ;
        MKS_SUB1L     = SUB1L     / pow( `C_m2cm , SUB1LP ) ;
        MKS_SLG       = SLG       / `C_m2cm ;
        MKS_SUB2L     = SUB2L     / `C_m2cm ;
        MKS_SUBLD2    = SUBLD2    * `C_m2cm ;
        MKS_RDTEMP1   = RDTEMP1   / `C_m2cm ;     //HV1
        MKS_RDTEMP2   = RDTEMP2   / `C_m2cm ;     //HV1
        MKS_RDVDTEMP1 = RDVDTEMP1 / `C_m2cm ;     //HV1
        MKS_RDVDTEMP2 = RDVDTEMP2 / `C_m2cm ;     //HV1
        MKS_NSUBSUB   = NSUBSUB   / `C_cm2m_p3 ;
        MKS_GLKSD3    = GLKSD3    * `C_m2cm ;
        MKS_GLEAK4    = GLEAK4    * `C_m2cm ;
        MKS_GLEAK5    = GLEAK5    * `C_m2cm ;
        MKS_GLEAK7    = GLEAK7    / `C_m2cm_p2 ;
        MKS_CIT       = CIT       * `C_m2cm_p2 ;
        MKS_OVSLP     = OVSLP     / `C_m2cm ;
        MKS_DLY3      = DLY3      / `C_m2cm_p2 ;
        MKS_DLYOV     = DLYOV     / `C_m2cm_p2 ;
        MKS_CTH0      = CTH0      * `C_m2cm ;
        MKS_RDRMUE    = RDRMUE    / `C_m2cm_p2 ;
        MKS_RDRVMAX   = RDRVMAX   / `C_m2cm ;
        MKS_RDRMUES   = RDRMUES   / `C_m2cm_p2 ;
        MKS_RDRVMAXS  = RDRVMAXS  / `C_m2cm ;
        UC_NDEPM      = UC_NDEPM  / `C_cm2m_p3 ;
        UC_NJUNC      = NJUNC     / `C_cm2m_p3 ; // new punchthough

        //-----------------------------------------------------------*
        //* Change unit into Kelvin.
        //*-----------------//
        KTNOM =  TNOM + 273.15 ; // [C] -> [K] //
        //     subNode  = `subNode_define ; Vsubs    = 0.0 ;
    end // initializeModel

    begin : initializeInstance

        drainConductance  = 0.0 ;
        sourceConductance = 0.0 ;
        //-----------------------------------------------------------*
        //* Range check of instance parameters
        //*-----------------//
        if (COERRREP) begin
            if ( L       < LMIN  || L       > LMAX ) $write("warning(HiSIM_HV(%m)): (L = %g) range [LMIN , LMAX].\n",L);
            if ( W/NF    < WMIN  || W/NF    > WMAX ) $write("warning(HiSIM_HV(%m)): (W/NF = %g) range [WMIN , WMAX].\n",W/NF);
        end

        // Calculate & check the Lgate and Wgate
        Lgate = L + XL ;
        Wgate = W / NF  + XW ;
        `RANGECHECKFoo( Lgate     , 0.0, `inf, "Lgate")
        `RANGECHECKFoo( Wgate     , 0.0, `inf, "Wgate")
        `RANGECHECKFoo( Lgate-XGL , 0.0, `inf, "Lgate-XGL" )
        `RANGECHECKFco( Lgate+LLD , 0.0, `inf, "Lgate+LLD" )
        `RANGECHECKFco( Wgate+WLD , 0.0, `inf, "Wgate+WLD")
        `RANGECHECKFco( Lgate+GDLD, 0.0, `inf, "Lgate+GDLD")

        // check LDRIFT1+LDRIFT2
        `RANGECHECKFoo( LDRIFT1+LDRIFT2  , 0.0, `inf, "LDRIFT1+LDRIFT2" )

        // Binning calculation //
        LG = Lgate * `C_m2um ; // Regard LG as unitless. Say, Lgate=1e-6 (m); LG = 1e-6 (m) / 1e-6 (m) = 1.
        WG = Wgate * `C_m2um ; // Regard WG as unitless.
        Lbin = pow(LG, LBINN) ;
        Wbin = pow(WG, WBINN) ;
        LWbin = Lbin * Wbin ;

        `BINNING(UC_VMAX, VMAX, LVMAX, WVMAX, PVMAX)
        `BINNING(UC_BGTMP1, BGTMP1, LBGTMP1, WBGTMP1, PBGTMP1)
        `BINNING(UC_BGTMP2, BGTMP2, LBGTMP2, WBGTMP2, PBGTMP2)
        `BINNING(UC_EG0, EG0, LEG0, WEG0, PEG0)
        `BINNING(UC_VFBOVER, VFBOVER, LVFBOVER, WVFBOVER, PVFBOVER)
        `BINNING(UC_NOVER, NOVER, LNOVER, WNOVER, PNOVER)
        `BINNING(UC_NOVERS, NOVERS, LNOVERS, WNOVERS, PNOVERS)
        `BINNING(UC_WL2, WL2, LWL2, WWL2, PWL2)
        `BINNING(UC_VFBC, VFBC, LVFBC, WVFBC, PVFBC)
        `BINNING(UC_NSUBC, NSUBC, LNSUBC, WNSUBC, PNSUBC)
        `BINNING(UC_NSUBP, NSUBP, LNSUBP, WNSUBP, PNSUBP)
        `BINNING(UC_SCP1, SCP1, LSCP1, WSCP1, PSCP1)
        `BINNING(UC_SCP2, SCP2, LSCP2, WSCP2, PSCP2)
        `BINNING(UC_SCP3, SCP3, LSCP3, WSCP3, PSCP3)
        `BINNING(UC_SC1, SC1, LSC1, WSC1, PSC1)
        `BINNING(UC_SC2, SC2, LSC2, WSC2, PSC2)
        `BINNING(UC_SC3, SC3, LSC3, WSC3, PSC3)
        `BINNING(UC_PGD1, PGD1, LPGD1, WPGD1, PPGD1)
        `BINNING(UC_NDEP, NDEP, LNDEP, WNDEP, PNDEP)
        `BINNING(UC_NINV, NINV, LNINV, WNINV, PNINV)
        `BINNING(UC_MUECB0, MUECB0, LMUECB0, WMUECB0, PMUECB0)
        `BINNING(UC_MUECB1, MUECB1, LMUECB1, WMUECB1, PMUECB1)
        `BINNING(UC_MUEPH1, MUEPH1, LMUEPH1, WMUEPH1, PMUEPH1)
        `BINNING(UC_VTMP, VTMP, LVTMP, WVTMP, PVTMP)
        `BINNING(UC_WVTH0, WVTH0, LWVTH0, WWVTH0, PWVTH0)
        `BINNING(UC_MUESR1, MUESR1, LMUESR1, WMUESR1, PMUESR1)
        `BINNING(UC_MUETMP, MUETMP, LMUETMP, WMUETMP, PMUETMP)
        `BINNING(UC_SUB1, SUB1, LSUB1, WSUB1, PSUB1)
        `BINNING(UC_SUB2, SUB2, LSUB2, WSUB2, PSUB2)
        `BINNING(UC_SVDS, SVDS, LSVDS, WSVDS, PSVDS)
        `BINNING(UC_SVBS, SVBS, LSVBS, WSVBS, PSVBS)
        `BINNING(UC_SVGS, SVGS, LSVGS, WSVGS, PSVGS)

        `BINNING(UC_SUB1SNP, SUB1SNP, LSUB1SNP, WSUB1SNP, PSUB1SNP)
        `BINNING(UC_SUB2SNP, SUB2SNP, LSUB2SNP, WSUB2SNP, PSUB2SNP)
        `BINNING(UC_SVDSSNP, SVDSSNP, LSVDSSNP, WSVDSSNP, PSVDSSNP)
        //       `BINNING(UC_SVGSSNP, SVGSSNP, LSVGSSNP, WSVGSSNP, PSVGSSNP)
        //       `BINNING(UC_SVBSSNP, SVBSSNP, LSVBSSNP, WSVBSSNP, PSVBSSNP)

        `BINNING(UC_FN1, FN1, LFN1, WFN1, PFN1)
        `BINNING(UC_FN2, FN2, LFN2, WFN2, PFN2)
        `BINNING(UC_FN3, FN3, LFN3, WFN3, PFN3)
        `BINNING(UC_FVBS, FVBS, LFVBS, WFVBS, PFVBS)
        `BINNING(UC_NSTI, NSTI, LNSTI, WNSTI, PNSTI)
        `BINNING(UC_WSTI, WSTI, LWSTI, WWSTI, PWSTI)
        `BINNING(UC_SCSTI1, SCSTI1, LSCSTI1, WSCSTI1, PSCSTI1)
        `BINNING(UC_SCSTI2, SCSTI2, LSCSTI2, WSCSTI2, PSCSTI2)
        `BINNING(UC_VTHSTI, VTHSTI, LVTHSTI, WVTHSTI, PVTHSTI)
        `BINNING(UC_MUESTI1, MUESTI1, LMUESTI1, WMUESTI1, PMUESTI1)
        `BINNING(UC_MUESTI2, MUESTI2, LMUESTI2, WMUESTI2, PMUESTI2)
        `BINNING(UC_MUESTI3, MUESTI3, LMUESTI3, WMUESTI3, PMUESTI3)
        `BINNING(UC_NSUBPSTI1, NSUBPSTI1, LNSUBPSTI1, WNSUBPSTI1, PNSUBPSTI1)
        `BINNING(UC_NSUBPSTI2, NSUBPSTI2, LNSUBPSTI2, WNSUBPSTI2, PNSUBPSTI2)
        `BINNING(UC_NSUBPSTI3, NSUBPSTI3, LNSUBPSTI3, WNSUBPSTI3, PNSUBPSTI3)
        `BINNING(UC_CGSO, CGSO, LCGSO, WCGSO, PCGSO)
        `BINNING(UC_CGDO, CGDO, LCGDO, WCGDO, PCGDO)
        `BINNING(UC_CLM1, CLM1, LCLM1, WCLM1, PCLM1)
        `BINNING(UC_CLM2, CLM2, LCLM2, WCLM2, PCLM2)
        `BINNING(UC_CLM3, CLM3, LCLM3, WCLM3, PCLM3)
        `BINNING(UC_WFC, WFC, LWFC, WWFC, PWFC)
        `BINNING(UC_GIDL1, GIDL1, LGIDL1, WGIDL1, PGIDL1)
        `BINNING(UC_GIDL2, GIDL2, LGIDL2, WGIDL2, PGIDL2)
        `BINNING(UC_GLEAK1, GLEAK1, LGLEAK1, WGLEAK1, PGLEAK1)
        `BINNING(UC_GLEAK2, GLEAK2, LGLEAK2, WGLEAK2, PGLEAK2)
        `BINNING(UC_GLEAK3, GLEAK3, LGLEAK3, WGLEAK3, PGLEAK3)
        `BINNING(UC_GLEAK6, GLEAK6, LGLEAK6, WGLEAK6, PGLEAK6)
        `BINNING(UC_GLKSD1, GLKSD1, LGLKSD1, WGLKSD1, PGLKSD1)
        `BINNING(UC_GLKSD2, GLKSD2, LGLKSD2, WGLKSD2, PGLKSD2)
        `BINNING(UC_GLKB1, GLKB1, LGLKB1, WGLKB1, PGLKB1)
        `BINNING(UC_GLKB2, GLKB2, LGLKB2, WGLKB2, PGLKB2)
        `BINNING(UC_NFTRP, NFTRP, LNFTRP, WNFTRP, PNFTRP)
        `BINNING(UC_NFALP, NFALP, LNFALP, WNFALP, PNFALP)
        `BINNING(UC_IBPC1, IBPC1, LIBPC1, WIBPC1, PIBPC1)
        `BINNING(UC_IBPC2, IBPC2, LIBPC2, WIBPC2, PIBPC2)
        `BINNING(UC_CGBO, CGBO, LCGBO, WCGBO, PCGBO)
        `BINNING(UC_CVDSOVER, CVDSOVER, LCVDSOVER, WCVDSOVER, PCVDSOVER)
        `BINNING(UC_FALPH, FALPH, LFALPH, WFALPH, PFALPH)
        `BINNING(UC_NPEXT, NPEXT, LNPEXT, WNPEXT, PNPEXT)
        `BINNING(UC_POWRAT, POWRAT, LPOWRAT, WPOWRAT, PPOWRAT)
        `BINNING(UC_RD, RD, LRD, WRD, PRD)
        `BINNING(UC_RD22, RD22, LRD22, WRD22, PRD22)
        `BINNING(UC_RD23, RD23, LRD23, WRD23, PRD23)
        `BINNING(UC_RD24, RD24, LRD24, WRD24, PRD24)
        `BINNING(UC_RDICT1, RDICT1, LRDICT1, WRDICT1, PRDICT1)
        `BINNING(UC_RDOV13, RDOV13, LRDOV13, WRDOV13, PRDOV13)
        `BINNING(UC_RDSLP1, RDSLP1, LRDSLP1, WRDSLP1, PRDSLP1)
        `BINNING(UC_RDVB, RDVB, LRDVB, WRDVB, PRDVB)
        `BINNING(UC_RDVD, RDVD, LRDVD, WRDVD, PRDVD)
        `BINNING(UC_RDVG11, RDVG11, LRDVG11, WRDVG11, PRDVG11)
        `BINNING(UC_RS, RS, LRS, WRS, PRS)
        `BINNING(UC_RTH0, RTH0, LRTH0, WRTH0, PRTH0)
        `BINNING(UC_VOVER, VOVER, LVOVER, WVOVER, PVOVER)

`ifdef COEXTDIO
            /* for Junction Diode Model */
`else
            `BINNING(UC_JS0D, JS0D, LJS0D, WJS0D, PJS0D)
            `BINNING(UC_JS0SWD, JS0SWD,  LJS0SWD, WJS0SWD, PJS0SWD)
            `BINNING(UC_NJD, NJD, LNJD, WNJD, PNJD)
            `BINNING(UC_CISBKD, CISBKD, LCISBKD, WCISBKD, PCISBKD)
            `BINNING(UC_VDIFFJD, VDIFFJD, LVDIFFJD, WVDIFFJD, PVDIFFJD)
            `BINNING(UC_JS0S, JS0S, LJS0S, WJS0S, PJS0S)
            `BINNING(UC_JS0SWS, JS0SWS,  LJS0SWS, WJS0SWS, PJS0SWS)
            `BINNING(UC_NJS, NJS, LNJS, WNJS, PNJS)
            `BINNING(UC_CISBKS, CISBKS, LCISBKS, WCISBKS, PCISBKS)
            `BINNING(UC_VDIFFJS, VDIFFJS, LVDIFFJS, WVDIFFJS, PVDIFFJS)
`endif /* End of COEXTDIO */

        // Check the binned parameters
        if (NSUBC     != UC_NSUBC) `RANGECHECKFoo( UC_NSUBC    ,  0.0, `inf, "NSUBC@binned")
            if (MUESTI1   != UC_MUESTI1) `RANGECHECKFco( UC_MUESTI1  ,  0.0, `inf, "MUESTI1@binned")
                if (NSUBPSTI1 != UC_NSUBPSTI1) `RANGECHECKFco( UC_NSUBPSTI1,  0.0, `inf, "NSUBPSTI1@binned")
                    if (FATAL_flag) $error(" *** Fatal(HiSIM_HV:%M): Range check of instance parameters failed.\n"); //$finish(0);

        //L-scaling (instance dependent)
        // LG scaling just as in hisim2
        // LG = Lgate * `C_m2um ;

        if ( UC_CODEP != 0 ) begin
            // LG dependence NDEPM  20170913
            T3 = pow( LG, NDEPMLP ) ;
            UC_NDEPM = UC_NDEPM*(1.0+NDEPML/T3) ;
            if ( UC_NDEPM < 1e21 ) UC_NDEPM = 1e21 ; // 1e15 (CGS)

            // LG dependence DEPVMAX
            T3 = pow( LG,  DEPVMAXLP ) ;
            UC_DEPVMAX = UC_DEPVMAX * (1.0 + DEPVMAXL / T3) ;

            //LG dependence DEPLEAK
            T3 = pow( LG,  DEPLEAKLP ) ;
            UC_DEPLEAK = DEPLEAK * (1.0 + DEPLEAKL / T3) ;
            if ( UC_DEPLEAK < 0.0 ) UC_DEPLEAK = 0.0 ;

            // LG dependence DEPMUE0 & DEPMUE1
            T3 = pow( LG,  DEPMUE0LP ) ;
            UC_DEPMUE0 = DEPMUE0 * (1.0 + DEPMUE0L / T3) ;
            if ( UC_DEPMUE0 < 1.0 ) UC_DEPMUE0 = 1.0 ;
            T3 = pow( LG,  DEPMUE1LP ) ;
            UC_DEPMUE1 = DEPMUE1 * (1.0 + DEPMUE1L / T3) ;
            if ( UC_DEPMUE1 < 0.0 ) UC_DEPMUE1 = 0.0 ;

            // LG dependence DEPMUEBACK0 & DEPMUEBACK1  (CODEP=1 only)
            T3 = pow( LG,  DEPMUEBACK0LP ) ;
            UC_DEPMUEBACK0 = DEPMUEBACK0 * (1.0 + DEPMUEBACK0L / T3) ;
            if ( UC_DEPMUEBACK0 < 0.0 ) UC_DEPMUEBACK0 = 0.0 ;
            T3 = pow( LG,  DEPMUEBACK1LP ) ;
            UC_DEPMUEBACK1 = DEPMUEBACK1 * (1.0 + DEPMUEBACK1L / T3) ;
            if ( UC_DEPMUEBACK1 < 0.0 ) UC_DEPMUEBACK1 = 0.0 ;

            // LG dependence DEPVDSEF1 & DEPVDSEF2  (CODEP=1 only)
            T3 = pow( LG,  DEPVDSEF1LP ) ;
            UC_DEPVDSEF1 = UC_DEPVDSEF1 * (1.0 + DEPVDSEF1L / T3) ;
            T3 = pow( LG,  DEPVDSEF2LP ) ;
            UC_DEPVDSEF2 = UC_DEPVDSEF2 * (1.0 + DEPVDSEF2L / T3) ;
            if ( UC_DEPVDSEF2 < 0.1 ) UC_DEPVDSEF2 = 0.1 ;

        end else begin // if ( UC_CODEP != 0 )
            UC_NDEPM=0.0;
            UC_DEPVMAX=0.0;
            UC_DEPLEAK=0.0;
            UC_DEPMUE0=0.0;
            UC_DEPMUE1=0.0;
            UC_DEPMUEBACK0=0.0;
            UC_DEPMUEBACK1=0.0;
            UC_DEPVDSEF1=0.0;
            UC_DEPVDSEF2=0.0;
        end

        //-----------------------------------------------------------*
        //* Range check of model parameters
        //*-----------------//

        if (COERRREP) begin
            if ( UC_VMAX < 1.0e6 || UC_VMAX > 20.0e6 ) $write("warning(HiSIM_HV(%m)): (VMAX = %g) range [1.0e6 , 20.0e6].\n",UC_VMAX);
            if ( UC_BGTMP1 < 50.0e-6 || UC_BGTMP1 > 1.0e-3 ) $write("warning(HiSIM_HV(%m)): (BGTMP1 = %g) range [50.0e-6 , 1.0e-3].\n",UC_BGTMP1);
            if ( UC_BGTMP2 < -1.0e-6 || UC_BGTMP2 > 1.0e-6 ) $write("warning(HiSIM_HV(%m)): (BGTMP2 = %g) range [-1.0e-6 , 1.0e-6].\n",UC_BGTMP2);
            if ( UC_EG0  < 1.0   || UC_EG0  > 1.3 ) $write("warning(HiSIM_HV(%m)): (EG0 = %g) range [1.0 , 1.3].\n",UC_EG0);
            if ( UC_VFBOVER < -1.2  || UC_VFBOVER > 1.0  ) $write("warning(HiSIM_HV(%m)): (VFBOVER = %g) range [-1.2 , 1.0].\n",UC_VFBOVER);
            if ( UC_CODEP == 0 ) begin
                if ( UC_VFBC < -1.2  || UC_VFBC > 0.0 ) $write("warning(HiSIM_HV(%m)): (VFBC = %g) range [-1.2 , -0.0].\n",UC_VFBC);
            end else begin
                if ( UC_VFBC < -1.2  || UC_VFBC > 0.8 ) $write("warning(HiSIM_HV(%m)): (VFBC = %g) range [-1.2 , 0.8].\n",UC_VFBC);
            end
            if ( UC_NSUBC < 1.0e16 || UC_NSUBC > 1.0e19 ) $write("warning(HiSIM_HV(%m)): (NSUBC = %g) range [1.0e16 , 1.0e19].\n",UC_NSUBC);
            if ( UC_NSUBP < 1.0e16 || UC_NSUBP > 1.0e19 ) $write("warning(HiSIM_HV(%m)): (NSUBP = %g) range [1.0e16 , 1.0e19].\n",UC_NSUBP);
            if ( UC_SCP1 < 0.0   || UC_SCP1 > 10.0 ) $write("warning(HiSIM_HV(%m)): (SCP1 = %g) range [0.0 , 10.0].\n",UC_SCP1);
            if ( UC_SCP2 < 0.0   || UC_SCP2 > 1.0 ) $write("warning(HiSIM_HV(%m)): (SCP2 = %g) range [0.0 , 1.0].\n",UC_SCP2);
            if ( UC_SCP3 < 0.0   || UC_SCP3 > 200e-9 ) $write("warning(HiSIM_HV(%m)): (SCP3 = %g) range [0.0 , 200e-9].\n",UC_SCP3);
            if ( UC_SC1  < 0.0   || UC_SC1  > 10.0 ) $write("warning(HiSIM_HV(%m)): (SC1 = %g) range [0.0 , 10.0].\n",UC_SC1);
            if ( UC_SC2  < 0.0   || UC_SC2  > 1.0 ) $write("warning(HiSIM_HV(%m)): (SC2 = %g) range [0.0 , 1.0].\n",UC_SC2);
            if ( UC_SC3  < 0.0   || UC_SC3  > 20e-6 ) $write("warning(HiSIM_HV(%m)): (SC3 = %g) range [0.0 , 20e-6].\n",UC_SC3);
            if ( UC_PGD1 < 0.0   || UC_PGD1 > 30.0e-3 ) $write("warning(HiSIM_HV(%m)): (PGD1 = %g) range [0.0 , 30.0e-3].\n",UC_PGD1);
            if ( UC_NDEP < 0.0   || UC_NDEP > 1.0 ) $write("warning(HiSIM_HV(%m)): (NDEP = %g) range [0.0 , 1.0].\n",UC_NDEP);
            if ( UC_NINV < 0.0   || UC_NINV > 1.0 ) $write("warning(HiSIM_HV(%m)): (NINV = %g) range [0.0 , 1.0].\n",UC_NINV);
            if ( UC_MUECB0 < 100.0 || UC_MUECB0 > 100.0e3 ) $write("warning(HiSIM_HV(%m)): (MUECB0 = %g) range [100.0 , 100.0e3].\n",UC_MUECB0);
            if ( UC_MUECB1 < 5.0   || UC_MUECB1 > 10.0e3 ) $write("warning(HiSIM_HV(%m)): (MUECB1 = %g) range [5.0 , 10.0e3].\n",UC_MUECB1);
            if ( UC_MUEPH1 < 2.0e3 || UC_MUEPH1 > 30.0e3 ) $write("warning(HiSIM_HV(%m)): (MUEPH1 = %g) range [2.0e3 , 30.0e3].\n",UC_MUEPH1);
            if ( UC_VTMP < -2.0  || UC_VTMP > 1.0 ) $write("warning(HiSIM_HV(%m)): (VTMP = %g) range [-2.0 , 1.0].\n",UC_VTMP);
            if ( UC_MUESR1 < 1.0e14 || UC_MUESR1 > 1.0e16 ) $write("warning(HiSIM_HV(%m)): (MUESR1 = %g) range [1.0e14 , 1.0e16].\n",UC_MUESR1);
            if ( UC_MUETMP < 0.5   || UC_MUETMP > 2.5 ) $write("warning(HiSIM_HV(%m)): (MUETMP = %g) range [0.5 , 2.5].\n",UC_MUETMP);
            if ( UC_CLM1 < 0.01  || UC_CLM1 > 1.0 ) $write("warning(HiSIM_HV(%m)): (CLM1 = %g) range [0.01 , 1.0].\n",UC_CLM1);
            if ( UC_CLM2 < 1.0   || UC_CLM2 > 4.0 ) $write("warning(HiSIM_HV(%m)): (CLM2 = %g) range [1.0 , 4.0].\n",UC_CLM2);
            if ( UC_CLM3 < 0.5   || UC_CLM3 > 5.0 ) $write("warning(HiSIM_HV(%m)): (CLM3 = %g) range [0.5 , 5.0].\n",UC_CLM3);
            if ( UC_WFC  < -5.0e-15 || UC_WFC  > 1.0e-6 ) $write("warning(HiSIM_HV(%m)): (WFC = %g) range [-5.0e-15 , 1.0e-6].\n",UC_WFC);
            if ( UC_CGSO < 0.0   || UC_CGSO > 100e-9*`C_VAC*KAPPA/TOX ) $write("warning(HiSIM_HV(%m)): (CGSO = %g) range [0.0 , 100e-9*`C_VAC*KAPPA/TOX].\n",UC_CGSO);
            if ( UC_CGDO < 0.0   || UC_CGDO > 100e-9*`C_VAC*KAPPA/TOX ) $write("warning(HiSIM_HV(%m)): (CGDO = %g) range [0.0 , 100e-9*`C_VAC*KAPPA/TOX].\n",UC_CGDO);
            if ( UC_IBPC1 < 0.0   || UC_IBPC1 > 1.0e12 ) $write("warning(HiSIM_HV(%m)): (IBPC1 = %g) range [0.0 , 1.0e12].\n",UC_IBPC1);
            if ( UC_IBPC2 < 0.0   || UC_IBPC2 > 1.0e12 ) $write("warning(HiSIM_HV(%m)): (IBPC2 = %g) range [0.0 , 1.0e12].\n",UC_IBPC2);
            if ( UC_CVDSOVER < 0.0   || UC_CVDSOVER > 1.0 ) $write("warning(HiSIM_HV(%m)): (CVDSOVER = %g) range [0.0 , 1.0].\n",UC_CVDSOVER);
            if ( UC_CVDSOVER != 0.0 && COTRENCH != 0) $write("warning(HiSIM_HV(%m)): non-zero CVDSOVER(%g) does not work for COTRENCH(%g) != 0", UC_CVDSOVER,COTRENCH); // 2.4.0
            if ( UC_NSTI < 1.0e16 || UC_NSTI > 1.0e19 ) $write("warning(HiSIM_HV(%m)): (NSTI = %g) range [1.0e16 , 1.0e19].\n",UC_NSTI);
            `MINCHECK(  UC_CGBO,       0.0,           "CGBO")
            if ( UC_NPEXT < 1.0e16 || UC_NPEXT > 1.0e18 ) $write("warning(HiSIM_HV(%m)): (NPEXT = %g) range [1.0e16 , 1.0e18].\n",UC_NPEXT);
            if ( UC_RD   < 0.0   || UC_RD   > 100.0e-3 ) $write("warning(HiSIM_HV(%m)): (RD = %g) range [0.0 , 100.0e-3].\n",UC_RD);
            if ( UC_RD22 < -5.0  || UC_RD22 > 0.0 ) $write("warning(HiSIM_HV(%m)): (RD22 = %g) range [-5.0 , 0.0].\n",UC_RD22);
            if ( UC_RD23 < 0.0   || UC_RD23 > 2.0 ) $write("warning(HiSIM_HV(%m)): (RD23 = %g) range [0.0 , 2.0].\n",UC_RD23);
            if ( UC_RD24 < 0.0   || UC_RD24 > 0.1 ) $write("warning(HiSIM_HV(%m)): (RD24 = %g) range [0.0 , 0.1].\n",UC_RD24);
            if ( UC_RDICT1 < -10.0 || UC_RDICT1 > 10.0 ) $write("warning(HiSIM_HV(%m)): (RDICT1 = %g) range [-10.0 , 10.0].\n",UC_RDICT1);
            if ( UC_RDOV13 < 0.0   || UC_RDOV13 > 1.0 ) $write("warning(HiSIM_HV(%m)): (RDOV13 = %g) range [0.0 , 1.0].\n",UC_RDOV13);
            if ( UC_RDSLP1 < -10.0 || UC_RDSLP1 > 10.0 ) $write("warning(HiSIM_HV(%m)): (RDSLP1 = %g) range [-10.0 , 10.0].\n",UC_RDSLP1);
            if ( UC_RDVB < 0.0   || UC_RDVB > 2.0 ) $write("warning(HiSIM_HV(%m)): (RDVB = %g) range [0.0 , 2.0].\n",UC_RDVB);
            if ( UC_RDVD < 0.0   || UC_RDVD > 2.0  ) $write("warning(HiSIM_HV(%m)): (RDVD = %g) range [0.0 , 2.0].\n",UC_RDVD);
            `MINCHECK(  UC_RDVG11,     0.0,           "RDVG11")
            if ( UC_RS   < 0.0   || UC_RS   > 10.0e-3 ) $write("warning(HiSIM_HV(%m)): (RS = %g) range [0.0 , 10.0e-3].\n",UC_RS);
            if ( UC_RTH0 < 0.0   || UC_RTH0 > 10.0 ) $write("warning(HiSIM_HV(%m)): (RTH0 = %g) range [0.0 , 10.0].\n",UC_RTH0);
            if ( UC_VOVER < 0.0   || UC_VOVER > 4.0  ) $write("warning(HiSIM_HV(%m)): (VOVER = %g) range [0.0 , 4.0].\n",UC_VOVER);
        end
        if ( UC_XPDV * UC_XLDLD > 1 ) begin
            UC_XPDV = 1/UC_XLDLD ;
        end
        `RANGECHECK(UC_POWRAT, 0.0, 1.0, "POWRAT")

        //if( CORDRIFT && UC_NOVER == 0.0 ) begin
        //  $write("warning(HiSIM_HV(%m)): CORDRIFT has been inactivated when NOVER = 0.0.\n");
        //  UC_CORDRIFT = 0 ;
        //end

        if ( CORDRIFT == 1 && ( (CORD > 0 && UC_NOVER == 0.0) || (CORS > 0 && UC_NOVERS == 0.0) ) ) begin
            $write("warning(HiSIM_HV(%m)): new resistance model has been inactivated. Falls back on to legacy resistance model.\n");
            UC_CORDRIFT = 0;
        end else begin
            UC_CORDRIFT = CORDRIFT ;
        end
        if ( UC_CORDRIFT == 1  ) begin
            flg_rd = (CORD > 0) ? 1:0;
            flg_rs = (CORS > 0) ? 1:0;
        end else begin // UC_CORDRIFT == 0
            if ( CORSRD == 0 || CORSRD == 2 ) begin
                flg_rd = 0;
                flg_rs = 0;
            end else begin // CORSRD == 1 || CORSRD == 3
                T1 = RSH*NRD*NF + (UC_RD + UC_RDVD)*(LDRIFT1 * UC_RDSLP1 * `C_m2um + UC_RDICT1 )*
                 ( LDRIFT2 * RDSLP2 * `C_m2um + RDICT2 );
                flg_rd = (T1 > 0.0) ? 1:0 ;
                T1 = RSHS*NRS*NF + UC_RS *(LDRIFT1S * UC_RDSLP1 * `C_m2um + UC_RDICT1 )*
                 ( LDRIFT2S * RDSLP2 * `C_m2um + RDICT2 );
                flg_rs = (T1 > 0.0) ? 1:0 ;
            end
        end

        //-----------------------------------------------------------*
        //* Change unit into MKS for instance parameters.
        //*-----------------//
        MKS_NSUBCDFM  = NSUBCDFM / `C_cm2m_p3 ;
        MKS_SUBLD2    = SUBLD2   * `C_m2cm ;
        UC_NSUBC      = UC_NSUBC  / `C_cm2m_p3 ;
        UC_NSUBP      = UC_NSUBP  / `C_cm2m_p3 ;
        UC_NSTI       = UC_NSTI   / `C_cm2m_p3 ;
        UC_NOVER      = UC_NOVER  / `C_cm2m_p3 ;
        UC_NOVERS     = UC_NOVERS / `C_cm2m_p3 ;
        UC_NSUBPSTI1  = UC_NSUBPSTI1 / `C_m2cm ;
        UC_MUESTI1    = UC_MUESTI1 / `C_m2cm ;
        UC_VMAX       = UC_VMAX   / `C_m2cm ;
        UC_WFC        = UC_WFC    * `C_m2cm_p2 ;
        UC_GLKSD1     = UC_GLKSD1 / `C_m2cm ;
        UC_GLKSD2     = UC_GLKSD2 * `C_m2cm ;
        UC_GLEAK2     = UC_GLEAK2 * `C_m2cm ;
        UC_GLKB2      = UC_GLKB2  * `C_m2cm ;
        UC_FN2        = UC_FN2    * `C_m2cm ;
        UC_GIDL1      = UC_GIDL1  / `C_m2cm_p1o2 ;
        UC_GIDL2      = UC_GIDL2  * `C_m2cm ;
        UC_NFALP      = UC_NFALP  / `C_m2cm ;
        UC_NFTRP      = UC_NFTRP  * `C_m2cm_p2 ;
        UC_NPEXT      = UC_NPEXT  / `C_cm2m_p3 ;
        UC_RD22       = UC_RD22   / `C_m2cm ;
        UC_RD23       = UC_RD23   / `C_m2cm ;
        UC_RD24       = UC_RD24   / `C_m2cm ;
        UC_RDVD       = UC_RDVD   / `C_m2cm ;
        UC_RTH0       = UC_RTH0   / `C_m2cm ;
        UC_VFBOVER    = -UC_VFBOVER ; // for Backward Compatibility //
        UC_DEPVMAX    = UC_DEPVMAX   / `C_m2cm ;

        flg_nqs = CONQS ;
        flg_qy = ( XQY != 0.0 || XQY1 != 0.0 ) ? 1 : 0 ;

        if (INFO >= 4) begin
            $write("//******* DEVICE PARAMETERS ***********//\n");
            $write("  L          = %12.5e  W          = %12.5e\n",L       ,W );
            $write("  NRD        = %12.5e  NRS        = %12.5e  NGCON      = %12.5e\n",NRD     ,NRS    ,NGCON);
            $write("  XGW        = %12.5e  XGL        = %12.5e  NSUBCDFM   = %12.5e\n",XGW     ,XGL    ,NSUBCDFM);
            $write("  SA         = %12.5e  SB         = %12.5e  SD         = %12.5e\n",SA      ,SB     ,SD);
            $write("  LOVER      = %12.5e  LOVERLD    = %12.5e\n",                     LOVER   ,LOVERLD);
            $write("  LDRIFT1    = %12.5e  LDRIFT2    = %12.5e  LDRIFT1S   = %12.5e\n",LDRIFT1 ,LDRIFT2,LDRIFT1S);
            $write("  LDRIFT2S   = %12.5e  SUBLD1     = %12.5e  SUBLD2     = %12.5e\n",LDRIFT2S,SUBLD1 ,SUBLD2);
            $write("  NF         = %12.5e  M          = %12.5e  DTEMP      = %12.5e\n",NF      ,mMod   ,DTEMP);

`ifdef COEXTDIO
                /* for Junction Diode Model */
`else
                $write("  AD         = %12.5e  PD         = %12.5e\n",AD      ,PD);
                $write("  AS         = %12.5e  PS         = %12.5e\n",AS      ,PS);
`endif /* End of COEXTDIO */

            $write("//******* FLAG PARAMETERS *************//\n");
            $write("  CORSRD     = %d  CORG       = %d  COIPRV     = %d\n",UC_CORSRD ,CORG   ,COIPRV);
            $write("  CORG       = %d  COIPRV     = %d\n",CORG   ,COIPRV);
            $write("  COPPRV     = %d  COADOV     = %d  COISUB     = %d\n",COPPRV ,COADOV ,COISUB);
            $write("  COIIGS     = %d  COGIDL     = %d  COOVLP     = %d\n",COIIGS ,COGIDL ,COOVLP);
            $write("  COOVLPS    = %d  COFLICK    = %d  COISTI     = %d\n",COOVLPS,COFLICK,COISTI);
            $write("  CONQS      = %d  COTHRML    = %d  COIGN      = %d\n",CONQS  ,COTHRML,COIGN);
            $write("  CODFM      = %d  CORBNET    = %d  COSELFHEAT = %d\n",CODFM  ,CORBNET,COSELFHEAT);
            $write("  COSYM      = %d  COSUBNODE  = %d  CORDRIFT   = %d\n",COSYM  ,COSUBNODE, UC_CORDRIFT);
            $write("//******* TECHNOLOGY PARAMETERS *******//\n");
            $write("  VERSION    = %-12.2f  TYPE       = %d   \n",VERSION,TYPE );
            $write("  VMAX       = %12.5e  VMAXT1     = %12.5e  VMAXT2     = %12.5e\n",VMAX   ,VMAXT1 ,VMAXT2);
            $write("  BGTMP1     = %12.5e  BGTMP2     = %12.5e  TNOM       = %12.5e\n",BGTMP1 ,BGTMP2 ,TNOM);
            $write("  EG0        = %12.5e  TOX        = %12.5e  XLD        = %12.5e\n",EG0    ,TOX    ,XLD);
            $write("  RDOV11     = %12.5e  RDOV12     = %12.5e  RDOV13     = %12.5e\n",RDOV11 ,RDOV12 ,RDOV13);//HV1
            $write("  RDSLP1     = %12.5e  RDICT1     = %12.5e  RDSLP2     = %12.5e\n",RDSLP1 ,RDICT1 ,RDSLP2);//HV1
            $write("  RDICT2     = %12.5e\n",RDICT2); //HV1
            $write("  DDLTMAX    = %12.5e\n",DDLTMAX);
            $write("  DDLTSLP    = %12.5e  DDLTICT    = %12.5e  VFBOVER    = %12.5e\n",DDLTSLP,DDLTICT,VFBOVER);
            $write("  NOVER      = %12.5e  NOVERS     = %12.5e  XWD        = %12.5e\n",NOVER  ,NOVERS ,XWD);
            $write("  XWDC       = %12.5e  XWDLD      = %12.5e                     \n",XWDC   ,XWDLD  );
            $write("  XL         = %12.5e  XW         = %12.5e  SAREF      = %12.5e\n",XL     ,XW     ,SAREF);
            $write("  SBREF      = %12.5e  LL         = %12.5e  LLD        = %12.5e\n",SBREF  ,LL     ,LLD);
            $write("  LLN        = %12.5e  WL         = %12.5e  WL1        = %12.5e\n",LLN    ,WL     ,WL1);
            $write("  WL1P       = %12.5e  WL2        = %12.5e  WL2P       = %12.5e\n",WL1P   ,WL2    ,WL2P);
            $write("  WLD        = %12.5e  WLN        = %12.5e  RSH        = %12.5e\n",WLD    ,WLN    ,RSH);
            $write("  RSHG       = %12.5e  XQY        = %12.5e  XQY1       = %12.5e\n",RSHG   ,XQY    ,XQY1);
            $write("  XQY2       = %12.5e\n", XQY2);
            $write("  RS         = %12.5e\n",RD     ,RS); //HV1
            $write("  VFBC       = %12.5e  VBI        = %12.5e  NSUBC      = %12.5e\n",VFBC   ,VBI    ,NSUBC);
            $write("  PARL2      = %12.5e  LP         = %12.5e  NSUBP      = %12.5e\n",PARL2  ,LP     ,NSUBP);
            $write("  NSUBP0     = %12.5e  NSUBWP     = %12.5e  SCP1       = %12.5e\n",NSUBP0 ,NSUBWP ,SCP1);
            $write("  SCP2       = %12.5e  SCP3       = %12.5e  SC1        = %12.5e\n",SCP2   ,SCP3   ,SC1);
            $write("  SC2        = %12.5e  SC3        = %12.5e  SC4        = %12.5e\n",SC2    ,SC3    ,SC4);
            $write("  PGD1       = %12.5e  PGD2       = %12.5e                     \n",PGD1   ,PGD2   );
            $write("  PGD4       = %12.5e  NDEP       = %12.5e  NDEPL      = %12.5e\n",PGD4   ,NDEP   ,NDEPL);
            $write("  NDEPLP     = %12.5e  NINV       = %12.5e  MUECB0     = %12.5e\n",NDEPLP ,NINV   ,MUECB0);
            $write("  MUECB1     = %12.5e  MUEPH0     = %12.5e  MUEPH1     = %12.5e\n",MUECB1 ,MUEPH0 ,MUEPH1);
            $write("  MUEPHW     = %12.5e  MUEPWP     = %12.5e  MUEPHL     = %12.5e\n",MUEPHW ,MUEPWP ,MUEPHL);
            $write("  MUEPLP     = %12.5e  MUEPHS     = %12.5e  MUEPSP     = %12.5e\n",MUEPLP ,MUEPHS ,MUEPSP);
            $write("  VTMP       = %12.5e  WVTH0      = %12.5e  MUESR0     = %12.5e\n",VTMP   ,WVTH0  ,MUESR0);
            $write("  MUESR1     = %12.5e  MUESRL     = %12.5e  MUESRW     = %12.5e\n",MUESR1 ,MUESRL ,MUESRW);
            $write("  MUESWP     = %12.5e  MUESLP     = %12.5e  MUETMP     = %12.5e\n",MUESWP ,MUESLP ,MUETMP);
            $write("  BB         = %12.5e  SUB1       = %12.5e  SUB2       = %12.5e\n",BB     ,SUB1   ,SUB2);
            $write("  SVGS       = %12.5e  SVBS       = %12.5e  SVBSL      = %12.5e\n",SVGS   ,SVBS   ,SVBSL);
            $write("  SVDS       = %12.5e  SLG        = %12.5e  SUB1L      = %12.5e\n",SVDS   ,SLG    ,SUB1L);
            $write("  SUB2L      = %12.5e  FN1        = %12.5e  FN2        = %12.5e\n",SUB2L  ,FN1    ,FN2);
            $write("  FN3        = %12.5e  FVBS       = %12.5e  SVGSL      = %12.5e\n",FN3    ,FVBS   ,SVGSL);
            $write("  SVGSLP     = %12.5e  SVGSWP     = %12.5e  SVGSW      = %12.5e\n",SVGSLP ,SVGSWP ,SVGSW);
            $write("  SVBSLP     = %12.5e  SLGL       = %12.5e  SLGLP      = %12.5e\n",SVBSLP ,SLGL   ,SLGLP);
            $write("  SUB1LP     = %12.5e  NSTI       = %12.5e  WSTI       = %12.5e\n",SUB1LP ,NSTI   ,WSTI);
            $write("  WSTIL      = %12.5e  WSTILP     = %12.5e  WSTIW      = %12.5e\n",WSTIL  ,WSTILP ,WSTIW);
            $write("  WSTIWP     = %12.5e  SCSTI1     = %12.5e  SCSTI2     = %12.5e\n",WSTIWP ,SCSTI1 ,SCSTI2);
            $write("  VTHSTI     = %12.5e  VDSTI      = %12.5e  MUESTI1    = %12.5e\n",VTHSTI ,VDSTI  ,MUESTI1);
            $write("  MUESTI2    = %12.5e  MUESTI3    = %12.5e  NSUBPSTI1  = %12.5e\n",MUESTI2,MUESTI3,NSUBPSTI1);
            $write("  NSUBPSTI2  = %12.5e  NSUBPSTI3  = %12.5e  LPEXT      = %12.5e\n",NSUBPSTI2,NSUBPSTI3,LPEXT);
            $write("  NPEXT      = %12.5e  SCP21      = %12.5e  SCP22      = %12.5e\n",NPEXT  ,SCP21  ,UC_SCP22);
            $write("  BS1        = %12.5e  BS2        = %12.5e  TPOLY      = %12.5e\n",BS1    ,BS2    ,TPOLY);
            $write("  CGBO       = %12.5e  CLM1       = %12.5e  CLM2       = %12.5e\n",CGBO   ,CLM1   ,CLM2);
            $write("  CLM3       = %12.5e  CLM5       = %12.5e  CLM6       = %12.5e\n",CLM3   ,CLM5   ,CLM6);
            $write("  VOVER      = %12.5e  VOVERP     = %12.5e  WFC        = %12.5e\n",VOVER  ,VOVERP ,WFC);
            $write("  NSUBCW     = %12.5e  NSUBCWP    = %12.5e  QME1       = %12.5e\n",NSUBCW ,NSUBCWP,QME1);
            $write("  QME2       = %12.5e  QME3       = %12.5e  VOVERS     = %12.5e\n",QME2   ,QME3   ,VOVERS);
            $write("  VOVERSP    = %12.5e  GIDL1      = %12.5e  GIDL2      = %12.5e\n",VOVERSP,GIDL1  ,GIDL2);
            $write("  GIDL3      = %12.5e  GIDL4      = %12.5e  GIDL5      = %12.5e\n",GIDL3  ,GIDL4  ,GIDL5);
            $write("  GLEAK1     = %12.5e  GLEAK2     = %12.5e  GLEAK3     = %12.5e\n",GLEAK1 ,GLEAK2 ,GLEAK3);
            $write("  GLEAK4     = %12.5e  GLEAK5     = %12.5e  GLEAK6     = %12.5e\n",GLEAK4 ,GLEAK5 ,GLEAK6);
            $write("  GLEAK7     = %12.5e  GLPART1    = %12.5e\n"                     ,GLEAK7 ,GLPART1);
            $write("  GLKSD1     = %12.5e  GLKSD2     = %12.5e  GLKSD3     = %12.5e\n",GLKSD1 ,GLKSD2 ,GLKSD3);
            $write("  GLKB1      = %12.5e  GLKB2      = %12.5e  GLKB3      = %12.5e\n",GLKB1  ,GLKB2  ,GLKB3 );
            $write("  EGIG       = %12.5e  IGTEMP2    = %12.5e  IGTEMP3    = %12.5e\n",EGIG   ,IGTEMP2,IGTEMP3);
            $write("  VZADD0     = %12.5e  PZADD0     = %12.5e  NFTRP      = %12.5e\n",VZADD0 ,PZADD0 ,NFTRP);
            $write("  NFALP      = %12.5e  CIT        = %12.5e  FALPH      = %12.5e\n",NFALP  ,CIT    ,FALPH);
            $write("  KAPPA      = %12.5e  CGDO       = %12.5e  CGSO       = %12.5e\n",KAPPA  ,CGDO   ,CGSO);
            $write("  NINVD      = %12.5e                                          \n",NINVD);
            $write("  NINVDW     = %12.5e  NINVDWP    = %12.5e  NINVDT1    = %12.5e\n",NINVDW ,NINVDWP,NINVDT1);
            $write("  NINVDT2    = %12.5e  RDVB       = %12.5e  VBSMIN     = %12.5e\n",NINVDT2,RDVB   ,VBSMIN); //HV1
            $write("  NINVDT2    = %12.5e  VBSMIN     = %12.5e\n",NINVDT2,VBSMIN);
            $write("  DLY1       = %12.5e  DLY2       = %12.5e  DLY3       = %12.5e\n",DLY1   ,DLY2   ,DLY3);
            $write("  OVSLP      = %12.5e  OVMAG      = %12.5e                     \n",OVSLP  ,OVMAG);
            $write("  RBPB       = %12.5e  RBPD       = %12.5e  RBPS       = %12.5e\n",RBPB   ,RBPD   ,RBPS);
            $write("  IBPC1      = %12.5e  IBPC2      = %12.5e  MPHDFM     = %12.5e\n",IBPC1  ,IBPC2  ,MPHDFM);
            $write("  RDVG11     = %12.5e  RDVG12     = %12.5e  RTH0       = %12.5e\n",RDVG11 ,RDVG12 ,RTH0); //HV1
            $write("  RTH0R      = deleted CTH0       = %12.5e  POWRAT     = %12.5e\n",CTH0   ,POWRAT);
            $write("  DLYOV      = %12.5e  QDFTVD     = deleted XLDLD      = %12.5e\n",DLYOV  ,UC_XLDLD);
            $write("  RDVD       = %12.5e  RD20       = %12.5e                     \n",RDVD   ,RD20);             //HV1
            $write("  RD21       = %12.5e  RD22       = %12.5e  RD22D      = %12.5e\n",RD21   ,RD22   ,RD22D);    //HV1
            $write("  RD23       = %12.5e  RD24       = %12.5e  RD25       = %12.5e\n",RD23   ,RD24   ,RD25);     //HV1
            $write("  RDVDL      = %12.5e  RDVDLP     = %12.5e  RDVDS      = %12.5e\n",RDVDL  ,RDVDLP ,RDVDS);    //HV1
            $write("  RDVDSP     = %12.5e  RD23L      = %12.5e  RD23LP     = %12.5e\n",RDVDSP ,RD23L  ,RD23LP);   //HV1
            $write("  RDS        = %12.5e  RDSP       = %12.5e  RDTEMP1    = %12.5e\n",RDS    ,RDSP   ,RDTEMP1);  //HV1
            $write("  RDTEMP2    = %12.5e  RDVDTEMP1  = %12.5e  RDVDTEMP2  = %12.5e\n",RDTEMP2,RDVDTEMP1,RDVDTEMP2); //HV1
            $write("  RTH0W      = %12.5e  RTH0WP     = %12.5e  RTH0NF     = %12.5e\n",RTH0W  ,RTH0WP ,RTH0NF);
            $write("  RTHTEMP1   = %12.5e  RTHTEMP2   = %12.5e  PRATTEMP1  = %12.5e\n",RTHTEMP1,RTHTEMP2,PRATTEMP1);
            $write("  PRATTEMP2  = %12.5e  RDVSUB     = %12.5e  RDVDSUB    = %12.5e\n",PRATTEMP2,RDVSUB,RDVDSUB); //HV1
            $write("  PRATTEMP2  = %12.5e\n",PRATTEMP2);
            $write("  DDRIFT     = %12.5e  VBISUB     = %12.5e  NSUBSUB    = %12.5e\n",DDRIFT ,VBISUB,NSUBSUB);
            $write("  gminMod    = %12.5e  mMod       = %12.5e  GBMIN      = %12.5e\n",gminMod ,mMod  ,GBMIN);

`ifdef COEXTDIO
                /* for Junction Diode Model */
`else
                $write("  JS0        = %12.5e  JS0SW      = %12.5e  DIVX       = %12.5e\n",JS0    ,JS0SW  ,DIVX);
                $write("  NJ         = %12.5e  NJSW       = %12.5e  XTI        = %12.5e\n",NJ     ,NJSW   ,XTI);
                $write("  CJ         = %12.5e  CJSW       = %12.5e  CJSWG      = %12.5e\n",CJ     ,CJSW   ,CJSWG);
                $write("  MJ         = %12.5e  MJSW       = %12.5e  MJSWG      = %12.5e\n",MJ     ,MJSW   ,MJSWG);
                $write("  PB         = %12.5e  PBSW       = %12.5e  PBSWG      = %12.5e\n",PB     ,PBSW   ,PBSWG);
                $write("  XTI2       = %12.5e  CISB       = %12.5e  CVB        = %12.5e\n",XTI2   ,CISB   ,CVB);
                $write("  CTEMP      = %12.5e  CISBK      = %12.5e  VDIFFJ     = %12.5e\n",CTEMP  ,CISBK  ,VDIFFJ);
                $write("  TCJBD      = %12.5e  TCJBDSW    = %12.5e  TCJBDSWG   = %12.5e\n",TCJBD  ,TCJBDSW ,TCJBDSWG);
                $write("  TCJBS      = %12.5e  TCJBSSW    = %12.5e  TCJBSSWG   = %12.5e\n",TCJBS  ,TCJBSSW ,TCJBSSWG);
                $write("  TPBBD      = %12.5e  TPBBDSW    = %12.5e  TPBBDSWG   = %12.5e\n",TPBBD  ,TPBBDSW ,TPBBDSWG);
                $write("  TPBBS      = %12.5e  TPBBSSW    = %12.5e  TPBBSSWG   = %12.5e\n",TPBBS  ,TPBBSSW ,TPBBSSWG);
`endif /* End of COEXTDIO */

        end // end of printing

        begin   // hsmhvtemp.c

            // Quantum Mechanical Effect //
            if (( QME1 == 0.0 && QME3 == 0.0 ) || QME2 == 0.0 ) begin
                flg_qmetemp = 0 ;
            end else begin
                flg_qmetemp = 1 ;
            end

            begin     // HSMHVinstances
                WLG = WG * LG ;
                UC_GDLD = GDLD * `C_m2um ;

                // Band gap //
                egtnom = UC_EG0 - KTNOM
                  * ( 90.25e-6 + KTNOM * 1.0e-7 ) ;

                // C_EOX //
                cecox = `C_VAC * KAPPA ;

                // Vth reduction for Small Vds //
                msc = UC_SCP22  ;

                // Poly-Si Gate Depletion //
                if ( UC_PGD1 == 0.0 ) begin
                    flg_pgd = 0 ;
                    cnstpgd = 0.0 ;
                end else begin
                    flg_pgd = 1 ;
                    // constant for Poly depletion //
                    cnstpgd = pow( 1e0 + 1e0 / LG , PGD4 ) * UC_PGD1 ;
                end

                // CLM5 & CLM6 //
                clmmod = 1e0 + pow( LG , CLM5 ) * CLM6 ;

                // Half length of diffusion //
                T1 = 1.0 / (SAREF + 0.5 * L)
                + 1.0 / (SBREF + 0.5 * L);
                Lod_half_ref = 2.0 / T1 ;

                if (SA > 0.0 && SB > 0.0 &&
                    (NF == 1.0 || (NF > 1.0 && SD > 0.0))) begin
                    T1 = 0.0;
                    for (i = 0; i < NF; i= i + 1) begin
                        T1 = T1 + 1.0 / (SA + 0.5 * L
                        + i * (SD + L))
                        + 1.0 / (SB + 0.5 * L
                        + i * (SD + L));
                    end
                    Lod_half = 2.0 * NF / T1;
                end else begin
                    Lod_half = 0.0;
                end
                Npexte = UC_NPEXT ;
                EF_MUEPH1 = UC_MUEPH1 ;
                EF_NSUBP  = UC_NSUBP ;
                EF_NSUBC  = UC_NSUBC ;

                // DFM //
                if ( CODFM == 1 && NSUBCDFM_GIVEN ) begin
                    if ( NSUBCDFM <   1.0e16 || NSUBCDFM >   1.0e19) $write("warning(HiSIM_HV(%m)): The parameter NSUBCDFM(= %e) must be in the range [ 1.0e16 , 1.0e19 ].\n",NSUBCDFM);
                    EF_MUEPH1 = EF_MUEPH1 * ( MPHDFM
                       *( ln(MKS_NSUBCDFM) - ln(EF_NSUBC) ) + 1.0 ) ;
                    EF_NSUBP = EF_NSUBP + MKS_NSUBCDFM - EF_NSUBC ;
                    Npexte = Npexte + MKS_NSUBCDFM - EF_NSUBC ;
                    EF_NSUBC = MKS_NSUBCDFM ;
                end

                // Phonon Scattering(temperature-independent part) //
                mueph = EF_MUEPH1
                 * (1.0e0 + (MUEPHW / pow( WG, MUEPWP)))
                 * (1.0e0 + (MUEPHL / pow( LG, MUEPLP)))
                 * (1.0e0 + (MUEPHS / pow( WLG, MUEPSP))) ;

                if (Lod_half > 0.0) begin
                    T1 = 1.0e0 / (1.0e0 + UC_MUESTI2) ;
                    T2 = pow (UC_MUESTI1 / Lod_half, UC_MUESTI3) ;
                    T3 = pow (UC_MUESTI1 / Lod_half_ref, UC_MUESTI3) ;
                    mueph = mueph * (1.0e0 + T1 * T2) / (1.0e0 + T1 * T3);
                end

                // Surface Roughness Scattering //
                muesr = MUESR0
                 * (1.0e0 +(MUESRL / pow(LG, MUESLP)))
                 * (1.0e0 +(MUESRW / pow(WG, MUESWP))) ;

                // Check the Mobility value after L , W and S dependence
                `RANGECHECK(mueph, 2e3 , 30e3 , "MUEPH1@L,W,S dependence")
                `RANGECHECK(muesr, 1.8 , 2.2  , "MUESR0@L,W dependence ")
                mueph = ( mueph < `Small ) ? `Small : mueph ;
                muesr = ( muesr < `Small ) ? `Small : muesr ;

                // Coefficients of Qbm for Eeff //
                T1 = pow( LG, NDEPLP ) ;
                ndep_o_esi = ( UC_NDEP * T1 ) / ( T1 + NDEPL )
                      / `C_ESI ;
                ninv_o_esi = UC_NINV / `C_ESI ;
                ninvd0 = NINVD * ( 1.0 + (NINVDL / pow( LG, NINVDLP)))*( 1.0 + (NINVDW / pow( WG, NINVDWP)));
                T1 = ( 1.0 + (DEPNINVDL / pow( LG, DEPNINVDLP))) * ( 1.0 + (DEPNINVDW / pow( WG, DEPNINVDWP))) ;
                ninvd0cRES = DEPNINVDC * T1 ;
                ninvd0hRES = DEPNINVDH * T1 ;
                // Metallurgical channel geometry //
                dL = XLD  +(MKS_LL / pow(Lgate + LLD, LLN)) ;
                dLLD = UC_XLDLD  +(MKS_LL / pow(Lgate + LLD, LLN)) ;
                dW = XWD  +(MKS_WL / pow(Wgate + WLD, WLN)) ;
                dWLD = XWDLD  +(MKS_WL / pow(Wgate + WLD, WLN)) ;
                dWCV = XWDC  +(MKS_WL / pow(Wgate + WLD, WLN)) ;
                Leff = Lgate - ( dL + dLLD ) ;
                if ( Leff <= 0.0 ) begin
                    $write("Fatal error(HiSIM_HV(%m)): An effective channel length is negative or 0\n");
                    FATAL_flag = 1;
                end

                // Wg dependence for short channel devices //
                lgatesm = Lgate + WL1 / pow( WLG , WL1P ) ;
                dVthsm = UC_WL2 / pow( WLG , WL2P ) ;

                // Lg dependence of wsti //
                T1 = 1.0e0 + WSTIL / pow( lgatesm * `C_m2um  , WSTILP ) ;
                T2 = 1.0e0 + WSTIW / pow( WG , WSTIWP ) ;
                UC_WSTI = UC_WSTI * T1 * T2 ;
                Weff   = Wgate - 2.0e0 * dW ;
                weff_ld = Wgate - 2.0e0 * dWLD ;
                weff_cv = Wgate - 2.0e0 * dWCV ;
                if ( Weff <= 0.0 ) begin
                    $write("Fatal error(HiSIM_HV(%m)): An effective channel width is negative or 0\n");
                    FATAL_flag = 1;
                end
                if ( weff_ld <= 0.0 ) begin
                    $write("Fatal error(HiSIM_HV(%m)): An effective channel width for XWDLD is negative or 0\n");
                    FATAL_flag = 1;
                end
                if ( weff_cv <= 0.0 ) begin
                    $write("Fatal error(HiSIM_HV(%m)): An effective channel width for XWDC is negative or 0\n");
                    FATAL_flag = 1;
                end
                weff_nf = Weff * NF ;
                weffcv_nf = weff_cv * NF ;

                // Surface impurity profile //
                // Note: Sign Changed --> //
                Nsubpp = EF_NSUBP   * ( 1.0e0 + (NSUBP0 / pow(WG, NSUBWP)) ) ;
                EF_NSUBC = EF_NSUBC * ( 1.0e0 + (NSUBCW / pow(WG, NSUBCWP)) ) ;
                T1 = EF_NSUBC * `C_cm2m_p3  ;
                T2 = Nsubpp * `C_cm2m_p3 ;

                // Clamping the minimum value for each parameters
                `MINRESET( T1 , 1e15, "NSUBC@W dependence")
                EF_NSUBC = T1 / `C_cm2m_p3 ;
                `MINRESET( T2 , 1e15, "NSUBP@W dependence")
                Nsubpp = T2 / `C_cm2m_p3 ;

                // <-- Note: Sign Changed //
                if (Lod_half > 0.0) begin
                    T1 = 1.0e0 / (1.0e0 + UC_NSUBPSTI2) ;
                    T2 = pow (UC_NSUBPSTI1 / Lod_half, UC_NSUBPSTI3) ;
                    T3 = pow (UC_NSUBPSTI1 / Lod_half_ref, UC_NSUBPSTI3) ;
                    Nsubps = Nsubpp * (1.0e0 + T1 * T2) / (1.0e0 + T1 * T3) ;
                end else begin
                    Nsubps = Nsubpp ;
                end
                if ( Lgate > LP || LP <= 0.0 ) begin
                    Nsub = (EF_NSUBC * (Lgate - LP)
                    +  Nsubps  * LP) / Lgate ;
                end else begin
                    Nsub = Nsubps
                    + (Nsubps - EF_NSUBC) * (LP - Lgate)
                    / LP ;
                end
                T3 = 0.5e0 * Lgate - LP ;
                `Fn_SL( T3 , T3 , 1E-9 , 1E-10 , T0 )
                T1 = 1.0e0 / ( 1.0e0 / T3 + 1.0e0 / LPEXT ) ;
                T2 = `Fn_Max(0.0e0, T1) ;
                Nsub = Nsub + T2 * (Npexte - EF_NSUBC) / Lgate ;
                q_Nsub   = `C_QE * Nsub ;
                qnsub_esi = q_Nsub * `C_ESI ;
                qnsub_esi2 = 2.0 * qnsub_esi ;

                // Pocket Overlap(temperature-independent part) //
                if ( Lgate <= 2.0e0 * LP && LP > 0 ) begin
                    Nsubb = 2.0e0 * Nsubps
                    - (Nsubps - EF_NSUBC) * Lgate
                    / LP - EF_NSUBC ;
                    ptovr0 = ln (Nsubb / EF_NSUBC) ;
                    // ptovr0 will be divided by beta later. //
                end else begin
                    ptovr0 = 0.0e0 ;
                end

                // costi0 and costi1 for STI transistor model(temperature-independent part) //
                costi00 = sqrt (2.0 * `C_QE * UC_NSTI * `C_ESI ) ;
                nsti_p2 = 1.0 / ( UC_NSTI * UC_NSTI ) ;

                // Velocity Temperature Dependence(Temperature-dependent part will be multiplied later.) //
                vmax0 =(1.0e0 +(UC_VOVER / pow(LG, VOVERP)))
                 *(1.0e0 +(VOVERS / pow(WLG, VOVERSP))) ;

                // 2 phi_B(temperature-independent) //
                // @300K, with pocket //
                Pb20 = 2.0e0 / `C_b300 * ln (Nsub / `C_Nin0) ;
                // @300K, w/o pocket //
                Pb2c = 2.0e0 / `C_b300 * ln (EF_NSUBC / `C_Nin0) ;

                // Gate resistance //
                if ( CORG == 1 ) begin
                    T1 = XGW + Weff / (3.0e0 * NGCON);
                    T2 = Lgate - XGL;
                    grg = RSHG * T1 / (NGCON * T2 * NF);
                    if (grg > 1.0e-3) grg = Mfactor / grg;
                    else begin
                        grg = Mfactor * 1.0e3;
                        $write("warning(HiSIM_HV(%m)): The gate conductance reset to 1.0e3 mho.\n");
                    end
                end else begin
                    grg = 1/RMIN;
                end

                // Process source/drain series resistance //
                if ( RSH > 0.0 ) begin
                    Rd0 = RSH * NRD ;
                    Rs0 = RSH * NRS ;
                end else begin
                    Rd0 = 0.0 ;
                    Rs0 = 0.0 ;
                end
                if ( RSHS > 0.0 ) begin
                    Rs0 = RSHS * NRS ;
                end else Rs0 = 0.0 ;

                if ( UC_CORDRIFT == 0 ) begin // CORDIRFT = 0
                    if ( UC_RD > 0.0 || UC_RS > 0.0 ) begin
                        Rdtemp0 = 1.0 + RDS / pow( WLG , RDSP ) ;
                        if ( UC_RDVD != 0.0 ) begin
                            T7 = ( 1.0 + RDVDS / pow( WLG , RDVDSP ) );
                            T6 = ( - RDVDL * pow( LG , RDVDLP ) ) ;
                            if (T6 > `large_arg) T6 = `large_arg ;
                            T6 = exp( T6 ) ;
                            Rdvdtemp0 = T6 * T7 ;
                        end else begin
                            Rdvdtemp0 = 0.0 ;
                        end
                    end else begin
                        Rdtemp0 = 0.0 ;
                        Rdvdtemp0 = 0.0 ;
                    end
                    if ( UC_RD23 != 0.0 ) begin
                        T2 = ( 1.0 + RD23S / pow( WLG , RD23SP ) );
                        T1 = ( - RD23L * pow( LG , RD23LP ) ) ;
                        if (T1 > `large_arg) T1 = `large_arg ;
                        T1 = exp( T1 ) ;
                        T3 = UC_RD23 * T2 * T1 ;
                        Rd23e = 0.5 * ( T3 + sqrt ( T3 * T3 + 4.0 * `dlt_rd23 * `dlt_rd23 ) ) ;
                    end else begin
                        Rd23e = 0.0 ;
                    end
                    Xmax = 0.0 ;
                    Xmax_s = 0.0 ;
                    Rdrvmaxwe = 0.0 ;
                    Rdrvmaxle = 0.0 ;
                    Rdrmuele = 0.0 ;
                    RdrmueVbs = 0.0;
                end // CORDIRFT = 0
                else begin // CORDIRFT = 1
                    Xmax  = sqrt ( RDRDJUNC * RDRDJUNC + UC_XLDLD * UC_XLDLD ) ;
                    Xmax_s = sqrt( RDRDJUNC * RDRDJUNC + XLD * XLD ) ;   // 20160615 compatibility
                    Rdrvmaxwe = 1.0e0 + (RDRVMAXW / pow( WG, RDRVMAXWP)) ;
                    Rdrvmaxle = 1.0e0 + (RDRVMAXL / pow( LG, RDRVMAXLP)) ;
                    Rdrmuele  = 1.0e0 + (RDRMUEL  / pow( LG, RDRMUELP )) ;
                    RdrmueVbs = 1.0; // see eval_rdrift later
                    Rdtemp0 = 0.0 ;
                    Rdvdtemp0 = 0.0 ;
                    Rd23e = 0.0 ;
                end // CORDIRFT = 1
                if ( UC_NOVER > 0.0 ) begin
                    kdep  = 2.0 * `C_ESI / ( `C_QE * UC_NOVER ) ;
                    kjunc = 2.0 * `C_ESI / `C_QE * EF_NSUBC / ( UC_NOVER + EF_NSUBC ) / UC_NOVER ;
                end else begin
                    kdep = 0.0 ;
                    kjunc = 0.0 ;
                end

                // Body resistance //
                if ( CORBNET == 1 ) begin
                    if (RBPB < 1.0e-3) grbpb = Mfactor * 1.0e3 ;
                    else grbpb = Mfactor * ( GBMIN + 1.0 / RBPB ) ;
                    if (RBPS < 1.0e-3) grbps = Mfactor * 1.0e3 ;
                    else grbps = Mfactor * ( GBMIN + 1.0 / RBPS ) ;
                    if (RBPD < 1.0e-3) grbpd = Mfactor * 1.0e3 ;
                    else grbpd = Mfactor * ( GBMIN + 1.0 / RBPD ) ;
                end else begin
                    grbpb = Mfactor * 1.0e3 ;
                    grbps = grbpb ;
                    grbpd = grbpb ;
                end

                // Vdseff //
                if ( CODDLT == 0 ) begin
                    T1 = DDLTSLP * LG + DDLTICT ;
                    if ( T1 < 0.0 ) begin T1 = 0.0 ; end
                    DDLTe = T1 * DDLTMAX / ( T1 + DDLTMAX ) + 1.0 ;
                end else begin
                    T1 = DDLTSLP * LG ;
                    if ( T1 < 0.0 ) begin T1 = 0.0 ; end
                    DDLTe = T1 * DDLTMAX / ( T1 + DDLTMAX ) + DDLTICT + `Small ;
                end
                `MINRESET( DDLTe , 0.1, "DDLT@L dependence")

                // Isub //
                if ( COISUB ) begin
                    T2 = pow( Weff , SVGSWP ) ;
                    vg2const = UC_SVGS
                      * ( 1.0e0 + MKS_SVGSL / pow( Lgate , SVGSLP ) )
                      * ( T2 / ( T2 + MKS_SVGSW ) ) ;
                    xvbs  = UC_SVBS * ( 1.0 + MKS_SVBSL/ pow( Lgate , SVBSLP ) ) ;
                    xgate = MKS_SLG * ( 1.0 + MKS_SLGL / pow( Lgate , SLGLP ) ) ;
                    xsub1 = UC_SUB1 * ( 1.0 + MKS_SUB1L / pow( Lgate , SUB1LP ) ) ;
                    xsub2 = UC_SUB2 * ( 1.0 + MKS_SUB2L / Lgate ) ;

                    xsub1_ = xsub1;
                    xsub2_ = xsub2;
                    vg2const_ = vg2const;
                    xvbs_  = xvbs;
                    xgate_ = xgate;
                    if ( COSNP ) begin // SVGS
                        //vg2const_ = UC_SVGSSNP * ( 1.0e0 + MKS_SVGSL / pow( Lgate , SVGSLP ) )* ( T2 / ( T2 + MKS_SVGSW ) ) ;
                        xsub1_ = UC_SUB1SNP * ( 1.0 + MKS_SUB1L / pow( Lgate , SUB1LP ) ) ;
                        xsub2_ = UC_SUB2SNP * ( 1.0 + MKS_SUB2L / Lgate ) ;
                        //xvbs_  = UC_SVBSSNP * ( 1.0 + MKS_SVBSL/ pow( Lgate , SVBSLP ) ) ; // 20180413
                    end

                    UC_SUBLD1 = SUBLD1 * ( 1.0 + SUBLD1L / pow( LG , SUBLD1LP ) ) ;
                end else begin
                    vg2const = 0.0 ;
                    xvbs = 0.0 ;
                    xgate = 0.0 ;
                    xsub1 = 0.0 ;
                    xsub2 = 0.0 ;
                    UC_SUBLD1 = 0.0 ;

                    vg2const_ = 0.0;
                    xvbs_ = 0.0;
                    xgate_ = 0.0;
                    xsub1_ = 0.0 ;
                    xsub2_ = 0.0 ;

                end

                // IBPC //
                UC_IBPC1  = ( UC_IBPC1 != 0.0 ) ? UC_IBPC1 * ( 1.0 + IBPC1L  / pow( LG , IBPC1LP ) ) : 0.0 ;

                // Fringing capacitance //
                cfrng = `C_EOX / ( `C_Pi / 2.0e0 ) * weffcv_nf
                 * ln( 1.0e0 + TPOLY / TOX ) ;

                // Additional term of lateral-field-induced capacitance //
                cqyb0 = ( XQY1 != 0.0 ) ? `C_m2um * weffcv_nf
                   * XQY1 / pow( LG , XQY2 ) : 0.0 ;

                // Parasitic component of the channel current //
                ptl0 = PTL * pow( LG        , - PTLP ) ;
                pt40 = PT4 * pow( LG        , - PT4P ) ;
                gdl0 = GDL * pow( LG + UC_GDLD , - GDLP ) ;

                // Self heating //
                RTH = UC_RTH0 / ( Mfactor * weff_nf )
                * ( 1.0 + RTH0L / pow( LG , RTH0LP ) )
                * ( 1.0 + RTH0W / pow( WG , RTH0WP ) );
                CTH = MKS_CTH0 * ( Mfactor * weff_nf ) ;
                RTH = RTH * ( ( 1.0 / pow( NF , RTH0NF ) ) ) ;

                rthtemp0 = 1.0 / pow( NF , RTH0NF ) / ( Mfactor * weff_nf )
                    * ( 1.0 + RTH0L / pow( LG , RTH0LP ) )
                    * ( 1.0 + RTH0W / pow( WG , RTH0WP ) );

                //-----------------------------------------------------------*
                //* Temperature dependent constants.
                //*-----------------//
                if ( COSELFHEAT == 0 || UC_RTH0 == 0.0 ) begin

                    cnst0over = 0.0;
                    cnst0overs= 0.0;

// ---- begin `include "HSMHV_temp_eval.inc" ----
/***********************************************************************

 HiSIM (Hiroshima University STARC IGFET Model)
 Copyright (C) 2000-2016 Hiroshima University and STARC
 Copyright (C) 2016-2023 Hiroshima University
 HiSIM_HV (High-Voltage Model)
 Copyright (C) 2007-2016 Hiroshima University and STARC
 Copyright (C) 2016-2023 Hiroshima University

 MODEL NAME : HiSIM_HV
 ( VERSION : 2  SUBVERSION : 5  REVISION : 1 )
 Model Parameter 'VERSION' : 2.51
 FILE : HSMHV_temp_eval.inc

 Date : 2023.02.09

 released by Hiroshima University

***********************************************************************/
//
////////////////////////////////////////////////////////////////
//
//
//
//
//Licensed under the Educational Community License, Version 2.0
//(the "License"); you may not use this file except in
//compliance with the License.
//
//You may obtain a copy of the License at:
//
//      http://opensource.org/licenses/ECL-2.0
//
//Unless required by applicable law or agreed to in writing,
//software distributed under the License is distributed on an
//"AS IS" BASIS, WITHOUT WARRANTIES OR CONDITIONS OF ANY KIND,
//either express or implied. See the License for the specific
//language governing permissions and limitations under the
//License.
//
//
//The HiSIM_HV standard has been supported by the members of
//Silicon Integration Initiative's Compact Model Coalition. A
//link to the most recent version of this standard can be found
//at:
//
//http://www.si2.org/cmc
//
////////////////////////////////////////////////////////////////
//

TTEMP = $temperature + DTEMP;
TTEMP0 = TTEMP ;
// Self heating //
TTEMP = TTEMP + deltemp ;
Tdiff0 =   TTEMP0 - KTNOM ;
Tdiff0_2 = TTEMP0 * TTEMP0 - KTNOM * KTNOM ;
Tdiff =    TTEMP  - KTNOM ;
Tdiff_2 =  TTEMP  * TTEMP  - KTNOM * KTNOM ;
Tratio = TTEMP / KTNOM ;
log_Tratio = ln(Tratio) ;

// Band gap //
Eg   = egtnom - UC_BGTMP1 * Tdiff - UC_BGTMP2 * Tdiff_2 ;
sqrt_eg = sqrt( Eg ) ;
T1 = 1.0 / TTEMP ;
T2 = 1.0 / KTNOM ;
T3 = egtnom + EGIG
       + IGTEMP2 * ( T1 - T2 )
       + IGTEMP3 * ( T1 * T1 - T2 * T2 ) ;
Egp12 = sqrt ( T3 ) ;
Egp32 = T3 * Egp12 ;

// Inverse of the thermal voltage //
beta   = `C_QE / (`C_KB * TTEMP) ;
beta_inv = 1.0 / beta ;
beta2 = beta * beta ;
betatnom = `C_QE / (`C_KB * KTNOM) ;

// Intrinsic carrier concentration //
Nin   = `C_Nin0 * exp(log_Tratio*1.5e0)
          * exp(- Eg / 2.0e0 * beta + egtnom / 2.0e0 * betatnom) ;

// Phonon Scattering(temperature-dependent part) //
T1 = exp(log_Tratio*UC_MUETMP) ;
mphn0 = T1 / mueph ;

// constant for depletion MOS  //
if ( UC_CODEP != 0 && UC_CODEP < 3 ) begin
    cnst0 = sqrt ( 2.0 * `C_ESI * `C_QE * UC_NDEPM * beta_inv ) ;
    cnst1 = Nin * Nin / UC_NDEPM / UC_NDEPM ;
    Pb2n =  2.0e0 * beta_inv * ln (UC_NDEPM / Nin) ;
    Vbipn = beta_inv * ln(UC_NDEPM * EF_NSUBC /Nin /Nin) ;
    T1 = exp(log_Tratio*DEPMUETMP) ;
    depmphn0 = T1 / UC_DEPMUEPH1 ;
    T0 = 1.8 + 0.4 * Tratio + 0.1 * Tratio * Tratio - DEPVTMP * ( 1.0 - Tratio ) ;
    UC_DEPVMAX = UC_DEPVMAX / T0 ;
    `MINRESET(UC_DEPVMAX , 1E3 , "DEPVMAX@T dependence ")
    // Temp. dependence of DEPMUE0 & DEPMUE2
    UC_DEPMUE0 = UC_DEPMUE0 / pow (Tratio, DEPMUE0TMP) ; // Coulomb(CODEP=1,2)
    UC_DEPMUE2 = UC_DEPMUE2 / pow (Tratio, DEPMUE2TMP) ; // Phonon(CODEP=2)
end else if ( UC_CODEP == 3) begin
    cnst0 = sqrt ( 2.0 * `C_ESI * `C_QE * UC_NDEPM * beta_inv ) ;
    cnst1 = Nin * Nin / UC_NDEPM / UC_NDEPM ;
    Pb2n =  2.0e0 * beta_inv * ln (UC_NDEPM / Nin) ;
    Vbipn = beta_inv * ln(UC_NDEPM * EF_NSUBC /Nin /Nin) ;
    T1 = exp(log_Tratio*DEPMUETMP) ; // revive 20170322
    depmphn0 = T1 / UC_DEPMUEPH1 ;   // revive 20170322
    T0 = 1.8 + 0.4 * Tratio + 0.1 * Tratio * Tratio - DEPVTMP * ( 1.0 - Tratio ) ;
    UC_DEPVMAX = UC_DEPVMAX / T0 ;
    `MINRESET(UC_DEPVMAX , 1E3 , "DEPVMAX@T dependence ")
    // Temp. dependence of DEPMUE0 & DEPMUE2
    UC_DEPMUE0 = UC_DEPMUE0 / pow (Tratio, DEPMUE0TMP) ; // Coulomb scat mobility for resistor (CODEP=3)
    UC_DEPWLP  = DEPWLP + DEPWLPT * ( Tratio - 1.0 ) ;
end else begin
    Pb2n =  0.0 ;
    //    Vbipn = 0.0 ;
    Vbipn = beta_inv * ln(UC_NJUNC/Nin * Nsub/Nin); //  All conc here in 1/m^3.
    depmphn0 = 0.0 ;
end

// Pocket Overlap(temperature-dependent part) //
ptovr = ptovr0 * beta_inv ;

// Velocity Temperature Dependence //
T1 = TTEMP  / KTNOM ;
T0 = 1.8 + 0.4 * T1 + 0.1 * T1 * T1 - UC_VTMP * (1.0 - T1) ;
if ( COTEMP != 2 ) begin // without deltemp(COTEMP=0,1,3) //
    VMAXeff = vmax0 * UC_VMAX
              / T0 * ( 1.0 + VMAXT1 * Tdiff0 + VMAXT2 * Tdiff0_2 ) ;
end else begin // with deltemp(COTEMP=2) //
    VMAXeff = vmax0 * UC_VMAX
              / T0 * ( 1.0 + VMAXT1 * Tdiff + VMAXT2 * Tdiff_2 ) ;
end
`MINCHECK(VMAXeff , 1E3 , "VMAXeff@T dependence ")

if ( COTEMP != 2 ) begin // without deltemp(COTEMP=0,1,3) //
    Ninvde = ninvd0 * ( 1.0 + NINVDT1 * Tdiff0 + NINVDT2 * Tdiff0_2 ) ;
    T1 = 1.0 + DEPNINVDT1 * Tdiff0 + DEPNINVDT2 * Tdiff0_2  ;
    NinvdecRES = ninvd0cRES * T1 ; // for Mu_res
    NinvdehRES = ninvd0hRES * T1 ; // for Mu_res
end else begin // with deltemp(COTEMP=2) //
    Ninvde = ninvd0 * ( 1.0 + NINVDT1 * Tdiff + NINVDT2 * Tdiff_2 ) ;
    T1 = 1.0 + DEPNINVDT1 * Tdiff + DEPNINVDT2 * Tdiff_2  ;
    NinvdecRES = ninvd0cRES * T1 ; // for Mu_res
    NinvdehRES = ninvd0hRES * T1 ; // for Mu_res
end
`MINRESET(Ninvde     , 0 , "NINVD@T dependence ")
`MINRESET(NinvdecRES , 0 , "NINVDCRES@T dependence ")
`MINRESET(NinvdehRES , 0 , "NINVDHRES@T dependence ")

// Temperature Dependence of RTH0 //
if ( COSELFHEAT ) begin
    RTH = ( UC_RTH0 + RTHTEMP1 * Tdiff0 + RTHTEMP2 * Tdiff0_2  ) * rthtemp0 ;
    `MINRESET(RTH , `C_RTH_MIN , "RTH@T dependence ")
end

// Temperature Dependence of POWRAT //
T2 = UC_POWRAT + PRATTEMP1 * Tdiff0 + PRATTEMP2 * Tdiff0_2  ;
`Fn_SL( T2 , T2 , 0 , 0.05 , T0 )
`Fn_SU( powratio , T2 , 1 , 0.05 , T0 )

// 2 phi_B(temperature-dependent) //
// @temp, with pocket //
Pb2 =  2.0e0 * beta_inv * ln (Nsub / Nin) ;

// Depletion Width //
T1 = 2.0e0 * `C_ESI / `C_QE ;
wdpl = sqrt ( T1 / Nsub ) ;
wdplp = sqrt( T1 / ( EF_NSUBP ) ) ;

if ( UC_CODEP == 0 ) begin
    // Coefficient of the F function for bulk charge //
    cnst0 = sqrt ( 2.0 * `C_ESI * `C_QE * Nsub * beta_inv ) ;

    // cnst1: n_{p0} / p_{p0} //
    T1 = Nin / Nsub ;
    cnst1 = T1 * T1 ;
end
if ( UC_CODEP == 0 ) begin
    if ( UC_NOVER != 0.0 ) begin
        cnst0over = cnst0 * sqrt( UC_NOVER / Nsub ) ;
    end
    if ( UC_NOVERS != 0.0 ) begin
        cnst0overs = cnst0 * sqrt( UC_NOVERS / Nsub ) ;
    end
end else begin
    if ( UC_NOVER != 0.0 ) begin
        cnst0over = cnst0 * sqrt( UC_NOVER / UC_NDEPM ) ;
    end
    if ( UC_NOVERS != 0.0 ) begin
        cnst0overs = cnst0 * sqrt( UC_NOVERS / UC_NDEPM ) ;
    end
end

// temperature-dependent resistance model //
if ( UC_CORDRIFT == 0 ) begin
    // drain side //
    if ( UC_RD > 0.0 ) begin
        T2 = Rdtemp0
           * ( LDRIFT1 * UC_RDSLP1 * `C_m2um   + UC_RDICT1 )
           * ( LDRIFT2 * RDSLP2 * `C_m2um   + RDICT2 ) ;

        if ( COTEMP == 1 ) begin // without deltemp(COTEMP=1) //
            Rde = ( UC_RD + MKS_RDTEMP1 * Tdiff0 + MKS_RDTEMP2 * Tdiff0_2 ) * T2 ;
            `Fn_SL( Rde, Rde, `C_rdtemp_min * UC_RD, `C_rdtemp_dlt * UC_RD, T0 )
        end else begin // with deltemp(COTEMP=0,2,3) //
            Rde = ( UC_RD + MKS_RDTEMP1 * Tdiff + MKS_RDTEMP2 * Tdiff_2 ) * T2 ;
            `Fn_SL( Rde, Rde, `C_rdtemp_min * UC_RD, `C_rdtemp_dlt * UC_RD, T0 )
        end
    end else begin
        Rde = 0.0 ;
    end
    // source side(asymmetric case) //
    if ( UC_RS > 0.0 ) begin
        T2 = Rdtemp0
           * ( LDRIFT1S * UC_RDSLP1 * `C_m2um   + UC_RDICT1 )
           * ( LDRIFT2S * RDSLP2 * `C_m2um   + RDICT2 ) ;

        if ( COTEMP == 1 ) begin // without deltemp(COTEMP=1) //
            Rse = ( UC_RS + MKS_RDTEMP1 * Tdiff0 + MKS_RDTEMP2 * Tdiff0_2 ) * T2 ;
            `Fn_SL( Rse, Rse, `C_rdtemp_min * UC_RS, `C_rdtemp_dlt * UC_RS, T0 )
        end else begin // with deltemp(COTEMP=0,2,3) //
            Rse = ( UC_RS + MKS_RDTEMP1 * Tdiff + MKS_RDTEMP2 * Tdiff_2 ) * T2 ;
            `Fn_SL( Rse, Rse, `C_rdtemp_min * UC_RS, `C_rdtemp_dlt * UC_RS, T0 )
        end
    end else begin
        Rse = 0.0 ;
    end
    if ( UC_RDVD > 0.0 ) begin
        T4 = Rdvdtemp0 * ( LDRIFT1 * UC_RDSLP1 * `C_m2um  + UC_RDICT1 )
           * ( LDRIFT2 * RDSLP2 * `C_m2um  + RDICT2 ) ;
        T1 = ( 1 -  UC_RDOV13 ) * LOVERLD * `C_m2um ;
        `Fn_SZ( T2  , RDOV12 , `rdsz_dlt , T0 )
        T8 = - RDOV11 / T2 ;
        T3 = ( T8 * LOVERLD * `C_m2um  + 1.0 + RDOV11 ) ;
        `Fn_SL( T5 , T3 * T4 , T4 , 10.0e-3 , T6 )
        `Fn_SU( T7  , T5    , T4 * ( RDOV11 + 1.0) , 50.0e-6 , T6 )
        `Fn_SL( T2  , T7 + T1 * T4  , 0, 50.0e-6 , T6 )

        if ( COTEMP == 0 || COTEMP == 1 ) begin // without deltemp(COTEMP=0,1) //
            Rdvde = ( UC_RDVD + MKS_RDVDTEMP1 * Tdiff0 + MKS_RDVDTEMP2 * Tdiff0_2 ) * T2 ;
            `Fn_SL( Rdvde, Rdvde, `C_rdtemp_min * UC_RDVD, `C_rdtemp_dlt * UC_RDVD, T0 )
        end else begin // with deltemp(COTEMP=2,3) //
            Rdvde = ( UC_RDVD + MKS_RDVDTEMP1 * Tdiff + MKS_RDVDTEMP2 * Tdiff_2 ) * T2 ;
            `Fn_SL( Rdvde, Rdvde, `C_rdtemp_min * UC_RDVD, `C_rdtemp_dlt * UC_RDVD, T0 )
        end

        T4 = Rdvdtemp0 * ( LDRIFT1S * UC_RDSLP1 * `C_m2um  + UC_RDICT1 )
           * ( LDRIFT2S * RDSLP2 * `C_m2um  + RDICT2 ) ;
        T1 = ( 1 -  UC_RDOV13 ) * LOVERS * `C_m2um ;
        T3 = ( T8 * LOVERS * `C_m2um + 1.0 + RDOV11 ) ;
        `Fn_SL( T5 , T3 * T4 , T4 , 10.0e-3 , T6 )
        `Fn_SU( T7  , T5    , T4 * ( RDOV11 + 1.0) , 50.0e-6 , T6 )
        `Fn_SL( T2  , T7 + T1 * T4  , 0, 50.0e-6 , T6 )

        if ( COTEMP == 0 || COTEMP == 1 ) begin // without deltemp(COTEMP=0,1) //
            Rsvde = ( UC_RDVD + MKS_RDVDTEMP1 * Tdiff0 + MKS_RDVDTEMP2 * Tdiff0_2 ) * T2 ;
            `Fn_SL( Rsvde, Rsvde, `C_rdtemp_min * UC_RDVD, `C_rdtemp_dlt * UC_RDVD, T0 )
        end else begin // with deltemp(COTEMP=2,3) //
            Rsvde = ( UC_RDVD + MKS_RDVDTEMP1 * Tdiff + MKS_RDVDTEMP2 * Tdiff_2 ) * T2 ;
            `Fn_SL( Rsvde, Rsvde, `C_rdtemp_min * UC_RDVD, `C_rdtemp_dlt * UC_RDVD, T0 )
        end
    end else begin
        Rdvde = 0.0 ;
        Rsvde = 0.0 ;
    end
end  // CORDRIFT=0

// costi0 and costi1 for STI transistor model(temperature-dependent part) //
costi0 = costi00 * sqrt(beta_inv) ;
costi0_p2 = costi0 * costi0 ;
costi1 = Nin * Nin * nsti_p2 ;

// Temperature dependence of Breakdown Model //
HBDCeff = HBDC + HBDCTMP * Tdiff ;

// Temperature dependence for Isub Model //
UC_SUBTMP  = SUBTMP ;
`RANGERESET(UC_SUBTMP ,    0.0 ,       5.0e-3 , "SUBTMP"   )

`ifdef _AGING_
    // Temperature dependence for aging model //
    Nt0s_temp  = TRAPTEMP1 * Tdiff + TRAPTEMP2 * Tdiff_2 ;
`endif
// end of HSMHVtemp_eval.h //
// ---- end `include "HSMHV_temp_eval.inc" ----

                    if ( UC_CORDRIFT > 0) begin
// ---- begin `include "HSMHV_temp_eval_rdris.inc" ----
/***********************************************************************

 HiSIM (Hiroshima University STARC IGFET Model)
 Copyright (C) 2000-2016 Hiroshima University and STARC
 Copyright (C) 2016-2023 Hiroshima University
 HiSIM_HV (High-Voltage Model)
 Copyright (C) 2007-2016 Hiroshima University and STARC
 Copyright (C) 2016-2023 Hiroshima University

 MODEL NAME : HiSIM_HV
 ( VERSION : 2  SUBVERSION : 5  REVISION : 1 )
 Model Parameter 'VERSION' : 2.51
 FILE : HSMHV_temp_eval_rdris.inc

 Date : 2023.02.09

 released by Hiroshima University

***********************************************************************/
//
////////////////////////////////////////////////////////////////
//
//
//
//
//Licensed under the Educational Community License, Version 2.0
//(the "License"); you may not use this file except in
//compliance with the License.
//
//You may obtain a copy of the License at:
//
//      http://opensource.org/licenses/ECL-2.0
//
//Unless required by applicable law or agreed to in writing,
//software distributed under the License is distributed on an
//"AS IS" BASIS, WITHOUT WARRANTIES OR CONDITIONS OF ANY KIND,
//either express or implied. See the License for the specific
//language governing permissions and limitations under the
//License.
//
//
//The HiSIM_HV standard has been supported by the members of
//Silicon Integration Initiative's Compact Model Coalition. A
//link to the most recent version of this standard can be found
//at:
//
//http://www.si2.org/cmc
//
////////////////////////////////////////////////////////////////
//

// Phonon Scattering(temperature-dependent part) //
T1 =  `Fn_Pow( Tratio, RDRMUETMPS ) ;
RRDRMUES = MKS_RDRMUES / T1 ;

// Velocity Temperature Dependence //
T0 = 1.8 + 0.4 * Tratio + 0.1 * Tratio * Tratio - RDRVTMPS * ( 1.0 - Tratio ) ;
RRDRVMAXS = MKS_RDRVMAXS / T0 ;

//Toshiba model //
UC_RDRBB_s = UC_RDRBB_s+RDRBBTMPS*(TTEMP-KTNOM) ;

// end of HSMHVtemp_eval_rdri.h //
// ---- end `include "HSMHV_temp_eval_rdris.inc" ----
// ---- begin `include "HSMHV_temp_eval_rdri.inc" ----
/***********************************************************************

 HiSIM (Hiroshima University STARC IGFET Model)
 Copyright (C) 2000-2016 Hiroshima University and STARC
 Copyright (C) 2016-2023 Hiroshima University
 HiSIM_HV (High-Voltage Model)
 Copyright (C) 2007-2016 Hiroshima University and STARC
 Copyright (C) 2016-2023 Hiroshima University

 MODEL NAME : HiSIM_HV
 ( VERSION : 2  SUBVERSION : 5  REVISION : 1 )
 Model Parameter 'VERSION' : 2.51
 FILE : HSMHV_temp_eval_rdri.inc

 Date : 2023.02.09

 released by Hiroshima University

***********************************************************************/
//
////////////////////////////////////////////////////////////////
//
//
//
//
//Licensed under the Educational Community License, Version 2.0
//(the "License"); you may not use this file except in
//compliance with the License.
//
//You may obtain a copy of the License at:
//
//      http://opensource.org/licenses/ECL-2.0
//
//Unless required by applicable law or agreed to in writing,
//software distributed under the License is distributed on an
//"AS IS" BASIS, WITHOUT WARRANTIES OR CONDITIONS OF ANY KIND,
//either express or implied. See the License for the specific
//language governing permissions and limitations under the
//License.
//
//
//The HiSIM_HV standard has been supported by the members of
//Silicon Integration Initiative's Compact Model Coalition. A
//link to the most recent version of this standard can be found
//at:
//
//http://www.si2.org/cmc
//
////////////////////////////////////////////////////////////////
//

// Phonon Scattering(temperature-dependent part) //
T1 =  `Fn_Pow( Tratio, RDRMUETMP ) ;
RRDRMUE = MKS_RDRMUE / T1 ;

// Velocity Temperature Dependence //
T0 = 1.8 + 0.4 * Tratio + 0.1 * Tratio * Tratio - RDRVTMP * ( 1.0 - Tratio ) ;
RRDRVMAX = MKS_RDRVMAX / T0 ;

//Toshiba model //
UC_RDRBB = UC_RDRBB + RDRBBTMP * (TTEMP-KTNOM) ;

// Check the value after temperature dependence
`MINRESET(UC_RDRBB, 0.1 , "RDRBB@T dependence")

// end of HSMHVtemp_eval_rdri.h //
// ---- end `include "HSMHV_temp_eval_rdri.inc" ----
                    end

`ifdef COEXTDIO
                        /* for Junction Diode Model */
`else
// ---- begin `include "HSMHV_temp_eval_dio.inc" ----
/***********************************************************************

 HiSIM (Hiroshima University STARC IGFET Model)
 Copyright (C) 2000-2016 Hiroshima University and STARC
 Copyright (C) 2016-2023 Hiroshima University
 HiSIM_HV (High-Voltage Model)
 Copyright (C) 2007-2016 Hiroshima University and STARC
 Copyright (C) 2016-2023 Hiroshima University

 MODEL NAME : HiSIM_HV
 ( VERSION : 2  SUBVERSION : 5  REVISION : 1 )
 Model Parameter 'VERSION' : 2.51
 FILE : HSMHV_temp_eval_dio.inc

 Date : 2023.02.09

 released by Hiroshima University

***********************************************************************/
//
////////////////////////////////////////////////////////////////
//
//
//
//
//Licensed under the Educational Community License, Version 2.0
//(the "License"); you may not use this file except in
//compliance with the License.
//
//You may obtain a copy of the License at:
//
//      http://opensource.org/licenses/ECL-2.0
//
//Unless required by applicable law or agreed to in writing,
//software distributed under the License is distributed on an
//"AS IS" BASIS, WITHOUT WARRANTIES OR CONDITIONS OF ANY KIND,
//either express or implied. See the License for the specific
//language governing permissions and limitations under the
//License.
//
//
//The HiSIM_HV standard has been supported by the members of
//Silicon Integration Initiative's Compact Model Coalition. A
//link to the most recent version of this standard can be found
//at:
//
//http://www.si2.org/cmc
//
////////////////////////////////////////////////////////////////
//

T0 = Tratio * Tratio ;

// for substrate-drain junction diode. //
`HSMHV_Idio_args1(js,     UC_JS0D,    XTID,  UC_NJD)
`HSMHV_Idio_args1(jssw,   UC_JS0SWD,  XTID,  NJSWD)
`HSMHV_Idio_args1(jsswg,  JS0SWGD,    XTID,  NJSWGD)
`HSMHV_Idio_args1(js2,    UC_JS0D,    XTI2D, UC_NJD)
`HSMHV_Idio_args1(jssw2,  UC_JS0SWD,  XTI2D, NJSWD)
`HSMHV_Idio_args1(jsswg2, JS0SWGD,    XTI2D, NJSWGD)

if ( CODIO > 0 ) begin //new model:
    `HSMHV_Idio_args2(isbd_btm, isbd2_btm, isbd_sws, isbd2_sws, isbd_swg, isbd2_swg, PD, AD)
end else begin //backward compatible:
    `HSMHV_Idio_args2_compat(isbd_btm, isbd2_btm, isbd_sws, isbd2_sws, isbd_swg, isbd2_swg, PD, AD)
end
isbd = isbd_btm + isbd_sws + isbd_swg ;

if ( isbd > 0 ) begin
    T2 = isbd + `Small ; //once removed in Geoffrey01_Small_20160309, but necessary for backward compatibility
    vbdt = UC_NJD / beta * ln( UC_VDIFFJD * T0 / T2 + 1.0 ) ;
    exptempd = exp (( Tratio - 1.0 ) * CTEMPD ) ;
    jd_nvtm_invd = 1.0 / ( UC_NJD / beta ) ;
    jd_expcd = exp (vbdt * jd_nvtm_invd ) ;
end

// for substrate-source junction diode. //
`HSMHV_Idio_args1(js,     UC_JS0S,    XTIS,  UC_NJS)
`HSMHV_Idio_args1(jssw,   UC_JS0SWS,  XTIS,  NJSWS)
`HSMHV_Idio_args1(jsswg,  JS0SWGS,    XTIS,  NJSWGS)
`HSMHV_Idio_args1(js2,    UC_JS0S,    XTI2S, UC_NJS)
`HSMHV_Idio_args1(jssw2,  UC_JS0SWS,  XTI2S, NJSWS)
`HSMHV_Idio_args1(jsswg2, JS0SWGS,    XTI2S, NJSWGS)

if ( CODIO > 0 ) begin //new model:
    `HSMHV_Idio_args2(isbs_btm, isbs2_btm, isbs_sws, isbs2_sws, isbs_swg, isbs2_swg, PS, AS)
end else begin //backward compatible:
    `HSMHV_Idio_args2_compat(isbs_btm, isbs2_btm, isbs_sws, isbs2_sws, isbs_swg, isbs2_swg, PS, AS)
end
isbs = isbs_btm + isbs_sws + isbs_swg ;

if ( isbs > 0 ) begin
    T3 = isbs + `Small ; //once removed in Geoffrey01_Small_20160309, but necessary for backward compatibility
    vbst = UC_NJS / beta * ln( UC_VDIFFJS * T0 / T3 + 1.0 ) ;
    exptemps = exp (( Tratio - 1.0 ) * CTEMPS ) ;
    jd_nvtm_invs = 1.0 / ( UC_NJS / beta ) ;
    jd_expcs = exp (vbst * jd_nvtm_invs ) ;
end

//-----------------------------------------------------------*
//* Charges and Capacitances.
//*-----------------//

// Drain Bulk Junction //
`HSMHV_Qdio_args1(czbd, czbdsw, czbdswg, PD, AD, CJD, TCJBD, CJSWD, TCJBDSW, CJSWGD, TCJBDSWG, "D")
`HSMHV_Qdio_args2(pzbd, pzbdsw, pzbdswg, PD, AD, PBD, TPBBD, PBSWD, TPBBDSW, PBSWGD, TPBBDSWG, "D")

// Source Bulk Junction //
`HSMHV_Qdio_args1(czbs, czbssw, czbsswg, PS, AS, CJS, TCJBS, CJSWS, TCJBSSW, CJSWGS, TCJBSSWG, "S")
`HSMHV_Qdio_args2(pzbs, pzbssw, pzbsswg, PS, AS, PBS, TPBBS, PBSWS, TPBBSSW, PBSWGS, TPBBSSWG, "S")

// end of HSMHVtemp_eval_dio.h //
// ---- end `include "HSMHV_temp_eval_dio.inc" ----
`endif /* End of COEXTDIO */

                end // end of if( tempNode < 0 || UC_RTH0 == 0.0 ) //

            end
        end
    end
    if (FATAL_flag) $error(" *** Fatal(HiSIM_HV:%M): Range check of internal variables failed.\n"); //$finish(0);
    //   Initial Settings for each steps.

    //   Check 5 Terminals
    //
    //   get biases from CKT //
    Vdsi  = TYPE * V(BRdpsp) ;
    Vgsi  = TYPE * V(BRgpsp) ;
    Vbsi  = TYPE * V(BRbpsp) ;
    Vdsei = TYPE * V(BRds )  ;
    Vgsei = TYPE * V(BRgps ) ;
    Vbsei = TYPE * V(BRbps ) ;
    Vddp = TYPE * V(BRddp ) ;
    Vsps = TYPE * V(BRsps)  ;

    //20160613 possible conflict still remains: should work it out --> Probably, OK.
`ifdef COEXTDIO
        /* for Junction Diode Model */
`else
        vsbs = TYPE * V(BRsbs ) ;
        vdbd = TYPE * V(BRdbd ) ;
        vbpsp = TYPE * V(BRbpsp ) ;
        vbpdp = TYPE * V(BRbpdp ) ;
        vbs_jct = vsbs;
        vbd_jct = vdbd;
        vbsi_jct = vbpsp;
        vbdi_jct = vbpdp;
`endif /* End of COEXTDIO */

`ifdef _4_PORTS_CONNECTED_
        Vsubs = 0 ;
`else // 5 or 6 Terminals
        Vsubs = TYPE * V(sub,s) ;
`endif
    //   NQS nodes
    if (flg_nqs) begin
        Qi_nqs = V(qi) ;
        Qb_nqs = V(qb) ;
    end else begin
        Qi_nqs = 0.0 ;
        Qb_nqs = 0.0 ;
    end
    //
    vgd  = Vgsi -Vdsi ;
    vbd  = Vbsi -Vdsi ;

    if (Vdsi >= 0) begin  // normal mode //
        mode = 1;
        Vds  = Vdsi ;
        Vgs  = Vgsi ;
        Vbs  = Vbsi ;
        Vdse = Vdsei ;
        Vgse = Vgsei ;
        Vbse = Vbsei ;
    end  else  begin     // reverse mode //
        mode = -1;
        Vds  = -Vdsi ;
        Vgs  =  vgd ;
        Vbs  =  vbd ;
        Vdse = -Vdsei ;
        Vgse = Vgsei - Vdsei ;
        Vbse = Vbsei - Vdsei ;
    end

    if ( INFO >= 5 ) begin  // mode, bias conditions ... //
        $write( "--- variables given to HSMHVevaluate() ----\n" );
        $write( "TYPE   = %d\n" , TYPE );
        $write( "mode   = %d\n" , mode );
        $write( "Vbsei Vbsi    = %20.10e %20.10e\n" , Vbsei, Vbsi );
        $write( "Vdsei Vdsi    = %20.10e %20.10e\n" , Vdsei, Vdsi );
        $write( "Vgsei Vgsi    = %20.10e %20.10e\n" , Vgsei, Vgsi );
        $write( "Vsubs       = %20.10e \n" , Vsubs );

`ifdef COEXTDIO
            /* for Junction Diode Model */
`else
            $write( "vbsj vbdj   = %20.10e %20.10e\n" , vbs_jct, vbd_jct );
`endif /* End of COEXTDIO */

    end // if( INFO >= 5 )

    if ( INFO >= 6 ) begin  // input flags //
        $write( "corsrd  = %d\n" , UC_CORSRD );
        $write( "coadov  = %d\n" , COADOV );
        $write( "coisub  = %d\n" , COISUB );
        $write( "coiigs  = %d\n" , COIIGS );
        $write( "cogidl  = %d\n" , COGIDL );
        $write( "coovlp  = %d\n" , COOVLP );
        $write( "coovlps = %d\n" , COOVLPS );
        $write( "coflick = %d\n" , COFLICK );
        $write( "coisti  = %d\n" , COISTI );
        $write( "conqs   = %d\n" , CONQS  );
        $write( "cothrml = %d\n" , COTHRML );
        $write( "coign   = %d\n" , COIGN );
        $write( "coselfheat = %d\n" , COSELFHEAT );
        $write( "cosym   = %d\n" , COSYM );
        $write( "cosubnode = %d\n" , COSUBNODE );
        $write( "cordrift = %d\n" , UC_CORDRIFT );
    end // if( INFO >= 6 )

    //start_of_evaluation;

    //-----------------------------------------------------------*
    //* Temperature dependent constants.
    //*-----------------//
    if ( COSELFHEAT > 0 && UC_RTH0 != 0.0 ) begin

        deltemp = V(temp) ;
        if ( COSELFHEAT == 2 ) begin
            // Clamping the maximum temperature rise (SHEMAX) //
            `Fn_SU( deltemp , deltemp , SHEMAX , SHEMAXDLT*10 ,  T0 )
        end

        if ( INFO >= 5 ) $write( "deltemp     = %20.10e \n" , deltemp );

// ---- begin `include "HSMHV_temp_eval.inc" ----
/***********************************************************************

 HiSIM (Hiroshima University STARC IGFET Model)
 Copyright (C) 2000-2016 Hiroshima University and STARC
 Copyright (C) 2016-2023 Hiroshima University
 HiSIM_HV (High-Voltage Model)
 Copyright (C) 2007-2016 Hiroshima University and STARC
 Copyright (C) 2016-2023 Hiroshima University

 MODEL NAME : HiSIM_HV
 ( VERSION : 2  SUBVERSION : 5  REVISION : 1 )
 Model Parameter 'VERSION' : 2.51
 FILE : HSMHV_temp_eval.inc

 Date : 2023.02.09

 released by Hiroshima University

***********************************************************************/
//
////////////////////////////////////////////////////////////////
//
//
//
//
//Licensed under the Educational Community License, Version 2.0
//(the "License"); you may not use this file except in
//compliance with the License.
//
//You may obtain a copy of the License at:
//
//      http://opensource.org/licenses/ECL-2.0
//
//Unless required by applicable law or agreed to in writing,
//software distributed under the License is distributed on an
//"AS IS" BASIS, WITHOUT WARRANTIES OR CONDITIONS OF ANY KIND,
//either express or implied. See the License for the specific
//language governing permissions and limitations under the
//License.
//
//
//The HiSIM_HV standard has been supported by the members of
//Silicon Integration Initiative's Compact Model Coalition. A
//link to the most recent version of this standard can be found
//at:
//
//http://www.si2.org/cmc
//
////////////////////////////////////////////////////////////////
//

TTEMP = $temperature + DTEMP;
TTEMP0 = TTEMP ;
// Self heating //
TTEMP = TTEMP + deltemp ;
Tdiff0 =   TTEMP0 - KTNOM ;
Tdiff0_2 = TTEMP0 * TTEMP0 - KTNOM * KTNOM ;
Tdiff =    TTEMP  - KTNOM ;
Tdiff_2 =  TTEMP  * TTEMP  - KTNOM * KTNOM ;
Tratio = TTEMP / KTNOM ;
log_Tratio = ln(Tratio) ;

// Band gap //
Eg   = egtnom - UC_BGTMP1 * Tdiff - UC_BGTMP2 * Tdiff_2 ;
sqrt_eg = sqrt( Eg ) ;
T1 = 1.0 / TTEMP ;
T2 = 1.0 / KTNOM ;
T3 = egtnom + EGIG
       + IGTEMP2 * ( T1 - T2 )
       + IGTEMP3 * ( T1 * T1 - T2 * T2 ) ;
Egp12 = sqrt ( T3 ) ;
Egp32 = T3 * Egp12 ;

// Inverse of the thermal voltage //
beta   = `C_QE / (`C_KB * TTEMP) ;
beta_inv = 1.0 / beta ;
beta2 = beta * beta ;
betatnom = `C_QE / (`C_KB * KTNOM) ;

// Intrinsic carrier concentration //
Nin   = `C_Nin0 * exp(log_Tratio*1.5e0)
          * exp(- Eg / 2.0e0 * beta + egtnom / 2.0e0 * betatnom) ;

// Phonon Scattering(temperature-dependent part) //
T1 = exp(log_Tratio*UC_MUETMP) ;
mphn0 = T1 / mueph ;

// constant for depletion MOS  //
if ( UC_CODEP != 0 && UC_CODEP < 3 ) begin
    cnst0 = sqrt ( 2.0 * `C_ESI * `C_QE * UC_NDEPM * beta_inv ) ;
    cnst1 = Nin * Nin / UC_NDEPM / UC_NDEPM ;
    Pb2n =  2.0e0 * beta_inv * ln (UC_NDEPM / Nin) ;
    Vbipn = beta_inv * ln(UC_NDEPM * EF_NSUBC /Nin /Nin) ;
    T1 = exp(log_Tratio*DEPMUETMP) ;
    depmphn0 = T1 / UC_DEPMUEPH1 ;
    T0 = 1.8 + 0.4 * Tratio + 0.1 * Tratio * Tratio - DEPVTMP * ( 1.0 - Tratio ) ;
    UC_DEPVMAX = UC_DEPVMAX / T0 ;
    `MINRESET(UC_DEPVMAX , 1E3 , "DEPVMAX@T dependence ")
    // Temp. dependence of DEPMUE0 & DEPMUE2
    UC_DEPMUE0 = UC_DEPMUE0 / pow (Tratio, DEPMUE0TMP) ; // Coulomb(CODEP=1,2)
    UC_DEPMUE2 = UC_DEPMUE2 / pow (Tratio, DEPMUE2TMP) ; // Phonon(CODEP=2)
end else if ( UC_CODEP == 3) begin
    cnst0 = sqrt ( 2.0 * `C_ESI * `C_QE * UC_NDEPM * beta_inv ) ;
    cnst1 = Nin * Nin / UC_NDEPM / UC_NDEPM ;
    Pb2n =  2.0e0 * beta_inv * ln (UC_NDEPM / Nin) ;
    Vbipn = beta_inv * ln(UC_NDEPM * EF_NSUBC /Nin /Nin) ;
    T1 = exp(log_Tratio*DEPMUETMP) ; // revive 20170322
    depmphn0 = T1 / UC_DEPMUEPH1 ;   // revive 20170322
    T0 = 1.8 + 0.4 * Tratio + 0.1 * Tratio * Tratio - DEPVTMP * ( 1.0 - Tratio ) ;
    UC_DEPVMAX = UC_DEPVMAX / T0 ;
    `MINRESET(UC_DEPVMAX , 1E3 , "DEPVMAX@T dependence ")
    // Temp. dependence of DEPMUE0 & DEPMUE2
    UC_DEPMUE0 = UC_DEPMUE0 / pow (Tratio, DEPMUE0TMP) ; // Coulomb scat mobility for resistor (CODEP=3)
    UC_DEPWLP  = DEPWLP + DEPWLPT * ( Tratio - 1.0 ) ;
end else begin
    Pb2n =  0.0 ;
    //    Vbipn = 0.0 ;
    Vbipn = beta_inv * ln(UC_NJUNC/Nin * Nsub/Nin); //  All conc here in 1/m^3.
    depmphn0 = 0.0 ;
end

// Pocket Overlap(temperature-dependent part) //
ptovr = ptovr0 * beta_inv ;

// Velocity Temperature Dependence //
T1 = TTEMP  / KTNOM ;
T0 = 1.8 + 0.4 * T1 + 0.1 * T1 * T1 - UC_VTMP * (1.0 - T1) ;
if ( COTEMP != 2 ) begin // without deltemp(COTEMP=0,1,3) //
    VMAXeff = vmax0 * UC_VMAX
              / T0 * ( 1.0 + VMAXT1 * Tdiff0 + VMAXT2 * Tdiff0_2 ) ;
end else begin // with deltemp(COTEMP=2) //
    VMAXeff = vmax0 * UC_VMAX
              / T0 * ( 1.0 + VMAXT1 * Tdiff + VMAXT2 * Tdiff_2 ) ;
end
`MINCHECK(VMAXeff , 1E3 , "VMAXeff@T dependence ")

if ( COTEMP != 2 ) begin // without deltemp(COTEMP=0,1,3) //
    Ninvde = ninvd0 * ( 1.0 + NINVDT1 * Tdiff0 + NINVDT2 * Tdiff0_2 ) ;
    T1 = 1.0 + DEPNINVDT1 * Tdiff0 + DEPNINVDT2 * Tdiff0_2  ;
    NinvdecRES = ninvd0cRES * T1 ; // for Mu_res
    NinvdehRES = ninvd0hRES * T1 ; // for Mu_res
end else begin // with deltemp(COTEMP=2) //
    Ninvde = ninvd0 * ( 1.0 + NINVDT1 * Tdiff + NINVDT2 * Tdiff_2 ) ;
    T1 = 1.0 + DEPNINVDT1 * Tdiff + DEPNINVDT2 * Tdiff_2  ;
    NinvdecRES = ninvd0cRES * T1 ; // for Mu_res
    NinvdehRES = ninvd0hRES * T1 ; // for Mu_res
end
`MINRESET(Ninvde     , 0 , "NINVD@T dependence ")
`MINRESET(NinvdecRES , 0 , "NINVDCRES@T dependence ")
`MINRESET(NinvdehRES , 0 , "NINVDHRES@T dependence ")

// Temperature Dependence of RTH0 //
if ( COSELFHEAT ) begin
    RTH = ( UC_RTH0 + RTHTEMP1 * Tdiff0 + RTHTEMP2 * Tdiff0_2  ) * rthtemp0 ;
    `MINRESET(RTH , `C_RTH_MIN , "RTH@T dependence ")
end

// Temperature Dependence of POWRAT //
T2 = UC_POWRAT + PRATTEMP1 * Tdiff0 + PRATTEMP2 * Tdiff0_2  ;
`Fn_SL( T2 , T2 , 0 , 0.05 , T0 )
`Fn_SU( powratio , T2 , 1 , 0.05 , T0 )

// 2 phi_B(temperature-dependent) //
// @temp, with pocket //
Pb2 =  2.0e0 * beta_inv * ln (Nsub / Nin) ;

// Depletion Width //
T1 = 2.0e0 * `C_ESI / `C_QE ;
wdpl = sqrt ( T1 / Nsub ) ;
wdplp = sqrt( T1 / ( EF_NSUBP ) ) ;

if ( UC_CODEP == 0 ) begin
    // Coefficient of the F function for bulk charge //
    cnst0 = sqrt ( 2.0 * `C_ESI * `C_QE * Nsub * beta_inv ) ;

    // cnst1: n_{p0} / p_{p0} //
    T1 = Nin / Nsub ;
    cnst1 = T1 * T1 ;
end
if ( UC_CODEP == 0 ) begin
    if ( UC_NOVER != 0.0 ) begin
        cnst0over = cnst0 * sqrt( UC_NOVER / Nsub ) ;
    end
    if ( UC_NOVERS != 0.0 ) begin
        cnst0overs = cnst0 * sqrt( UC_NOVERS / Nsub ) ;
    end
end else begin
    if ( UC_NOVER != 0.0 ) begin
        cnst0over = cnst0 * sqrt( UC_NOVER / UC_NDEPM ) ;
    end
    if ( UC_NOVERS != 0.0 ) begin
        cnst0overs = cnst0 * sqrt( UC_NOVERS / UC_NDEPM ) ;
    end
end

// temperature-dependent resistance model //
if ( UC_CORDRIFT == 0 ) begin
    // drain side //
    if ( UC_RD > 0.0 ) begin
        T2 = Rdtemp0
           * ( LDRIFT1 * UC_RDSLP1 * `C_m2um   + UC_RDICT1 )
           * ( LDRIFT2 * RDSLP2 * `C_m2um   + RDICT2 ) ;

        if ( COTEMP == 1 ) begin // without deltemp(COTEMP=1) //
            Rde = ( UC_RD + MKS_RDTEMP1 * Tdiff0 + MKS_RDTEMP2 * Tdiff0_2 ) * T2 ;
            `Fn_SL( Rde, Rde, `C_rdtemp_min * UC_RD, `C_rdtemp_dlt * UC_RD, T0 )
        end else begin // with deltemp(COTEMP=0,2,3) //
            Rde = ( UC_RD + MKS_RDTEMP1 * Tdiff + MKS_RDTEMP2 * Tdiff_2 ) * T2 ;
            `Fn_SL( Rde, Rde, `C_rdtemp_min * UC_RD, `C_rdtemp_dlt * UC_RD, T0 )
        end
    end else begin
        Rde = 0.0 ;
    end
    // source side(asymmetric case) //
    if ( UC_RS > 0.0 ) begin
        T2 = Rdtemp0
           * ( LDRIFT1S * UC_RDSLP1 * `C_m2um   + UC_RDICT1 )
           * ( LDRIFT2S * RDSLP2 * `C_m2um   + RDICT2 ) ;

        if ( COTEMP == 1 ) begin // without deltemp(COTEMP=1) //
            Rse = ( UC_RS + MKS_RDTEMP1 * Tdiff0 + MKS_RDTEMP2 * Tdiff0_2 ) * T2 ;
            `Fn_SL( Rse, Rse, `C_rdtemp_min * UC_RS, `C_rdtemp_dlt * UC_RS, T0 )
        end else begin // with deltemp(COTEMP=0,2,3) //
            Rse = ( UC_RS + MKS_RDTEMP1 * Tdiff + MKS_RDTEMP2 * Tdiff_2 ) * T2 ;
            `Fn_SL( Rse, Rse, `C_rdtemp_min * UC_RS, `C_rdtemp_dlt * UC_RS, T0 )
        end
    end else begin
        Rse = 0.0 ;
    end
    if ( UC_RDVD > 0.0 ) begin
        T4 = Rdvdtemp0 * ( LDRIFT1 * UC_RDSLP1 * `C_m2um  + UC_RDICT1 )
           * ( LDRIFT2 * RDSLP2 * `C_m2um  + RDICT2 ) ;
        T1 = ( 1 -  UC_RDOV13 ) * LOVERLD * `C_m2um ;
        `Fn_SZ( T2  , RDOV12 , `rdsz_dlt , T0 )
        T8 = - RDOV11 / T2 ;
        T3 = ( T8 * LOVERLD * `C_m2um  + 1.0 + RDOV11 ) ;
        `Fn_SL( T5 , T3 * T4 , T4 , 10.0e-3 , T6 )
        `Fn_SU( T7  , T5    , T4 * ( RDOV11 + 1.0) , 50.0e-6 , T6 )
        `Fn_SL( T2  , T7 + T1 * T4  , 0, 50.0e-6 , T6 )

        if ( COTEMP == 0 || COTEMP == 1 ) begin // without deltemp(COTEMP=0,1) //
            Rdvde = ( UC_RDVD + MKS_RDVDTEMP1 * Tdiff0 + MKS_RDVDTEMP2 * Tdiff0_2 ) * T2 ;
            `Fn_SL( Rdvde, Rdvde, `C_rdtemp_min * UC_RDVD, `C_rdtemp_dlt * UC_RDVD, T0 )
        end else begin // with deltemp(COTEMP=2,3) //
            Rdvde = ( UC_RDVD + MKS_RDVDTEMP1 * Tdiff + MKS_RDVDTEMP2 * Tdiff_2 ) * T2 ;
            `Fn_SL( Rdvde, Rdvde, `C_rdtemp_min * UC_RDVD, `C_rdtemp_dlt * UC_RDVD, T0 )
        end

        T4 = Rdvdtemp0 * ( LDRIFT1S * UC_RDSLP1 * `C_m2um  + UC_RDICT1 )
           * ( LDRIFT2S * RDSLP2 * `C_m2um  + RDICT2 ) ;
        T1 = ( 1 -  UC_RDOV13 ) * LOVERS * `C_m2um ;
        T3 = ( T8 * LOVERS * `C_m2um + 1.0 + RDOV11 ) ;
        `Fn_SL( T5 , T3 * T4 , T4 , 10.0e-3 , T6 )
        `Fn_SU( T7  , T5    , T4 * ( RDOV11 + 1.0) , 50.0e-6 , T6 )
        `Fn_SL( T2  , T7 + T1 * T4  , 0, 50.0e-6 , T6 )

        if ( COTEMP == 0 || COTEMP == 1 ) begin // without deltemp(COTEMP=0,1) //
            Rsvde = ( UC_RDVD + MKS_RDVDTEMP1 * Tdiff0 + MKS_RDVDTEMP2 * Tdiff0_2 ) * T2 ;
            `Fn_SL( Rsvde, Rsvde, `C_rdtemp_min * UC_RDVD, `C_rdtemp_dlt * UC_RDVD, T0 )
        end else begin // with deltemp(COTEMP=2,3) //
            Rsvde = ( UC_RDVD + MKS_RDVDTEMP1 * Tdiff + MKS_RDVDTEMP2 * Tdiff_2 ) * T2 ;
            `Fn_SL( Rsvde, Rsvde, `C_rdtemp_min * UC_RDVD, `C_rdtemp_dlt * UC_RDVD, T0 )
        end
    end else begin
        Rdvde = 0.0 ;
        Rsvde = 0.0 ;
    end
end  // CORDRIFT=0

// costi0 and costi1 for STI transistor model(temperature-dependent part) //
costi0 = costi00 * sqrt(beta_inv) ;
costi0_p2 = costi0 * costi0 ;
costi1 = Nin * Nin * nsti_p2 ;

// Temperature dependence of Breakdown Model //
HBDCeff = HBDC + HBDCTMP * Tdiff ;

// Temperature dependence for Isub Model //
UC_SUBTMP  = SUBTMP ;
`RANGERESET(UC_SUBTMP ,    0.0 ,       5.0e-3 , "SUBTMP"   )

`ifdef _AGING_
    // Temperature dependence for aging model //
    Nt0s_temp  = TRAPTEMP1 * Tdiff + TRAPTEMP2 * Tdiff_2 ;
`endif
// end of HSMHVtemp_eval.h //
// ---- end `include "HSMHV_temp_eval.inc" ----

    end else begin
        TTEMP       = $temperature + DTEMP;
    end // else: !if( COSELFHEAT > 0 && UC_RTH0 != 0.0 )
`ifdef _AGING_
        keT = `C_KB / `C_QE * TTEMP ; // aging; trap
`endif
    // Metallurgical channel geometry //
    WeffLD_nf = weff_ld * NF ;
    Ldrift0 = LDRIFT1 +  LDRIFT2 ;

    // Flat band voltage //
`ifdef _AGING_
        Vfb = UC_VFBC + V(dVfb) + TRAPDVTH ;
`else
        Vfb = UC_VFBC ;
`endif

    // Velocity Temperature Dependence //
    Vmaxe = VMAXeff ;

    // c_eox: Permittivity in ox  //
    c_eox = cecox ;

    // Tox and Cox without QME //
    Tox0 = TOX ;
    Cox0 = c_eox / Tox0 ;
    Cox0_inv = 1.0 / Cox0 ;
    Coxb0 = c_eox / UC_TOXB ;

    // for calculation of Ps0_min //
    Vgs_min = TYPE * VGSMIN ;

    //---------------------------------------------------*
    //* Determine clamping limits for too large Vbs(internal).
    //*-----------------//
    `Fn_SU( T1 , Pb2  - VZADD0 , 0.8 , 0.1 , T0 )
    Vbs_max = T1 ;
    if ( Pb20 - VZADD0 < Vbs_max ) begin
        Vbs_max = Pb20 - VZADD0 ;
    end
    if ( Pb2c - VZADD0 < Vbs_max ) begin
        Vbs_max = Pb2c - VZADD0 ;
    end
    if ( UC_CODEP > 0 && UC_CODEP <= 3 ) begin
        if ( Pb2n - VZADD0 < Vbs_max ) begin
            Vbs_max = Pb2n - VZADD0 ;
        end
        if ( Vbipn - VZADD0 < Vbs_max ) begin
            Vbs_max = Vbipn - VZADD0 ;
        end
    end

    if ( Vbs_bnd > Vbs_max * 0.5 ) begin
        Vbs_bnd = 0.5 * Vbs_max ;
    end

    //used in the localized block "Vbscl_local":
    if ($param_given(VBFWDMX)) begin
        Vbs_max_local = VBFWDMX; //user-defined value
    end else begin
        Vbs_max_local = Vbs_max; //original value
    end
    if ($param_given(VBFWDBND)) begin
        Vbs_bnd_local = VBFWDBND; //user-defined value
    end else begin
        if ($param_given(VBFWDMX)) begin
            Vbs_bnd_local = 0.5 * Vbs_max_local; //based on the user-defined value
        end else begin
            Vbs_bnd_local = Vbs_bnd; //original value
        end
    end
    if ( Vbs_bnd_local > Vbs_max_local * 0.5 ) begin
        Vbs_bnd_local = 0.5 * Vbs_max_local ;
    end

    if (Rse > 0.0 || Rde > 0.0) begin         //HV1
        if ( UC_CORSRD == 1 ) flg_rsrd  = 1 ;  //HV1
        if ( UC_CORSRD == 2 ) flg_rsrd  = 2 ;  //HV1
        if ( UC_CORSRD == 3 ) flg_rsrd  = 3 ;  //HV1
    end                                      //HV1

    //++++++++++++++++++++++++++++++++++++++++++++++++++++++++++++++++++++
    //* PART-1: Basic device characteristics.
    //*+++++++++++++++++++++++++++++++++++++++++++++++++++++++++++++++++++//
    flg_pprv = 0 ;

    if ( ( UC_CORDRIFT == 1 && COSUBNODE == 1 ) &&
         ( UC_NOVER * ( `NSUBSUB + UC_NOVER ) ) > 0 ) begin
        //----------------------------------------------------------*
        //* Considering these special cases:
        //* ( mode == HiSIM_NORMAL_MODE  && Vdse < 0.0 )
        //* ( mode == HiSIM_REVERSE_MODE && Vdse < 0.0 )
        //*----------------------------------------------------------//
        Vdsegmt = Vdsei ; // geometrical outer biases //
        if ( Vdsegmt >= 0.0 ) begin // vdse normal mode //
            Vdserev = Vdsegmt ;
            Vsubsrev = Vsubs ;
        end else begin // vdse reverse mode //
            Vdserev = - Vdsegmt ;
            Vsubsrev = Vsubs - Vdsegmt ;
        end
        //-----------------------------------------------------------*
        //* Vxserevz: Modified bias introduced to realize symmetry at Vds=0.
        //*-----------------//
        `Fn_SymAdd( Vzadd , Vdserev / 2 , VZADD0 , T2 )
        if ( Vzadd < `ps_conv ) begin
            Vzadd = `ps_conv ;
        end
        Vdserevz = Vdserev + 2.0 * Vzadd ;

        // external substrate node exists && LDMOS case: //
        // Substrate Effect //
        T0 = `VBISUB - `RDVDSUB * Vdserevz - `RDVSUB * Vsubsrev ;
        `Fn_SZ( T1, T0, 10.0, T2 )
        T1 = T1 + `epsm10 ;
        T0 = `NSUBSUB / ( UC_NOVER * ( `NSUBSUB + UC_NOVER ) ) ;
        T4 = 2 * `C_ESI / `C_QE * T0 ;
        Wdep = sqrt ( T4 * T1 ) + `Small ;
        `Fn_SU( Wdep, Wdep, `DDRIFT, `C_sub_delta* `DDRIFT, T0 )
    end else begin
        Wdep = 0.0 ;
    end
    //HV1{
    if ( flg_rsrd == 1 || flg_rsrd == 3 ) begin

        //----------------------------------------------------------*
        //* Considering these special cases:
        //* ( mode == HiSIM_NORMAL_MODE  && Vdse < 0.0 )
        //* ( mode == HiSIM_REVERSE_MODE && Vdse < 0.0 )
        //*----------------------------------------------------------//
        Vdsegmt = Vdsei ; // geometrical outer biases //
        Vgsegmt = Vgsei ;
        Vbsegmt = Vbsei ;
        if ( Vdsegmt >= 0.0 ) begin // vdse normal mode //
            VdseModeNML = 1 ;
            VdseModeRVS = 0 ;
            Vdserev = Vdsegmt ;
            Vgserev = Vgsegmt ;
            Vbserev = Vbsegmt ;
            Vsubsrev = Vsubs ;
        end else begin // vdse reverse mode //
            VdseModeNML = 0 ;
            VdseModeRVS = 1 ;
            Vdserev = - Vdsegmt ;
            Vgserev = Vgsegmt - Vdsegmt ;
            Vbserev = Vbsegmt - Vdsegmt ;
            Vsubsrev = Vsubs - Vdsegmt ;
        end
        if ( Rdvde > 0.0 || Rsvde > 0.0 || UC_RDVG11 > 0.0 || UC_RDVB > 0.0 || COSUBNODE == 1 ) begin
            //-----------------------------------------------------------*
            //* Vxserevz: Modified bias introduced to realize symmetry at Vds=0.
            //*-----------------//
            `Fn_SymAdd( Vzadd , Vdserev / 2 , VZADD0 , T2 )
            if ( Vzadd < `ps_conv ) begin
                Vzadd = `ps_conv ;
            end
            Vdserevz = Vdserev + 2.0 * Vzadd ;
            Vgserevz = Vgserev + Vzadd ;
            Vbserevz = Vbserev + Vzadd ;

            // bias-dependent Rdrift for HVMOS/LDMOS //

            if ( COSYM == 1 || VdseModeNML == 1 ) begin // HVMOS or normal mode LDMOS: //
                // ... Vdse dependence             //
                T1 = VdseModeNML * Rde + VdseModeRVS * Rse ;
                T0 = VdseModeNML * Rdvde + VdseModeRVS * Rsvde ;
                T4 = T1 + T0 * Vdserevz ;

                // ... Vgse dependence             //
                `Fn_SZ( T10 , RDVG12 , `rdsz_dlt , T0 )
                T1  = T4 * ( 1.0 + UC_RDVG11 * ( 1.0 - Vgserevz   / T10 ) ) ;
                `Fn_SL2( T2 , T1 , T4 , `rdsl2_dlt , T0 , T5 )
                T3  = T4 * ( 1.0 + UC_RDVG11 ) ;
                `Fn_SU2( Rdrift , T2 , T3 , `rdsu2_dlt , T0, T5 )

                // ... Vbse dependence             //
                T1 = 1.0 - UC_RDVB * Vbserevz ;
                `Fn_SZ( T3 , T1 , `rdsz_dlt , T4 )
                T3 = T3 + `Small ;
                T0 = Rdrift ;
                Rdrift = Rdrift       * T3 ;

            end else begin // reverse mode LDMOS: //
                Rdrift = Rse ;
            end

            // Rsdrift //
            T4 = ( VdseModeNML * Rse + VdseModeRVS * Rde ) ;

            if ( COSYM == 1 || VdseModeRVS == 1 ) begin // HVMOS or reverse mode LDMOS: //
                // ... Vdse dependence             //
                T0 = VdseModeNML * Rsvde + VdseModeRVS * Rdvde ;
                T4 = T4 + T0 * ( 2.0 * VZADD0 ) ;

                // ... Vgse dependence             //
                T10 = RDVG12 + `Small ;
                T1  = T4 * ( 1.0 + UC_RDVG11 * ( 1.0 - Vgserevz   / T10 ) ) ;
                `Fn_SL2( T2 , T1 , T4 , `rdsl2_dlt , T0 , T5 )
                T3  = T4 * ( 1.0 + UC_RDVG11 ) ;
                `Fn_SU2( Rsdrift , T2 , T3 , `rdsu2_dlt , T0, T5 )

                // ... Vbse dependence             //
                T1 = 1.0 - UC_RDVB * Vbserevz ;
                `Fn_SZ( T3 , T1 , `rdsz_dlt , T4 )
                T3 = T3 + `Small ;
                T0 = Rsdrift ;
                Rsdrift = Rsdrift       * T3 ;
            end else begin // LDMOS normal mode: //
                Rsdrift = Rse ;
            end

            if ( COSUBNODE == 1 && COSYM == 0 &&

                ( UC_NOVER * ( `NSUBSUB + UC_NOVER ) ) > 0 ) begin
                // external substrate node exists && LDMOS case: //
                // Substrate Effect //
                T0 = `VBISUB - `RDVDSUB * Vdserevz - `RDVSUB * Vsubsrev ;
                `Fn_SZ( T1, T0, 10.0, T2 )
                T1 = T1 + `epsm10 ;
                T0 = `NSUBSUB / ( UC_NOVER * ( `NSUBSUB + UC_NOVER ) ) ;
                T4 = 2 * `C_ESI / `C_QE * T0 ;
                Wdep = sqrt ( T4 * T1 ) + `Small ;
                `Fn_SU( Wdep, Wdep, `DDRIFT, `C_sub_delta* `DDRIFT, T0 )
                T6 = Ldrift0 / (`DDRIFT - Wdep) ;

                T0 = Rdrift  * T6 ;
                T1 = Rsdrift * T6 ;
                Rdrift  = T0 * VdseModeNML + Rdrift  * VdseModeRVS ;
                Rsdrift = T1 * VdseModeRVS + Rsdrift * VdseModeNML ;
            end else begin
                Wdep = 0.0 ;
            end

            Rdd = Rdrift ;
            Rsd = Rsdrift ;

        end else begin // bias-independent Rs/Rd //
            Rdd = VdseModeNML * Rde + VdseModeRVS * Rse ;
            Rsd = VdseModeNML * Rse + VdseModeRVS * Rde ;
        end

        // Weff dependence of the resistances //
        Rdd = Rdd /  WeffLD_nf ;
        Rsd = Rsd /  WeffLD_nf ;

        // Sheet resistances are added. //
        Rdd = Rdd + VdseModeNML * Rd0 + VdseModeRVS * Rs0 ;
        Rsd = Rsd + VdseModeNML * Rs0 + VdseModeRVS * Rd0 ;

        // Re-stamps for hsmhvnoi.c //
        // Please see hsmhvnoi.c //
        T0 = VdseModeNML * Rdd + VdseModeRVS * Rsd ; // mode-dependent --> geometrical //
        if ( T0 > `Res_min && COTHRML != 0 ) drainConductance = Mfactor / T0 ;
        else drainConductance = 0.0 ;

        T0 = VdseModeNML * Rsd + VdseModeRVS * Rdd ; // mode-dependent --> geometrical //
        if ( T0 > `Res_min && COTHRML != 0 ) sourceConductance = Mfactor / T0 ;
        else sourceConductance = 0.0 ;

    end // end of case flg_rsrd=1 or flg_rsrd=3 //}HV1

    // Clamping for Vbs > Vbs_bnd //
    if ( Vbs > Vbs_bnd ) begin
        T1 = Vbs - Vbs_bnd ;
        T2 = Vbs_max - Vbs_bnd ;
        `Fn_SUPoly4m( TY , T1 , T2 , VbscldVbs , T0 )
        Vbscl    = Vbs_bnd    + TY ;

        T3 = 1 / T2 ;
        T4 = T1 * T3 ;
        T5 = T4 * T4;

        T7 = 1 + T4 + T5 * ( 1 + T4 + T5 ) ;
        VbscldVbs = ( 1 + 2 * T4 + 3 * T5 + 4 * T4 * T5)/(T7 * T7) ;
    end  else begin
        Vbscl     = Vbs ;
        VbscldVbs = 1.0 ;
    end

    //-----------------------------------------------------------*
    //* Vxsz: Modified bias introduced to realize symmetry at Vds=0.
    //*-----------------//
    T1 = VbscldVbs * Vds / 2 ;
    `Fn_SymAdd(  Vzadd , T1 , VZADD0 , T2 )
    if ( Vzadd < `ps_conv ) begin
        Vzadd = `ps_conv ;
    end
    Vbsz = Vbscl + Vzadd ;
    Vdsz = Vds + 2.0 * Vzadd ;
    Vgsz = Vgs + Vzadd ;

    //---------------------------------------------------*
    //* Factor of modification for symmetry.
    //*-----------------//
    T1 = qnsub_esi * Cox0_inv * Cox0_inv ;
    T2 = Vgs - Vfb ;
    T3 = 1 + 2.0 / T1 * ( T2 - 1.0 / betatnom - Vbscl ) ;
    `Fn_SZ( T4 , T3 , 1e-3 , T5 )
    T4 = T4 + `Small ;
    TX = sqrt( T4 ) ;
    Pslsat = T2 + T1 * ( 1.0 - TX ) ;
    VdsatS = Pslsat - Pb2c ;
    `Fn_SL( VdsatS , VdsatS , 0.1 , 5e-2 , T6 )
    T1 = Vds / VdsatS ;
    `Fn_SUPoly4( TX , T1 , 1.0 , T0 )
    FMDVDS = TX * TX ;

    //-----------------------------------------------------------*
    //* Quantum effect
    //*-----------------//
    if ( flg_qmetemp == 0 ) begin
        flg_qme = 0 ;
    end else begin
        flg_qme = 1 ;
    end
    T1 = qnsub_esi2 ;
    T2 = sqrt( T1 * Pb20 ) ;
    Vthq = Pb20 + Vfb + T2 * Cox0_inv ;
    if ( flg_qme == 0 ) begin
        Toxe = Tox0 ;
        Cox = Cox0 ;
        Cox_inv  = Cox0_inv ;
        T0 = cnst0 * cnst0 * Cox_inv ;
        cnstCoxi = T0 * Cox_inv ;
    end else begin
        T5 = Vgs  - Vbs - Vthq + QME2 ;
        `Fn_SZ( T2 , T5 , `qme_dlt, T3)
        T2 = T2 + `Small ;
        T3 = 1.0 /  T2 ;
        T7 = -1.0 / ( T2 * T2 ) ;
        T4 = 2.0 * abs(Vthq) ;
        T6 = T5 - Vgs + Vfb ;
        if (T6 > T4) begin
            T4 = T6;
        end
        `Fn_SU( T2 , T3 , 1.0 / T4  , `qme_dlt, T6 )
        dTox = QME1 * T2 + QME3 ;
        T7   = QME1 ;
        if ( dTox * 1.0e12 < Tox0 ) begin
            dTox = 0.0 ;
            flg_qme = 0 ;
        end
        Toxe = Tox0 + dTox ;
        Cox = c_eox / Toxe ;
        T1 = - c_eox / ( Toxe * Toxe ) ;
        Cox_inv  = Toxe / c_eox ;
        T1 = 1.0 / c_eox ;
        T0 = cnst0 * cnst0 * Cox_inv ;
        cnstCoxi = T0 * Cox_inv ;
    end

    //---------------------------------------------------*
    //* Vbsz2 : Vbs for dVth
    //*-----------------//
    Vbsz2 = Vbsz ;

    //---------------------------------------------------*
    //* Vthp : Vth with pocket.
    //*-----------------//
    T1 = qnsub_esi2 ;
    Qb0 = sqrt (T1 * (Pb20 - Vbsz2)) ;
    T2 = 0.5 * T1 / Qb0 ;
    Vthp = Pb20 + Vfb + Qb0 * Cox_inv + ptovr;
    Pb20b = Pb20 ;
    T0 = 0.95 ;
    T4 = (UC_CODEP > 1) ? 0.0 : 1.0 ;
    T1 = T0 * Pb20b - T4 * Vbsz2 - 1.0e-3 ;
    T2 = sqrt (T1 * T1 + 4.0 * T0 * Pb20b * 1.0e-3) ;
    T3 = T0 * Pb20b - 0.5 * (T1 + T2) ;
    T5 = (UC_CODEP == 1) ? DEPETA * Vdsz : 0.0 ;
    Pbsum = Pb20b - T3 + T5 ;

    sqrt_Pbsum = sqrt( Pbsum ) ;

    //-------------------------------------------*
    //* dVthLP : Short-channel effect induced by pocket.
    //* - Vth0 : Vth without pocket.
    //*-----------------//
    if ( LP != 0.0 ) begin
        T1 = qnsub_esi2 ;
        T2 = BS2 - Vbsz2 ;
        T3 = T2 + `Small ;
        T4 = sqrt (T3 * T3 + 4.0 * `vth_dlt) ;
        T5 = 0.5 * (T3 + T4) ;
        T6 = 0.5 * (1.0 + T3 / T4) ;
        T7 = 1.0 / T5 ;
        bs12 = BS1 * T7 ;
        T8 = - bs12 * T7 ;
        `Fn_SU( T10 , Vbsz2 + bs12, 0.93 * Pb20, `vth_dlt, T0)
        Qbmm = sqrt (T1 * (Pb20 - T10 )) ;
        T9 = T0 / Qbmm ;
        dqb = (Qb0 - Qbmm) * Cox_inv ;
        T1 = 2.0 * `C_QE * EF_NSUBC * `C_ESI ;
        T2 = sqrt( T1 * ( Pb2c - Vbsz2 ) ) ;
        Vth0 = Pb2c + Vfb + T2 * Cox_inv ;
        T3 = 0.5 * T1 / T2 * Cox_inv ;
        T1 = `C_ESI * Cox_inv ;
        T2 = wdplp ;
        T4 = 1.0e0 / ( LP * LP ) ;
        T5 = 2.0e0 * ( VBI - Pb20b ) * T1 * T2 * T4 ;
        dVth0 = T5 * sqrt_Pbsum ;
        T6 = 0.5 * T5 / sqrt_Pbsum ;
        T7 = 2.0e0 * ( VBI - Pb20b ) * `C_ESI * T2 * T4 * sqrt_Pbsum ;
        T8 = - 2.0e0 * T1 * T2 * T4 * sqrt_Pbsum ;
        T1 = Vthp - Vth0 ;
        T2 = UC_SCP1 + UC_SCP3 * Pbsum / LP ;
        T3 = T2 + UC_SCP2 * Vdsz ;
        Vdx = SCP21 + Vdsz ;
        Vdx2 = Vdx * Vdx ;
        dVthLP = T1 * dVth0 * T3 + dqb - msc / Vdx2 ;
    end else begin
        dVthLP = 0.0e0 ;
    end

    //---------------------------------------------------*
    //* dVthSC : Short-channel effect induced by Vds.
    //*-----------------//

    T1 = `C_ESI * Cox_inv ;
    T2 = wdpl ;
    T3 = Lgate - PARL2 ;
    T4 = 1.0e0 / ( T3 * T3 ) ;
    T5 = 2.0e0 * ( VBI - Pb20b ) * T1 * T2 * T4 ;
    dVth0 = T5 * sqrt_Pbsum ;
    T6 = T5 / 2.0 / sqrt_Pbsum ;
    T7 = 2.0e0 * ( VBI - Pb20b ) * `C_ESI * T2 * T4 * sqrt_Pbsum ;
    T8 = - 2.0e0 * T1 * T2 * T4 * sqrt_Pbsum ;
    T1 = UC_SC3 / Lgate ;
    T4 = UC_SC1 + T1 * Pbsum ;
    T5 = T4 + UC_SC2 * Vdsz * ( 1.0 +  SC4 * Pbsum );
    dVthSC = dVth0 * T5 ;

    //---------------------------------------------------*
    //* dVthW : narrow-channel effect.
    //*-----------------//
    T1 = 1.0 / Cox ;
    T2 = T1 * T1 ;
    T3 = 1.0 / ( Cox +  UC_WFC / Weff ) ;
    T4 = T3 * T3 ;
    T5 = T1 - T3 ;
    T6 = Qb0 * ( T2 - T4 ) ;
    dVthW = Qb0 * T5 + UC_WVTH0 / WG ;

    //---------------------------------------------------*
    //* dVth : Total variation.
    //* - Positive dVth means the decrease in Vth.
    //*-----------------//
    dVth = dVthSC + dVthLP + dVthW + dVthsm ;

    //---------------------------------------------------*
    //* Vth : Threshold voltage for OP.
    //*-----------------//
    T2 = sqrt( qnsub_esi2 * (Pb2-Vbsz) ) ;
    Vth = Pb2 + Vfb + T2 * Cox0_inv - dVth ;

    //-----------------------------------------------------------*
    //* Constants in the equation of Ps0 .
    //*-----------------//
    fac1 = cnst0 * Cox_inv ;
    fac1p2 = fac1 * fac1 ;

    //---------------------------------------------------*
    //* Poly-Depletion Effect
    //*-----------------//
    dPpg = 0.0 ;
    if ( flg_pgd == 1 ) begin
        T7 = Vgsz ;
        T0 = cnstpgd ;
        T3 = T7 - PGD2 ;
        `Fn_ExpLim( dPpg , T3 , T6 )
        `Fn_SZ( dPpg , dPpg - 1.0 , `pol_dlt , T6 )
        dPpg = dPpg * T0 ;
        `Fn_SU( dPpg , dPpg , `pol_b , `pol_dlt , T9 )

    end

    //     Vbscl_org = Vbscl ;
    //     VbscldVbs_org = VbscldVbs ;

    begin : Vbscl_local  // *******************************

        real Vbscl ;
        real VbscldVbs, Vzadd, Vbsz, Vdsz, Vgsz ;

        if (COVBSCL) begin

            // Clamping for Vbs > Vbs_bnd_local //
            if ( Vbs > Vbs_bnd_local ) begin  // Vbs_max_local and Vbs_bnd_local
                T1 = Vbs - Vbs_bnd_local ;
                T2 = Vbs_max_local - Vbs_bnd_local ;
                `Fn_SUPoly4m( TY , T1 , T2 , VbscldVbs , T0 )
                Vbscl    = Vbs_bnd_local    + TY ;

                T3 = 1 / T2 ;
                T4 = T1 * T3 ;
                T5 = T4 * T4;

                T7 = 1 + T4 + T5 * ( 1 + T4 + T5 ) ;
                VbscldVbs = ( 1 + 2 * T4 + 3 * T5 + 4 * T4 * T5)/(T7 * T7) ;
            end  else begin
                Vbscl     = Vbs ;
                VbscldVbs = 1.0 ;
            end

        end else begin
            Vbscl = Vbs ;
            VbscldVbs = 1.0 ;
        end

        //-----------------------------------------------------------*
        //* Update Vxsz (Modified bias introduced to realize symmetry at Vds=0).
        //*-----------------//
        T1 = VbscldVbs * Vds / 2 ;
        `Fn_SymAdd(  Vzadd , T1 , VZADD0 , T2 )
        if ( Vzadd < `ps_conv ) begin
            Vzadd = `ps_conv ;
        end
        Vbsz = Vbscl + Vzadd ;
        Vdsz = Vds + 2.0 * Vzadd ;
        Vgsz = Vgs + Vzadd ;

        //---------------------------------------------------*
        //* Vgp : Effective gate bias with SCE & RSCE & flatband.
        //*-----------------//
        Vgp = Vgs - Vfb + dVth - dPpg ;

        //---------------------------------------------------*
        //* Vgs_fb : Actual flatband voltage taking account Vbscl.
        //* - note: if Vgs == Vgs_fb then Vgp == Ps0 == Vbscl .
        //*------------------//
        Vgs_fb = Vfb - dVth + dPpg + Vbscl ;

`ifdef _AGING_
            //-----------------------------------------------------------*
            //* initilization for Trap simulation.
            //*-----------------//
            Ids_trap  = 0.0 ;
            Isub_trap = 0.0 ;
            keT       = `C_KB / `C_QE * TTEMP ;
            Qt0       = 0.0 ;
            DVddp     = 0.0 ;
            AVddp     = Vdse - Vds ;
            pretime0  = (DEGTIME0 > 0 ) ? DEGTIME0 * 0.01 : `pretime ;
            //*-----------------//
            Nt0s_temp = 0.0 ;
            Nt_max0 = 0.0 ;
            Nt_maxl = 0.0 ;
            MKS_TRAPGC1 = TRAPGC1 / `C_cm2m_p3 ;
            MKS_TRAPES1 = TRAPES1 ;
            MKS_TRAPGC0 = TRAPGC0 / `C_cm2m_p3 ;
            MKS_TRAPGCLIM = TRAPGCLIM / `C_cm2m_p3 ;
            MKS_TRAPGC2 = TRAPGC2 / `C_cm2m_p3 ;
            MKS_GC1MAX  = TRAPGC1MAX / `C_cm2m_p3 ;
            if ( TRAPGC1MAX == 0 ) begin
                nt0s      = 0.0 ;
                ntls      = 0.0 ;
            end else begin
                `Fn_calcNKT(NtK20,MKS_TRAPGC2,TRAPES2)
                `Fn_calcNKT(NtK30,MKS_TRAPGC0,TRAPES0)
                `Fn_calcNKT(NtK40,MKS_TRAPGCLIM,TRAPESLIM)

                //---------------------------------------------------*
                //* Trap estimation.
                //*-----------------//
                if ( analysis("tran") == 0 ) begin
                    Ps0_prv     = V(ps0) ;
                    Vtraplx_prv = V(vtraplx) ;
                end
                if ( CODEG == 1 ) begin // update NtK10
                    if ( CODEGSTEP == 0 ) begin
                        MKS_TRAPGC1 = V(vgc1) * 1e24 ;
                        MKS_TRAPES1 = V(ve1) ;
                    end else begin
                        MKS_TRAPGC1 = gc1 ;
                        MKS_TRAPES1 = e1  ;
                    end
                end
                `Fn_SL(MKS_TRAPES1, MKS_TRAPES1, 1e-6 , 1e-3 , T0)
                `Fn_calcNKT(NtK10,MKS_TRAPGC1,MKS_TRAPES1)
                `Fn_calc_TRAP( Nt_maxl , NtK10 , NtK20, NtK30, NtK40, Ps0_prv , 0 )
                Nt_max0 = Nt_maxl ;
                exp_time = (CODEG == 1 && TRAPTAUCAP > 0.0) ? lexp( - 0.5 * DEGTIME / TRAPTAUCAP ) : 0.0 ;
                nt0s  = ( Nt_max0 * (1.0 + Nt0s_temp) ) * ( 1 - exp_time ) ;
                ntls  = nt0s ;
            end // end of Trap estimation

`ifdef _AGING_DEBUG_
                $write( "debugz %m Vgs %g Vgp %g NtK10 %g NtK20 %g Nt_max0 %g nt0s %g MKS_TRAPGC1 %g MKS_TRAPES1 \n",
                Vgs, Vgp, NtK10 , NtK20, Nt_max0, nt0s , MKS_TRAPGC1 , MKS_TRAPES1 ) ;
                $write( "debugz1 abstime %g %m nt0s %g Isub_trap %g \n", $abstime, nt0s, Isub_trap );
`endif

`endif // _AGING_

        if ( UC_CODEP != 0 ) begin

            //---------------------------------------------------*
            //* depletion MOS mode
            //*------------------//

            case (CODEP)
                1: begin // 2.2.0 old Model
// ---- begin `include "HSMHV_depmos.inc" ----
/***********************************************************************

 HiSIM (Hiroshima University STARC IGFET Model)
 Copyright (C) 2000-2016 Hiroshima University and STARC
 Copyright (C) 2016-2023 Hiroshima University
 HiSIM_HV (High-Voltage Model)
 Copyright (C) 2007-2016 Hiroshima University and STARC
 Copyright (C) 2016-2023 Hiroshima University

 MODEL NAME : HiSIM_HV
 ( VERSION : 2  SUBVERSION : 5  REVISION : 1 )
 Model Parameter 'VERSION' : 2.51
 FILE : vaFiles/HSMHV_depmos.inc

 Date : 2023.02.09

 released by Hiroshima University

***********************************************************************/
//
////////////////////////////////////////////////////////////////
//
//
//
//
//Licensed under the Educational Community License, Version 2.0
//(the "License"); you may not use this file except in
//compliance with the License.
//
//You may obtain a copy of the License at:
//
//      http://opensource.org/licenses/ECL-2.0
//
//Unless required by applicable law or agreed to in writing,
//software distributed under the License is distributed on an
//"AS IS" BASIS, WITHOUT WARRANTIES OR CONDITIONS OF ANY KIND,
//either express or implied. See the License for the specific
//language governing permissions and limitations under the
//License.
//
//
//The HiSIM_HV standard has been supported by the members of
//Silicon Integration Initiative's Compact Model Coalition. A
//link to the most recent version of this standard can be found
//at:
//
//http://www.si2.org/cmc
//
////////////////////////////////////////////////////////////////
//

begin : HSMHV_depmos

    //* for depletion mode MOS *
    real W_b0, W_bL, W_s0, W_sL, W_sub0, W_subL ;
    real W_bsub0, W_bsubL ;
    real vthn, afact, bfact, cfact, afact2, afact3  ;
    real phi_s0_DEP, phi_sL_DEP , Vbi_DEP ;
    real phi_j0_DEP, phi_jL_DEP, Vgp0, Psbmax ;
    real y0 ;

    real phi_s0_DEP_old, phi_b0_DEP_old, phi_bL_DEP_old, phi_j0_DEP_old, phi_jL_DEP_old ;
    real phi_sL_DEP_old ;
    real Q_s0, Q_sL, Q_sub0, Q_subL ;
    integer depmode ;

    real phi_s0_DEP_ini, phi_sL_DEP_ini, phi_b0_DEP_ini ;
    real phi_b0_DEP,  phi_bL_DEP ;

    real y1, y2 ;
    real y11, y12, y21, y22, dety ;
    real rev11, rev12, rev21, rev22 ;
    real Qn_res0 ;
    real Q_b0_dep, Q_sub0_dep, Q_bL_dep, Q_subL_dep ;

    real W_res0 ;

    real q_Ndepm_esi,Idd_drift,Idd_diffu,Qn_bac ;
    real Mu_res, Mu_bac ;

    real dydPsm ;

    real Vgp1, Vgp0old, Vds_maxb0, Vds_maxbL, phi_j0_DEP_acc, phi_jL_DEP_acc ;
    real Q_n0_cur, Q_nL_cur ;
    real  Q_s0_dep, Q_sL_dep ;

    real sm_delta ;
    real phib_ref, phib_ref_dPs, phib_ref_dPd ;
    real Q_s0_dPs, Q_sL_dPs, Q_s0_dPb, Q_sL_dPb ;
    real Q_b0_dep_dPb, Q_bL_dep_dPb, Q_b0_dep_dPd, Q_bL_dep_dPd, Q_sub0_dep_dPd, Q_subL_dep_dPd ;
    real phi_j0_DEP_dPb, phi_jL_DEP_dPb ;
    real NdepmpNsub_inv1, NdepmpNsub ;
    real Vgpp ;

    real Q_n0, Q_nL, Qn_delta ;

    real C_QE2, C_ESI2, Tn2 ;
    real q_Nsub, Ndepm2, q_Ndepm ;
    real C_2ESIpq_Ndepm, C_2ESIpq_Ndepm_inv , C_2ESI_q_Ndepm ;
    real C_2ESIpq_Nsub , C_2ESIpq_Nsub_inv ;
    real ps_conv3 , ps_conv23 ;
    real Ids_bac, Edri ;
    real Qn_drift ;
    real Vdseff0 ;
    real Ey_suf ;

    // for Vdseff calculation
`define DEPQFN3    0.3
`define DEPQFN_dlt 2.0

    // for Current Smoothing
`define Ps_delta   0.06
`define Ps_delta0  0.10

    // Constants
    Vbi_DEP = Vbipn ;
    q_Ndepm = `C_QE * UC_NDEPM ;
    Ndepm2  = UC_NDEPM * UC_NDEPM ;
    q_Ndepm_esi = `C_QE * UC_NDEPM * `C_ESI ;
    q_Nsub = `C_QE * EF_NSUBC ;
    C_QE2  = `C_QE * `C_QE ;
    C_ESI2 = `C_ESI * `C_ESI ;
    Tn2    = UC_DEPTHN * UC_DEPTHN ;
    C_2ESIpq_Ndepm = 2.0 *`C_ESI/q_Ndepm ;
    C_2ESIpq_Ndepm_inv = q_Ndepm / (2.0 * `C_ESI) ;
    C_2ESI_q_Ndepm = 2.0 * `C_ESI * q_Ndepm ;
    C_2ESIpq_Nsub  = 2.0 * `C_ESI / q_Nsub  ;
    C_2ESIpq_Nsub_inv  = q_Nsub / (2.0 * `C_ESI) ;
    NdepmpNsub  = UC_NDEPM / EF_NSUBC ;
    NdepmpNsub_inv1  = 1.0 / (1.0 + NdepmpNsub ) ;
    ps_conv3  = `ps_conv * 1000.0 ;
    ps_conv23 = `ps_conv2 * 1000.0 ;

    // for Initialization
    phi_s0_DEP = 0.0 ;
    phi_sL_DEP = 0.0 ;
    Q_s0       = 0.0 ;
    Q_sL       = 0.0 ;
    Q_s0_dep   = 0.0 ;
    Q_sL_dep   = 0.0 ;
    Q_b0_dep   = 0.0 ;
    Q_bL_dep   = 0.0 ;
    Q_sub0_dep = 0.0 ;
    Q_subL_dep = 0.0 ;
    phib_ref   = 0.0 ;

    //---------------------------------------------------*
    //* depletion MOS mode
    //*------------------//

    //---------------------------------------------------*
    //* start of Ps0 calculation. (label)
    //*-----------------//

    //---------------------------------------------------*
    //* region judgement
    //*------------------//

    Vgp = Vgp + `epsm10 * 1.0e7 ;

    afact = Cox * Cox / cnst0 / cnst0 ;
    afact2 = afact / Nin / Nin * Ndepm2 ;
    W_bsub0 = sqrt(C_2ESIpq_Ndepm * EF_NSUBC / (EF_NSUBC + UC_NDEPM) * ( - Vbscl + Vbi_DEP)) ;

    /* fully depleted case */
    if ( W_bsub0 > UC_DEPTHN ) begin

        Vgp0 = 0.0;

        W_b0 = UC_DEPTHN ;
        phi_b0_DEP = 0.0 ;
        phi_j0_DEP = phi_b0_DEP - C_2ESIpq_Ndepm_inv * W_b0 * W_b0 ;
        Vds_maxb0 = 0.0 ;

        Vgp0old = Vgp0 ;
        phi_j0_DEP_old = phi_j0_DEP ;

        for ( lp_s0 = 1 ; lp_s0 <= `lp_se_max + 1 ; lp_s0 = lp_s0 + 1 ) begin

            W_b0 = sqrt(C_2ESIpq_Ndepm * (phi_b0_DEP - phi_j0_DEP) ) ;
            `Fn_SU_CP( W_b0 , W_b0 , UC_DEPTHN , 1e-8, 2 , T0 )

            T1 = phi_j0_DEP - Vbscl+ Vbi_DEP ;
            `Fn_SL_CP( T2 , T1 , 0.0 , 0.1, 2 , T7 )
            W_sub0 = sqrt(C_2ESIpq_Nsub * T2 ) ;

            Q_b0_dep = W_b0 * q_Ndepm ;
            Q_b0_dep_dPd = - `C_ESI / W_b0 * T0 ;
            Q_sub0_dep = - W_sub0 * q_Nsub ;
            Q_sub0_dep_dPd = - `C_ESI / W_sub0 * T7 ;

            y1 = Cox * (Vgp0 - phi_b0_DEP) + Q_b0_dep + Q_sub0_dep ;
            y11 = Cox ;
            y12 = Q_b0_dep_dPd + Q_sub0_dep_dPd ;

            y2 = phi_j0_DEP - NdepmpNsub_inv1 * (NdepmpNsub * phi_b0_DEP + Vbscl - Vbi_DEP) ;
            y21 = 0.0 ;
            y22 = 1.0 ;

            dety = y11 * y22 - y21 * y12;
            rev11 = (y22) / dety ;
            rev12 = ( - y12) / dety ;
            rev21 = ( - y21) / dety ;
            rev22 = (y11) / dety ;

            if ( abs( rev11 * y1 + rev12 * y2 ) > 0.5 ) begin
                Vgp0 = Vgp0 - 0.5 * `Fn_Sgn( rev11 * y1 + rev12 * y2 ) ;
                phi_j0_DEP = phi_j0_DEP - 0.5 * `Fn_Sgn( rev21 * y1 + rev22 * y2 ) ;
            end else begin
                Vgp0 = Vgp0 - ( rev11 * y1 + rev12 * y2 ) ;
                phi_j0_DEP = phi_j0_DEP - ( rev21 * y1 + rev22 * y2 ) ;
            end

            if ( abs(Vgp0 - Vgp0old) <= `ps_conv &&
                 abs(phi_j0_DEP - phi_j0_DEP_old) <= `ps_conv ) lp_s0=`lp_se_max + 1 ;

                Vgp0old = Vgp0 ;
            phi_j0_DEP_old = phi_j0_DEP ;
        end
        phi_j0_DEP_acc = phi_j0_DEP ;

        W_sub0 = UC_DEPTHN * NdepmpNsub ;
        phi_j0_DEP = C_2ESIpq_Nsub_inv * W_sub0 * W_sub0 + Vbscl - Vbi_DEP ;
        phi_b0_DEP = phi_j0_DEP + C_2ESIpq_Ndepm_inv * Tn2 ;
        phi_s0_DEP = phi_b0_DEP ;
        Psbmax = phi_b0_DEP ;
        Vgp1 = phi_b0_DEP ;
        if ( Vgp > Vgp0 ) begin
            depmode = 1 ;
        end else if (Vgp > Vgp1 ) begin
            depmode = 3 ;
        end else begin
            depmode = 2 ;
        end

        /* else */
    end else begin
        Vgp0 = 0.0 ;
        Vgp1 = Vgp0 ;
        Psbmax = 0.0 ;
        Vds_maxb0 = Vgp0 ;
        W_b0 = W_bsub0 ;
        W_sub0 = W_b0 * NdepmpNsub ;
        phi_j0_DEP = C_2ESIpq_Nsub_inv * W_sub0 * W_sub0 + Vbscl - Vbi_DEP ;
        phi_b0_DEP = C_2ESIpq_Ndepm_inv * W_b0 * W_b0 + phi_j0_DEP ;
        phi_j0_DEP_acc = phi_j0_DEP ;
        if ( Vgp > Vgp0 ) begin
            depmode = 1 ;
        end else begin
            depmode = 2 ;
        end

    end

    T1 = C_2ESI_q_Ndepm * ( Psbmax - ( - Pb2n + Vbscl)) ;
    if ( T1 > 0.0 ) begin
        vthn = - Pb2n + Vbscl - sqrt(T1) / Cox ;
    end else begin
        vthn = - Pb2n + Vbscl ;
    end

    //---------------------------------------------------*
    //* initial potential Ps0,Pb0,Pj0 calculated.
    //*------------------//

    /* accumulation region */
    if ( Vgp > Vgp0 ) begin
        phi_j0_DEP = phi_j0_DEP_acc ;
        phi_b0_DEP = 0.0 ;
        phi_s0_DEP_ini = ln(afact * Vgp * Vgp) / (beta + 2.0 / Vgp) + phi_b0_DEP ;
        if ( phi_s0_DEP_ini < Vds_maxb0 + ps_conv23 ) phi_s0_DEP_ini = Vds_maxb0 + ps_conv23 ;

        /* fully depleted region */
    end else if ( Vgp > Vgp1 ) begin

        phi_s0_DEP_ini = phi_s0_DEP ;

        /* depletion and inversion region */
    end else begin

        /* depletion region */
        if ( Vgp > vthn ) begin
            bfact = - 2.0 * afact * Vgp + beta ;
            cfact = afact * Vgp * Vgp - beta * phi_b0_DEP ;
            phi_b0_DEP_old = phi_b0_DEP ;

            phi_s0_DEP_ini = ( - bfact + sqrt(bfact * bfact - 4.0 * afact * cfact)) / 2.0 / afact ;
            if ( phi_s0_DEP_ini > Psbmax - ps_conv3 ) phi_s0_DEP_ini = Psbmax - ps_conv3 ;

            W_s0 = sqrt(C_2ESIpq_Ndepm * (phi_b0_DEP - phi_s0_DEP_ini) ) ;
            W_b0 = sqrt(C_2ESIpq_Ndepm * (phi_b0_DEP - phi_j0_DEP) ) ;

            if ( W_s0 + W_b0 > UC_DEPTHN ) begin
                for ( lp_s0 = 1 ; lp_s0 <= `lp_se_max + 1 ; lp_s0 = lp_s0 + 1 ) begin

                    y0 = W_s0 + W_b0 - UC_DEPTHN ;

                    dydPsm = `C_ESI / q_Ndepm / W_s0 + `C_ESI / q_Ndepm * ( 1.0 - (NdepmpNsub) / ( 1.0 + (NdepmpNsub))) / W_b0 ;

                    if ( abs(y0 / dydPsm) > 0.5 ) begin
                        phi_b0_DEP = phi_b0_DEP - 0.5 * `Fn_Sgn(y0 / dydPsm) ;
                    end else begin
                        phi_b0_DEP = phi_b0_DEP - y0 / dydPsm ;
                    end
                    if ( (phi_b0_DEP - Vbscl + Vbi_DEP) < `epsm10 ) phi_b0_DEP=Vbscl - Vbi_DEP + `epsm10 ;

                    cfact = afact * Vgp * Vgp - beta * phi_b0_DEP ;
                    T1 = bfact * bfact - 4.0 * afact * cfact ;
                    if ( T1 > 0.0 ) begin
                        phi_s0_DEP_ini = ( - bfact + sqrt(T1)) / 2.0 / afact ;
                    end else begin
                        phi_s0_DEP_ini = ( - bfact) / 2.0 / afact ;
                    end

                    if ( phi_s0_DEP_ini > Psbmax ) phi_s0_DEP_ini = Psbmax ;
                    if ( phi_s0_DEP_ini > phi_b0_DEP ) begin
                        phi_s0_DEP_ini = phi_b0_DEP - ps_conv23 ;
                        lp_s0=`lp_se_max + 1 ;
                    end

                    W_s0 = sqrt(C_2ESIpq_Ndepm * (phi_b0_DEP - phi_s0_DEP_ini) ) ;
                    phi_j0_DEP = ( NdepmpNsub * phi_b0_DEP + Vbscl - Vbi_DEP) / (1.0 + NdepmpNsub) ;
                    W_b0 = sqrt(C_2ESIpq_Ndepm * (phi_b0_DEP - phi_j0_DEP) ) ;

                    if ( abs(phi_b0_DEP - phi_b0_DEP_old) <= 1.0e-8 ) lp_s0=`lp_se_max + 1 ;
                    phi_b0_DEP_old = phi_b0_DEP ;
                end
            end

        end else begin

            afact3 = afact2 / exp(beta * Vbscl) ;
            phi_b0_DEP_old = phi_b0_DEP ;
            phi_s0_DEP_ini = ln(afact3 * Vgp * Vgp) / ( - beta + 2.0 / Vgp) ;
            W_s0 = sqrt(C_2ESIpq_Ndepm * (phi_b0_DEP - phi_s0_DEP_ini) ) ;
            W_b0 = sqrt(C_2ESIpq_Ndepm * (phi_b0_DEP - phi_j0_DEP) ) ;
            if ( W_s0 + W_b0 >  UC_DEPTHN ) begin
                for ( lp_s0 = 1 ; lp_s0 <= lp_s0_max + 1 ; lp_s0 = lp_s0 + 1 ) begin

                    y0 = W_s0 + W_b0 - UC_DEPTHN ;
                    dydPsm = `C_ESI / q_Ndepm / W_s0 + `C_ESI / q_Ndepm * ( 1.0 - (NdepmpNsub) / ( 1.0 + (NdepmpNsub))) / W_b0 ;

                    if ( abs(y0 / dydPsm) > 0.5 ) begin
                        phi_b0_DEP = phi_b0_DEP - 0.5 * `Fn_Sgn(y0 / dydPsm) ;
                    end else begin
                        phi_b0_DEP = phi_b0_DEP - y0 / dydPsm ;
                    end
                    if ( (phi_b0_DEP - Vbscl + Vbi_DEP) < `epsm10 ) phi_b0_DEP=Vbscl - Vbi_DEP + `epsm10 ;

                    W_s0 = sqrt(C_2ESIpq_Ndepm * (phi_b0_DEP - phi_s0_DEP_ini) ) ;
                    phi_j0_DEP = ( NdepmpNsub * phi_b0_DEP + Vbscl - Vbi_DEP) / (1.0 + NdepmpNsub) ;
                    W_b0 = sqrt(C_2ESIpq_Ndepm * (phi_b0_DEP - phi_j0_DEP) ) ;

                    if ( abs(phi_b0_DEP - phi_b0_DEP_old) <= 1.0e-5 ) lp_s0=lp_s0_max + 1 ;
                    phi_b0_DEP_old = phi_b0_DEP ;
                end

            end
        end // end of phi_b0_DEP loop //

    end

    phi_b0_DEP_ini = phi_b0_DEP ;

    /*                               */
    /* solve poisson at source side  */
    /*                               */

    sm_delta = 0.12 ;

    flg_conv = 0 ;

    phi_s0_DEP = phi_s0_DEP_ini ;
    phi_b0_DEP = phi_b0_DEP_ini ;

    phi_s0_DEP_old = phi_s0_DEP ;
    phi_b0_DEP_old = phi_b0_DEP ;

    for ( lp_s0 = 1 ; lp_s0 <= `lp_se_max + 1 ; lp_s0 = lp_s0 + 1 ) begin

        phi_j0_DEP  = NdepmpNsub_inv1 * (NdepmpNsub * phi_b0_DEP + Vbscl - Vbi_DEP) ;
        phi_j0_DEP_dPb = NdepmpNsub_inv1 * NdepmpNsub ;

        T1 = phi_b0_DEP - phi_j0_DEP ;
        `Fn_SL_CP( T2 , T1 , 0.0 , 0.1, 2 , T0 )
        W_b0 = sqrt(C_2ESIpq_Ndepm * (T2) ) ;
        `Fn_SU_CP( W_b0 , W_b0 , UC_DEPTHN , 1e-8, 2 , T3 )

        W_sub0 = sqrt(C_2ESIpq_Nsub * (phi_j0_DEP - Vbscl + Vbi_DEP) ) ;
        Q_b0_dep = W_b0 * q_Ndepm ;
        Q_b0_dep_dPb = `C_ESI / W_b0 * T0 * T3 ;
        Q_b0_dep_dPd = - `C_ESI / W_b0 * T0 * T3 ;
        Q_sub0_dep = - W_sub0 * q_Nsub ;
        Q_sub0_dep_dPd = - `C_ESI / W_sub0 ;

        T1 = 8.0 * q_Ndepm_esi * Tn2 ;
        phib_ref = (4.0 * phi_j0_DEP * phi_j0_DEP * C_ESI2 - 8.0 * phi_j0_DEP * C_ESI2 * phi_s0_DEP
               + 4.0 * C_ESI2 * phi_s0_DEP * phi_s0_DEP
               + 4.0 * phi_j0_DEP * q_Ndepm_esi * Tn2
               + 4.0 * phi_s0_DEP * q_Ndepm_esi * Tn2
               + Ndepm2 * C_QE2 * Tn2 * Tn2) / T1 ;
        phib_ref_dPs = ( - 8.0 * phi_j0_DEP * C_ESI2 + 4.0 * C_ESI2 * phi_s0_DEP * 2.0
               + 4.0 * q_Ndepm_esi * Tn2) / T1 ;
        phib_ref_dPd = (4.0 * phi_j0_DEP * C_ESI2 * 2.0 - 8.0 * C_ESI2 * phi_s0_DEP
               + 4.0 * q_Ndepm_esi * Tn2) / T1 ;

        T1 = beta * (phi_s0_DEP - phi_b0_DEP) ;
        T2 = exp(T1) ;
        if ( phi_s0_DEP >= phi_b0_DEP ) begin
            Q_s0 = - cnst0 * sqrt(T2 - 1.0 - T1 + 1e-15) ;
            Q_s0_dPs = 0.5 * cnst0 * cnst0 / Q_s0 * (beta * T2 - beta ) ;
            Q_s0_dPb = - Q_s0_dPs ;
        end else begin
            T3 = exp( - beta * (phi_s0_DEP - Vbscl)) ;
            T4 = exp( - beta * (phi_b0_DEP - Vbscl)) ;
            Q_s0 = cnst0 * sqrt(T2 - 1.0 - T1 + 1e-15 + cnst1 * (T3 - T4) ) ;
            T5 = 0.5 * cnst0 * cnst0 / Q_s0 ;
            Q_s0_dPs = T5 * (beta * T2 - beta + cnst1 * ( - beta * T3) ) ;
            Q_s0_dPb = T5 * ( - beta * T2 + beta + cnst1 * beta * T4 ) ;
        end

        `Fn_SU_CP( T1 , phib_ref , Vds_maxb0 , sm_delta, 4 , T0 )

        y1 = phi_b0_DEP - T1 ;
        y11 = - phib_ref_dPs * T0 ;
        y12 = 1.0 - phib_ref_dPd * phi_j0_DEP_dPb * T0 ;

        y2 = Cox * (Vgp - phi_s0_DEP) + Q_s0 + Q_b0_dep + Q_sub0_dep ;
        y21 = - Cox + Q_s0_dPs ;
        y22 = Q_s0_dPb + Q_b0_dep_dPb + Q_b0_dep_dPd * phi_j0_DEP_dPb + Q_sub0_dep_dPd * phi_j0_DEP_dPb ;

        dety = y11 * y22 - y21 * y12;
        rev11 = (y22) / dety ;
        rev12 = ( - y12) / dety ;
        rev21 = ( - y21) / dety ;
        rev22 = (y11) / dety ;
        if ( abs( rev21 * y1 + rev22 * y2 ) > 0.5 ) begin
            phi_s0_DEP = phi_s0_DEP - 0.5 * `Fn_Sgn( rev11 * y1 + rev12 * y2 ) ;
            phi_b0_DEP = phi_b0_DEP - 0.5 * `Fn_Sgn( rev21 * y1 + rev22 * y2 ) ;
        end else begin
            phi_s0_DEP = phi_s0_DEP - ( rev11 * y1 + rev12 * y2 ) ;
            phi_b0_DEP = phi_b0_DEP - ( rev21 * y1 + rev22 * y2 ) ;
        end

        if ( abs(phi_s0_DEP - phi_s0_DEP_old) <= `ps_conv &&  abs(phi_b0_DEP - phi_b0_DEP_old) <= `ps_conv ) begin
            lp_s0=`lp_se_max + 1 ;
            flg_conv = 1 ;
        end

        phi_s0_DEP_old = phi_s0_DEP ;
        phi_b0_DEP_old = phi_b0_DEP ;

    end

    if ( flg_conv == 0 ) begin
        $write( "*** warning(HiSIM_HV(%m)): Went Over Iteration Maximum(Ps0)\n" ) ;
        $write( " Vbse   = %7.3f Vdse = %7.3f Vgse = %7.3f\n" ,Vbse , Vdse , Vgse ) ;
    end

    if ( W_bsub0 > UC_DEPTHN && depmode !=2 ) begin
        `Fn_SU_CP(phi_b0_DEP , phi_b0_DEP , phi_s0_DEP , 0.02, 2 , T1 )
    end

    phi_j0_DEP  = NdepmpNsub_inv1 * (NdepmpNsub * phi_b0_DEP + Vbscl - Vbi_DEP) ;

    T1 = beta * (phi_s0_DEP - phi_b0_DEP) ;
    T2 = exp(T1) ;
    if ( phi_s0_DEP >= phi_b0_DEP ) begin
        Q_s0 = - cnst0 * sqrt(T2 - 1.0e0 - T1 + 1e-15 ) ;
        Q_n0 = Q_s0 ;

        Q_s0_dep = 0.0 ;
        Q_sub0 = 0.0 ;

        W_b0 = sqrt(C_2ESIpq_Ndepm * (phi_b0_DEP - phi_j0_DEP) ) ;
        `Fn_SU_CP( W_b0 , W_b0 , UC_DEPTHN , 1e-8, 2 , T3 )
        W_sub0 = sqrt(C_2ESIpq_Nsub * (phi_j0_DEP - Vbscl + Vbi_DEP) ) ;
        Q_b0_dep = W_b0 * q_Ndepm ;
        Q_sub0_dep = - W_sub0 * q_Nsub ;
    end else begin
        T3 = exp( - beta * (phi_s0_DEP - Vbscl)) ;
        T4 = exp( - beta * (phi_b0_DEP - Vbscl)) ;
        Q_s0 = cnst0 * sqrt(T2 - 1.0 - T1 + cnst1 * (T3 - T4) + 1e-15) ;

        if ( W_bsub0 > UC_DEPTHN && depmode !=2 ) begin
            Q_sub0 = 0.0 ;
            Q_s0_dep = 0.0 ;
        end else begin
            T3 = cnst0 * sqrt( - T1
               + cnst1 * (exp( - beta * (phi_s0_DEP - Vbscl)) - exp( - beta * (phi_b0_DEP - Vbscl)))) ;
            Q_sub0 = T3 - cnst0 * sqrt( - T1)  ;
            Q_s0_dep = cnst0 * sqrt(T2 - 1.0e0 - T1 + 1e-15) ;
        end

        Q_n0 = 0.0 ;

        T1 = phi_b0_DEP - phi_j0_DEP ;
        `Fn_SL_CP( T2 , T1 , 0.0 , 0.1, 2 , T0 )
        W_b0 = sqrt(C_2ESIpq_Ndepm * (T2) ) ;
        `Fn_SU_CP( W_b0 , W_b0 , UC_DEPTHN , 1e-8, 2 , T3 )
        W_sub0 = sqrt(C_2ESIpq_Nsub * (phi_j0_DEP - Vbscl + Vbi_DEP) ) ;
        Q_b0_dep = W_b0 * q_Ndepm ;
        Q_sub0_dep = - W_sub0 * q_Nsub ;

    end

    T1 = phi_b0_DEP - phi_j0_DEP ;
    `Fn_SL_CP( T2 , T1 , 0.0 , 0.1, 2 , T0 )
    W_b0 = sqrt(C_2ESIpq_Ndepm * (T2) ) ;
    `Fn_SU_CP( W_b0 , W_b0 , UC_DEPTHN , 1e-8, 2 , T3 )

    T1 = phi_b0_DEP - phi_s0_DEP ;
    `Fn_SL_CP( T2 , T1 , 0.0 , 0.05, 2 , T0 )
    W_s0 = sqrt(C_2ESIpq_Ndepm * (T2) ) ;

    T1 = UC_DEPTHN - W_b0 - W_s0 ;
    `Fn_SL_CP( W_res0 , T1 , 1e-25 , 1e-18, 2 , T0 )

    Qn_res0 = - W_res0 * q_Ndepm ;

    if ( W_bsub0 > UC_DEPTHN && depmode !=2 ) begin
        `Fn_SU_CP(T2 , phi_s0_DEP , Vds_maxb0 , 0.8, 2 , T1 )
    end else begin
        `Fn_SU_CP( T2 , phib_ref , Vds_maxb0 , 0.8, 2 , T0 )
    end

    Qn_bac = - `C_QE * UC_NDEPM * exp(beta * (T2 - Vds_maxb0)) * W_b0 ;

    `Fn_SL_CP( T2 , (phi_s0_DEP - Vds_maxb0) , 0.0, `Ps_delta, 2 , T0 )
    T4 = exp(beta * (T2)) - 1.0 - beta * (T2) + `epsm10 ;

    Q_n0_cur = - cnst0 * sqrt(T4) ;

    T4 = exp(beta * (`Ps_delta0)) - 1.0 - beta * (`Ps_delta0) ;
    Qn_delta = cnst0 * sqrt(T4) ;

    //-----------------------------------------------------------*
    //* Start point of Psl(= Ps0 + Pds) calculation.(label)
    //*-----------------//

    // start_of_Psl:

    // Vdseff(begin) //
    Vdsorg = Vds ;

    if ( Vds > 1e-6 ) begin

        T2 = q_Ndepm_esi / ( Cox * Cox ) ;
        T0 = Vgp + 2.0 - beta_inv - Vbsz ;
        T4 = 1.0e0 + 2.0e0 / T2 * T0 ;
        `Fn_SL_CP( T9 , T4 , 0 , `DEPQFN_dlt , 2 , T0 )
        T9 = T9 + `Small ;
        T3 = sqrt( T9 ) ;
        T4 = T2 * ( 1.0e0 - T3 ) ;
        T10 = Vgp + 2.0 + T4 ;

        `Fn_SL_CP( T10 , T10 , `DEPQFN3 , 0.2, 4 , T0 )
        T10 = T10 + `epsm10 ;

        T1 = Vds / T10 ;
        T2 = `Fn_Pow( T1 , DDLTe-1.0e0 ) ;
        T7 = T2 * T1 ;
        T3 = 1.0 + T7 ;
        T4 = `Fn_Pow( T3 , 1.0 / DDLTe-1.0 ) ;
        T6 = T4 * T3  ;
        Vdseff = Vds / T6 ;

        `Fn_SL_CP( Vgpp , Vgp , 0.0 , 0.5, 2 , T0 )

        T1 = Vgpp * 0.8 ;

        `Fn_SU_CP( Vds , Vdseff , Vgpp , T1, 2 , T0 )

    end else begin
        Vdseff = Vds ;
    end

    //---------------------------------------------------*
    //* start of Psl calculation. (label)
    //*-----------------//

    if ( Vds <= 0.0e0 ) begin

        phi_sL_DEP = phi_s0_DEP ;
        phi_bL_DEP = phi_b0_DEP ;
        phi_jL_DEP = phi_j0_DEP ;

        Q_subL = Q_sub0 ;
        Q_nL = Q_n0 ;
        Q_bL_dep = Q_b0_dep ;
        Q_subL_dep = Q_sub0_dep ;
        Q_sL_dep = Q_s0_dep ;
        Q_nL_cur = Q_n0_cur ;

    end else begin

        W_bsubL = sqrt(C_2ESIpq_Ndepm * EF_NSUBC / (EF_NSUBC + UC_NDEPM) * (Vds - Vbscl + Vbi_DEP)) ;

        //---------------------------------------------------*
        //* region judgement
        //*------------------//

        /* fully depleted case */
        if ( W_bsubL > UC_DEPTHN ) begin

            Vgp0 = Vds ;
            W_bL = UC_DEPTHN ;
            phi_bL_DEP = Vds ;
            Vds_maxbL = Vds ;
            phi_jL_DEP = phi_bL_DEP - C_2ESIpq_Ndepm_inv * W_bL * W_bL ;

            Vgp0old = Vgp0 ;
            phi_jL_DEP_old = phi_jL_DEP ;

            Q_bL_dep = W_bL * q_Ndepm ;

            for ( lp_s0 = 1 ; lp_s0 <= `lp_se_max + 1 ; lp_s0 = lp_s0 + 1 ) begin

                W_bL = sqrt(C_2ESIpq_Ndepm * (phi_bL_DEP - phi_jL_DEP) ) ;
                `Fn_SU_CP( W_bL , W_bL , UC_DEPTHN , 1e-8, 2 , T0 )

                T1 = phi_jL_DEP - Vbscl + Vbi_DEP ;
                `Fn_SL_CP( T2 , T1 , 0.0 , 0.1, 2 , T7 )
                W_subL = sqrt(C_2ESIpq_Nsub * T2 ) ;

                Q_bL_dep = W_bL * q_Ndepm ;
                Q_bL_dep_dPd = - `C_ESI / W_bL * T0 ;
                Q_subL_dep = - W_subL * q_Nsub ;
                Q_subL_dep_dPd = - `C_ESI / W_subL * T7 ;

                y1 = Cox * (Vgp0 - phi_bL_DEP) + Q_bL_dep + Q_subL_dep ;
                y11 = Cox ;
                y12 = Q_bL_dep_dPd + Q_subL_dep_dPd ;

                y2 = phi_jL_DEP - NdepmpNsub_inv1 * (NdepmpNsub * phi_bL_DEP + Vbscl - Vbi_DEP) ;
                y21 = 0.0 ;
                y22 = 1.0 ;

                dety = y11 * y22 - y21 * y12;
                rev11 = (y22) / dety ;
                rev12 = ( - y12) / dety ;
                rev21 = ( - y21) / dety ;
                rev22 = (y11) / dety ;

                if ( abs( rev11 * y1 + rev12 * y2 ) > 0.5 ) begin
                    Vgp0 = Vgp0 - 0.5 * `Fn_Sgn( rev11 * y1 + rev12 * y2 ) ;
                    phi_jL_DEP = phi_jL_DEP - 0.5 * `Fn_Sgn( rev21 * y1 + rev22 * y2 ) ;
                end else begin
                    Vgp0 = Vgp0 - ( rev11 * y1 + rev12 * y2 ) ;
                    phi_jL_DEP = phi_jL_DEP - ( rev21 * y1 + rev22 * y2 ) ;
                end

                if ( abs(Vgp0 - Vgp0old) <= `ps_conv &&
                    abs(phi_jL_DEP - phi_jL_DEP_old) <= `ps_conv ) lp_s0=`lp_se_max + 1 ;

                    Vgp0old = Vgp0 ;
                phi_jL_DEP_old = phi_jL_DEP ;
            end
            phi_jL_DEP_acc = phi_jL_DEP ;

            W_subL = UC_DEPTHN * NdepmpNsub ;
            phi_jL_DEP = C_2ESIpq_Nsub_inv * W_subL * W_subL + Vbscl - Vbi_DEP ;
            phi_bL_DEP = phi_jL_DEP + C_2ESIpq_Ndepm_inv * Tn2 ;
            phi_sL_DEP = phi_bL_DEP ;
            Psbmax = phi_bL_DEP ;
            Vgp1 = phi_bL_DEP ;
            if ( Vgp > Vgp0 ) begin
                depmode = 1 ;
            end else if (Vgp > Vgp1 ) begin
                depmode = 3 ;
            end else begin
                depmode = 2 ;
            end

            /* else */
        end else begin
            Vgp0 = Vds ;
            Vgp1 = Vgp0 ;
            Psbmax = Vgp0 ;
            Vds_maxbL = Vgp0 ;
            W_bL = W_bsubL ;
            W_subL = W_bL * NdepmpNsub ;
            phi_jL_DEP = C_2ESIpq_Nsub_inv * W_subL * W_subL + Vbscl - Vbi_DEP ;
            phi_bL_DEP = C_2ESIpq_Ndepm_inv * W_bL * W_bL + phi_jL_DEP ;
            phi_jL_DEP_acc = phi_jL_DEP ;
            if ( Vgp > Vgp0 ) begin
                depmode = 1 ;
            end else begin
                depmode = 2 ;
            end

        end

        T1 = C_2ESI_q_Ndepm * ( Psbmax - ( - Pb2n + Vbscl)) ;
        if ( T1 > 0.0 ) begin
            vthn = - Pb2n + Vbscl - sqrt(T1) / Cox ;
        end else begin
            vthn = - Pb2n + Vbscl ;
        end

        //---------------------------------------------------*
        //* initial potential Ps0,Pbl,Pjl calculated.
        //*------------------//

        /* accumulation region */
        if ( Vgp > Vgp0 ) begin
            phi_jL_DEP = phi_jL_DEP_acc ;
            phi_bL_DEP = Vds ;
            phi_sL_DEP_ini = ln(afact * Vgp * Vgp) / (beta + 2.0 / Vgp) + Vds ;

            if ( phi_sL_DEP_ini < Vds_maxbL + ps_conv23 ) phi_sL_DEP_ini = Vds_maxbL + ps_conv23 ;

            /* fully depleted region */
        end else if ( Vgp > Vgp1 ) begin

            phi_sL_DEP_ini = phi_sL_DEP ;

            /* depletion & inversion */

        end else begin

            /* depletion */
            if ( Vgp > vthn ) begin
                bfact = - 2.0 * afact * Vgp + beta ;
                cfact = afact * Vgp * Vgp - beta * phi_bL_DEP ;
                phi_bL_DEP_old = phi_bL_DEP ;
                phi_sL_DEP_ini = ( - bfact + sqrt(bfact * bfact - 4.0 * afact * cfact)) / 2.0 / afact ;
                if ( phi_sL_DEP_ini > Psbmax - ps_conv23 ) phi_sL_DEP_ini = Psbmax - ps_conv23 ;
                W_sL = sqrt(C_2ESIpq_Ndepm * (phi_bL_DEP - phi_sL_DEP_ini) ) ;
                W_bL = sqrt(C_2ESIpq_Ndepm * (phi_bL_DEP - phi_jL_DEP) ) ;

                if ( W_sL + W_bL > UC_DEPTHN ) begin
                    for ( lp_s0 = 1 ; lp_s0 <= `lp_se_max + 1 ; lp_s0 = lp_s0 + 1 ) begin

                        y0 = W_sL + W_bL - UC_DEPTHN ;

                        dydPsm = `C_ESI / q_Ndepm / W_sL + `C_ESI / q_Ndepm * ( 1.0 - (NdepmpNsub) / ( 1.0 + (NdepmpNsub))) / W_bL ;

                        if ( abs(y0 / dydPsm) > 0.5 ) begin
                            phi_bL_DEP = phi_bL_DEP - 0.5 * `Fn_Sgn(y0 / dydPsm) ;
                        end else begin
                            phi_bL_DEP = phi_bL_DEP - y0 / dydPsm ;
                        end

                        if ( (phi_bL_DEP - Vbscl + Vbi_DEP) < `epsm10 ) phi_bL_DEP=Vbscl - Vbi_DEP + `epsm10 ;

                        cfact = afact * Vgp * Vgp - beta * phi_bL_DEP ;
                        T1 = bfact * bfact - 4.0 * afact * cfact ;
                        if ( T1 > 0.0 ) begin
                            phi_sL_DEP_ini = ( - bfact + sqrt(T1)) / 2.0 / afact ;
                        end else begin
                            phi_sL_DEP_ini = ( - bfact) / 2.0 / afact ;
                        end

                        if ( phi_sL_DEP_ini > Psbmax ) phi_sL_DEP_ini = Psbmax ;
                        if ( phi_sL_DEP_ini > phi_bL_DEP ) begin
                            phi_sL_DEP_ini = phi_bL_DEP - ps_conv23 ;
                            lp_s0=`lp_se_max + 1 ;
                        end
                        W_sL = sqrt(C_2ESIpq_Ndepm * (phi_bL_DEP - phi_sL_DEP_ini) ) ;
                        phi_jL_DEP = ( NdepmpNsub * phi_bL_DEP + Vbscl - Vbi_DEP) / (1.0 + NdepmpNsub) ;
                        W_bL = sqrt(C_2ESIpq_Ndepm * (phi_bL_DEP - phi_jL_DEP) ) ;

                        if ( abs(phi_bL_DEP - phi_bL_DEP_old) <= 1.0e-8 ) lp_s0=`lp_se_max + 1 ;
                        phi_bL_DEP_old = phi_bL_DEP ;
                    end
                end

                /* inversion */
            end else begin

                phi_bL_DEP = phi_b0_DEP ;
                phi_jL_DEP = phi_j0_DEP ;
                phi_sL_DEP_ini = phi_s0_DEP ;

            end

        end

        phi_b0_DEP_ini = phi_bL_DEP ;

        /*                              */
        /* solve poisson  at drain side */
        /*                              */

        flg_conv = 0 ;

        /* accumulation */

        phi_sL_DEP = phi_sL_DEP_ini ;
        phi_bL_DEP = phi_b0_DEP_ini ;

        phi_sL_DEP_old = phi_sL_DEP ;
        phi_bL_DEP_old = phi_bL_DEP ;

        for ( lp_s0 = 1 ; lp_s0 <= `lp_se_max + 1 ; lp_s0 = lp_s0 + 1 ) begin

            phi_jL_DEP  = NdepmpNsub_inv1 * (NdepmpNsub * phi_bL_DEP + Vbscl - Vbi_DEP) ;
            phi_jL_DEP_dPb = NdepmpNsub_inv1 * NdepmpNsub ;

            T1 = phi_bL_DEP - phi_jL_DEP ;
            `Fn_SL_CP( T2 , T1 , 0.0 , 0.1, 2 , T0 )
            W_bL = sqrt(C_2ESIpq_Ndepm * (T2) ) ;
            `Fn_SU_CP( W_bL , W_bL , UC_DEPTHN , 1e-8, 2 , T3 )
            W_subL = sqrt(C_2ESIpq_Nsub * (phi_jL_DEP - Vbscl + Vbi_DEP) ) ;
            Q_bL_dep = W_bL * q_Ndepm ;
            Q_bL_dep_dPb = `C_ESI / W_bL * T0 * T3 ;
            Q_bL_dep_dPd = - `C_ESI / W_bL * T0 * T3 ;
            Q_subL_dep = - W_subL * q_Nsub ;
            Q_subL_dep_dPd = - `C_ESI / W_subL ;

            T1 = 8.0 * q_Ndepm_esi * Tn2 ;
            phib_ref = (4.0 * phi_jL_DEP * phi_jL_DEP * C_ESI2 - 8.0 * phi_jL_DEP * C_ESI2 * phi_sL_DEP
               + 4.0 * C_ESI2 * phi_sL_DEP * phi_sL_DEP
               + 4.0 * phi_jL_DEP * q_Ndepm_esi * Tn2
               + 4.0 * phi_sL_DEP * q_Ndepm_esi * Tn2
               + Ndepm2 * C_QE2 * Tn2 * Tn2) / T1 ;
            phib_ref_dPs = ( - 8.0 * phi_jL_DEP * C_ESI2 + 4.0 * C_ESI2 * phi_sL_DEP * 2.0
               + 4.0 * q_Ndepm_esi * Tn2) / T1 ;
            phib_ref_dPd = (4.0 * phi_jL_DEP * C_ESI2 * 2.0 - 8.0 * C_ESI2 * phi_sL_DEP
               + 4.0 * q_Ndepm_esi * Tn2) / T1 ;

            T1 = beta * (phi_sL_DEP - phi_bL_DEP) ;
            T2 = exp(T1) ;
            if ( phi_sL_DEP >= phi_bL_DEP ) begin
                Q_sL = - cnst0 * sqrt(T2 - 1.0 - T1 + 1e-15) ;
                Q_sL_dPs = 0.5 * cnst0 * cnst0 / Q_sL * (beta * T2 - beta) ;
                Q_sL_dPb = - Q_sL_dPs ;
            end else begin
                T3 = exp( - beta * (phi_sL_DEP - Vbscl)) ;
                T4 = exp( - beta * (phi_bL_DEP - Vbscl)) ;
                Q_sL = cnst0 * sqrt(T2 - 1.0 - T1 + cnst1 * (T3 - T4) + 1e-15) ;
                T5 = 0.5 * cnst0 * cnst0 / Q_sL ;
                Q_sL_dPs = T5 * (beta * T2 - beta + cnst1 * ( - beta * T3) ) ;
                Q_sL_dPb = T5 * ( - beta * T2 + beta + cnst1 * beta * T4 ) ;
            end

            `Fn_SU_CP( T1 , phib_ref , Vds_maxbL , sm_delta, 4 , T0 )

            y1 = phi_bL_DEP - T1 ;
            y11 = - phib_ref_dPs * T0 ;
            y12 = 1.0 - phib_ref_dPd * phi_jL_DEP_dPb * T0 ;

            y2 = Cox * (Vgp - phi_sL_DEP) + Q_sL + Q_bL_dep + Q_subL_dep ;
            y21 = - Cox + Q_sL_dPs ;
            y22 = Q_sL_dPb + Q_bL_dep_dPb + Q_bL_dep_dPd * phi_jL_DEP_dPb + Q_subL_dep_dPd * phi_jL_DEP_dPb ;

            dety = y11 * y22 - y21 * y12;
            rev11 = (y22) / dety ;
            rev12 = ( - y12) / dety ;
            rev21 = ( - y21) / dety ;
            rev22 = (y11) / dety ;
            if ( abs( rev21 * y1 + rev22 * y2 ) > 0.5 ) begin
                phi_sL_DEP = phi_sL_DEP - 0.5 * `Fn_Sgn( rev11 * y1 + rev12 * y2 ) ;
                phi_bL_DEP = phi_bL_DEP - 0.5 * `Fn_Sgn( rev21 * y1 + rev22 * y2 ) ;
            end else begin
                phi_sL_DEP = phi_sL_DEP - ( rev11 * y1 + rev12 * y2 ) ;
                phi_bL_DEP = phi_bL_DEP - ( rev21 * y1 + rev22 * y2 ) ;
            end

            if ( abs(phi_sL_DEP - phi_sL_DEP_old) <= `ps_conv &&  abs(phi_bL_DEP - phi_bL_DEP_old) <= `ps_conv ) begin
                lp_s0=`lp_se_max + 1 ;
                flg_conv = 1 ;
            end

            phi_sL_DEP_old = phi_sL_DEP ;
            phi_bL_DEP_old = phi_bL_DEP ;

        end

        if ( flg_conv == 0 ) begin
            $write( "*** warning(HiSIM_HV(%m)): Went Over Iteration Maximum(Psl)\n" ) ;
            $write( " Vbse   = %7.3f Vdse = %7.3f Vgse = %7.3f\n" ,Vbse , Vdse , Vgse ) ;
        end

        if ( W_bsubL > UC_DEPTHN && depmode !=2 ) begin
            `Fn_SU_CP(phi_bL_DEP , phi_bL_DEP , phi_sL_DEP , 0.02, 2 , T1 )
        end

        phi_jL_DEP  = NdepmpNsub_inv1 * (NdepmpNsub * phi_bL_DEP + Vbscl - Vbi_DEP) ;

        T1 = beta * (phi_sL_DEP - phi_bL_DEP) ;
        T2 = exp(T1) ;
        if ( phi_sL_DEP >= phi_bL_DEP ) begin
            Q_sL = - cnst0 * sqrt(T2 - 1.0 - T1 + 1e-15 ) ;
            Q_nL = Q_sL ;

            Q_sL_dep = 0.0 ;
            Q_subL = 0.0 ;

            W_bL = sqrt(C_2ESIpq_Ndepm * (phi_bL_DEP - phi_jL_DEP) ) ;
            `Fn_SU_CP( W_bL , W_bL , UC_DEPTHN , 1e-8, 2 , T3 )
            W_subL = sqrt(C_2ESIpq_Nsub * (phi_jL_DEP - Vbscl + Vbi_DEP) ) ;
            Q_bL_dep = W_bL * q_Ndepm ;
            Q_subL_dep = - W_subL * q_Nsub ;

        end else begin

            T3 = exp( - beta * (phi_sL_DEP - Vbscl)) ;
            T4 = exp( - beta * (phi_bL_DEP - Vbscl)) ;
            Q_sL = cnst0 * sqrt(T2 - 1.0 - T1 + cnst1 * (T3 - T4) + 1e-15) ;

            if ( W_bsubL > UC_DEPTHN && depmode !=2 ) begin
                Q_subL = 0.0 ;
                Q_sL_dep = 0.0 ;
            end else begin
                T3 = cnst0 * sqrt( - T1
                 + cnst1 * (exp( - beta * (phi_sL_DEP - Vbscl)) - exp( - beta * (phi_bL_DEP - Vbscl)))) ;
                Q_subL = T3 - cnst0 * sqrt( - T1)  ;
                Q_sL_dep = cnst0 * sqrt(T2 - 1.0 - T1 + 1e-15) ;
            end
            Q_nL = 0.0 ;

            T1 = phi_bL_DEP - phi_jL_DEP ;
            `Fn_SL_CP( T2 , T1 , 0.0 , 0.1, 2 , T0 )
            W_bL = sqrt(C_2ESIpq_Ndepm * (T2) ) ;
            `Fn_SU_CP( W_bL , W_bL , UC_DEPTHN , 1e-8, 2 , T3 )
            W_subL = sqrt(C_2ESIpq_Nsub * (phi_jL_DEP - Vbscl + Vbi_DEP) ) ;
            Q_bL_dep = W_bL * q_Ndepm ;
            Q_subL_dep = - W_subL * q_Nsub ;

        end

        `Fn_SL_CP( T2 , (phi_sL_DEP - Vds_maxbL) , 0.0, `Ps_delta , 2 , T0 )
        T4 = (exp(beta * (T2)) - 1.0 - beta * (T2))  + `epsm10 ;

        Q_nL_cur = - cnst0 * sqrt(T4) ;

    end

    //---------------------------------------------------*
    //* Assign Pds.
    //*-----------------//
    Ps0 = phi_s0_DEP ;
    Psl = phi_sL_DEP ;
    Pds = phi_sL_DEP - phi_s0_DEP ;

    T1 = - (Q_s0 + Q_sL) ;
    `Fn_SL_CP( Qn_drift , T1 , 0.0, Qn_delta , 2 , T0 )
    Idd_drift =  beta * (Qn_drift) / 2.0 * Pds ;

    Idd_diffu = - ( - Q_nL_cur + Q_n0_cur);

    Idd = Idd_drift + Idd_diffu ;

    Qiu = - Q_n0_cur ;

    Lch = Leff ;
    //-----------------------------------------------------------*
    //* Muun : surface universal mobility.  (CGS unit)
    //*-----------------//
    T2 = ninv_o_esi / `C_m2cm ;
    T4 = 1.0 + ( phi_sL_DEP - phi_s0_DEP ) * Ninvde ;
    T5 =  T2 * Qiu ;
    T3 = T5 / T4 ;
    Eeff = T3 ;
    T5 = `Fn_Pow( Eeff , MUEPH0 - 1.0e0 ) ;
    T8 = T5 * Eeff ;
    T7 = `Fn_Pow( Eeff , muesr - 1.0e0 ) ;
    T6 = T7 * Eeff ;
    T9 = `C_QE * `C_m2cm_p2 ;
    Rns = Qiu / T9 ;

    T1 = 1.0e0 / ( UC_MUECB0 + UC_MUECB1 * Rns / 1.0e11 + `Small )
          + mphn0 * T8 + T6 / UC_MUESR1 ;

    Muun = 1.0e0 / T1 ;

    //  Change to MKS unit //
    Muun = Muun / `C_m2cm_p2 ;

    //-----------------------------------------------------------*
    //* Mu : mobility
    //*-----------------//
    T2 = beta * (Qiu + `Small) * Lch ;
    T1 = 1.0e0 / T2 ;
    TY = Idd * T1 ;
    T2 = 0.2 * Vmaxe / Muun ;
    Ey = sqrt( TY * TY + T2 * T2 ) ;
    T4 = 1.0 / Ey ;
    Em = Muun * Ey ;
    T1  = Em / Vmaxe ;
    Ey_suf = Ey ;
    // note: bb = 2 (electron) ;1 (hole) //
    if ( 1.0e0 - `epsm10 <= BB && BB <= 1.0e0 + `epsm10 ) begin
        T3 = 1.0e0 ;
    end else if ( 2.0e0 - `epsm10 <= BB && BB <= 2.0e0 + `epsm10 ) begin
        T3 = T1 ;
    end else begin
        T3 = `Fn_Pow( T1 , BB - 1.0e0 ) ;
    end
    T2 = T1 * T3 ;
    T4 = 1.0e0 + T2 ;
    if ( 1.0e0 - `epsm10 <= BB && BB <= 1.0e0 + `epsm10 ) begin
        T5 = 1.0 / T4 ;
    end else if ( 2.0e0 - `epsm10 <= BB && BB <= 2.0e0 + `epsm10 ) begin
        T5 = 1.0 / sqrt( T4 ) ;
    end else begin
        T6 = `Fn_Pow( T4 , ( - 1.0e0 / BB - 1.0e0 ) ) ;
        T5 = T4 * T6 ;
    end
    Mu = Muun * T5 ;

    //-----------------------------------------------------------*
    //*  resistor region current.  (CGS unit)
    //*-----------------//

    if ( Vdsorg > 1e-6 ) begin

        T2 = q_Ndepm_esi / ( Cox * Cox ) ;
        T0 = Vgp + UC_DEPVDSEF1 - beta_inv - Vbsz ;
        T4 = 1.0e0 + 2.0e0 / T2 * T0 ;
        `Fn_SL_CP( T9 , T4 , 0 , `DEPQFN_dlt , 2 , T0 )

        T9 = T9 + `Small ;
        T3 = sqrt( T9 ) ;
        T4 = T2 * ( 1.0e0 - T3 ) ;
        T10 = Vgp + UC_DEPVDSEF1 + T4 ;
        T10 = T10 * UC_DEPVDSEF2 ;

        `Fn_SL_CP( T10 , T10 , UC_DEPLEAK, 4.00, 4 , T0 )

        T1 = Vdsorg / T10 ;
        T2 = `Fn_Pow( T1 , DDLTe-1.0e0 ) ;
        T7 = T2 * T1 ;
        T3 = 1.0 + T7 ;
        T4 = `Fn_Pow( T3 , 1.0 / DDLTe-1.0 ) ;
        T6 = T4 * T3  ;
        Vdseff0 = Vdsorg / T6 ;

    end else begin
        Vdseff0 = Vdsorg ;
    end

    //-----------------------------------------------------------*
    //*  resistor region universal mobility.  (CGS unit)
    //*-----------------//

    T4 = 1.0 + ( phi_sL_DEP - phi_s0_DEP ) * Ninvde  ;

    Qiu = - Qn_res0 ;
    T5 =  Qiu ;
    T3 = T5 / T4 ;
    Eeff = T3 ;
    T5 = `Fn_Pow( Eeff , DEPMUEPH0 - 1.0e0 ) ;
    T8 = T5 * Eeff ;
    T9 = `C_QE * `C_m2cm_p2 ;
    Rns = Qiu / T9 ;

    T1 = 1.0e0 / ( UC_DEPMUE0 + UC_DEPMUE1 * Rns / 1.0e11 + `Small )
          + depmphn0 * T8  ;

    Muun = 1.0e0 / T1 ;

    //  Change to MKS unit //
    Muun = Muun / `C_m2cm_p2 ;

    Edri = Vdseff0 / Lch ;

    T1 = Muun * Edri / UC_DEPVMAX ;
    T2 = `Fn_Pow(T1,DEPBB) ;
    T3 = 1.0 + T2 ;
    T4 = `Fn_Pow(T3,1.0 / DEPBB) ;
    Mu_res = Muun / T4 ;
    Ids_res = weff_nf * ( - Qn_res0) * Mu_res * Edri ;

    //-----------------------------------------------------------*
    //*  back region universal mobility.  (CGS unit)
    //*-----------------//

    T4 = 1.0 + ( phi_sL_DEP - phi_s0_DEP ) * Ninvde ;

    Qiu = - Qn_bac ;
    T5 =  Qiu ;
    T3 = T5 / T4 ;
    Eeff = T3 ;
    T5 = `Fn_Pow( Eeff , DEPMUEPH0 - 1.0e0 ) ;
    T8 = T5 * Eeff ;
    T9 = `C_QE * `C_m2cm_p2 ;
    Rns = Qiu / T9 ;

    T1 = 1.0e0 / ( UC_DEPMUEBACK0 + UC_DEPMUEBACK1 * Rns / 1.0e11 + `Small )
          + depmphn0 * T8  ;

    Muun = 1.0e0 / T1 ;

    //  Change to MKS unit //
    Muun = Muun / `C_m2cm_p2 ;

    Edri = Vdseff0 / Lch ;

    T1 = Muun * Edri / (UC_DEPVMAX) ;
    T2 = `Fn_Pow(T1,DEPBB) ;
    T3 = 1.0 + T2 ;
    T4 = `Fn_Pow(T3,1.0 / DEPBB) ;
    Mu_bac = Muun / T4 ;
    Ids_bac = weff_nf * ( - Qn_bac) * Mu_bac * Edri ;

    //-----------------------------------------------------------*
    //* Ids: channel current.
    //*-----------------//
    betaWL = weff_nf * beta_inv / Lch ;
    Ids0 = betaWL * Idd * Mu + Ids_res + Ids_bac ;
    Ids_acc = betaWL * Idd * Mu ;
    Mu_acc = Mu ;

    // Vdseff //
    Vds = Vdsorg;

    //-----------------------------------------------------------*
    //* Adding parasitic components to the channel current.
    //*-----------------//
    if ( PTL != 0 ) begin
        T1 =  0.5 * ( Vds - Pds ) ;
        `Fn_SymAdd( T6 , T1 , 0.01 , T2 )
        T1 = 1.1 - ( phi_s0_DEP + T6 );
        `Fn_SZ( T2 , T1 , 0.05 , T0 )
        T2 = T2 + `Small ;
        T0 = beta * ptl0 ;
        T3 = Cox * T0 ;
        T0 = pow( T2 , PTP ) ;
        T9 = T3 * T0 ;
        T4 = 1.0 + Vdsz * PT2 ;
        T0 = pt40 ;
        T5 = phi_s0_DEP + T6 - Vbsz ;
        T4 = T4 + Vdsz * T0 * T5 ;
        T6 = T9 * T4 ;
        T9 = T6 ;
    end else begin
        T9 = 0.0 ;
    end
    if ( GDL != 0 ) begin
        T1 = beta * gdl0 ;
        T2 = Cox * T1 ;
        T8 = T2 * Vdsz ;
    end else begin
        T8 = 0.0 ;
    end
    if (( T9 + T8 ) > 0.0 ) begin
        Idd1 = Pds * ( T9 + T8 ) ;
        Ids0 = Ids0 + betaWL * Idd1 * Mu ;
    end

    if ( flg_rsrd == 2 || flg_rsrd == 3 ) begin
        if ( RD20 > 0.0 ) begin
            T4 = Rd23e ;
            T1 = UC_RD24 * ( Vgse-RD25 ) ;
            `Fn_SL( T2 , T1 , T4 , `delta_rd , T0 )
            T3 = T4 * ( RD20 + 1.0 ) ;
            `Fn_SU( T7 , T2 , T3 , `delta_rd , T0 )
        end else begin
            T7 = Rd23e;
        end

        if (Vdse >= 0.0) begin
            Vdse_eff = Vdse ;
        end else begin
            Vdse_eff = 0.0 ;
        end
        // smoothing of Ra for Vdse_eff close to zero //
        // ... smoothing parameter is Ra_N            //
        if (Vdse_eff < `Ra_N * `Small2) begin
            Ra_alpha = pow( `Ra_N + 1.0 , RD21 - 1.0 )
                       * (`Ra_N + 1.0 - 0.5 * RD21 * `Ra_N)
                       * pow( `Small2,RD21 );
            Ra_beta = 0.5 * RD21
                      * pow( `Ra_N + 1.0 , RD21 - 1.0 ) / `Ra_N
                      * pow( `Small2, RD21 - 2.0 );
            T1 = Ra_alpha + Ra_beta * Vdse_eff * Vdse_eff;
        end else begin
            T1 = pow( Vdse_eff + `Small2 , RD21 ) ;
        end
        T9 = pow( Vdse_eff + `Small2 , RD22D ) ;
        Ra = ( T7 * T1 + Vbse * UC_RD22 * T9 ) / weff_nf ;
        T0 = Ra * Ids0 ;
        T1 = Vds + `Small2 ;
        T2 = 1.0 / T1 ;
        T3 = 1.0 + T0 * T2 ;
        T4 = 1.0 / T3 ;
        Ids = Ids0 * T4 ;
    end else begin
        Ids = Ids0 ;
        Ra = 0.0 ;
    end

    /* charge calculation */

    //---------------------------------------------------*
    //* Qbu : -Qb in unit area.
    //*-----------------//
    Qbu = - 0.5 * (Q_sub0 + Q_subL + Q_sub0_dep + Q_subL_dep ) ;
    Qiu = - 0.5 * (Q_n0 + Q_nL + Q_s0_dep + Q_sL_dep + Q_b0_dep + Q_bL_dep) ;
    Qdrat = 0.5;

    //---------------------------------------------------*
    //set flg_noqi & Qiu_noi
    //---------------------------------------------------*
    Qiu_noi = - 0.5 * (Q_n0 + Q_nL) ;
    Qn0 = -Q_n0 ;
    Ey  = Ey_suf ;
    if ( Qn0 < `Small || Qiu < `Small ) begin
        flg_noqi = 1 ;
    end

end // HSMHV_depmos
// ---- end `include "HSMHV_depmos.inc" ----
                end
                2: begin // 2.3.0 new Model
// ---- begin `include "HSMHV_depmos2.inc" ----
/***********************************************************************

 HiSIM (Hiroshima University STARC IGFET Model)
 Copyright (C) 2000-2016 Hiroshima University and STARC
 Copyright (C) 2016-2023 Hiroshima University
 HiSIM_HV (High-Voltage Model)
 Copyright (C) 2007-2016 Hiroshima University and STARC
 Copyright (C) 2016-2023 Hiroshima University

 MODEL NAME : HiSIM_HV
 ( VERSION : 2  SUBVERSION : 5  REVISION : 1 )
 Model Parameter 'VERSION' : 2.51
 FILE : vaFiles/HSMHV_depmos2.inc

 Date : 2023.02.09

 released by Hiroshima University

***********************************************************************/
//
////////////////////////////////////////////////////////////////
//
//
//
//
//Licensed under the Educational Community License, Version 2.0
//(the "License"); you may not use this file except in
//compliance with the License.
//
//You may obtain a copy of the License at:
//
//      http://opensource.org/licenses/ECL-2.0
//
//Unless required by applicable law or agreed to in writing,
//software distributed under the License is distributed on an
//"AS IS" BASIS, WITHOUT WARRANTIES OR CONDITIONS OF ANY KIND,
//either express or implied. See the License for the specific
//language governing permissions and limitations under the
//License.
//
//
//The HiSIM_HV standard has been supported by the members of
//Silicon Integration Initiative's Compact Model Coalition. A
//link to the most recent version of this standard can be found
//at:
//
//http://www.si2.org/cmc
//
////////////////////////////////////////////////////////////////
//

//---------------------------------------------------*
begin : HSMHV_depmos2
    //*------------------//
    //
    real W_b0, W_bL, W_sub0, W_subL ;
    real Tnp ;
    real Wbsub , W_bsub0, W_bsubL ;
    real kjuncpn_Vbs_Vbi , phib_ref , phib_ref_dPs , phib_ref_dPb ;
    real phi_j0_DEP_dPb , phi_jL_DEP_dPb ;
    real Q_b0_dep_dPb, Q_bL_dep_dPb, Q_b0_dep_dPd, Q_bL_dep_dPd, Q_sub0_dep_dPd, Q_subL_dep_dPd ;
    real sm_delta ;

    real Vds_maxb0, Vds_maxbL ;
    real phi_s0_DEP, phi_sL_DEP , Vbi_DEP ;
    real phi_b0_DEP, phi_bL_DEP ;
    real phi_j0_DEP, phi_jL_DEP ;
    real phi_s0_DEP_ini, phi_sL_DEP_ini ;

    real Q_s0, Q_sL, Q_sub0, Q_subL ;
    real Q_b0_dep, Q_sub0_dep, Q_bL_dep, Q_subL_dep ;

    real PF1 , PF11 , PF12 , PF2 , PF21 , PF22 ;
    real PDJ , PDJI , PJI11 , PJI12 , PJI21 , PJI22 , dPs , dPb ;

    real q_Ndepm_esi, Edri ;
    real Ey_acc , Vbsc , phi_j0 ;

    real Q_n0_cur , Q_nL_cur , Q_n0_sym ;
    real Q_n0 , Q_nL , Qn_drift ;
    real Q_s0_dep, Q_sL_dep ;

    real Q_s0_dPs, Q_sL_dPs ;
    real Q_s0_dPb, Q_sL_dPb ;
    real NdepmpNsub_inv1, NdepmpNsub ;

    real Tn2 ;
    real q_Nsub, q_Ndepm , q_Ndepm_esi_Cox_inv2 , C2_q_Ndepm_esi_Cox_inv2 ;
    real C_2ESIpq_Ndepm ;
    real C_2ESIpq_Nsub ;
    real DEPQFN_dlt , Ps_delta ;
    real VFBOFFSET , VgpDEP_dlt;
    integer VgpDEP_pw ;
    real Vgp_res , vfb_res ;

    // Constants
    Vbi_DEP = Vbipn ;
    q_Ndepm = `C_QE * UC_NDEPM ;
    q_Ndepm_esi = `C_QE * UC_NDEPM * `C_ESI ;
    q_Nsub = `C_QE * EF_NSUBC ;
    Tn2    = UC_DEPTHN * UC_DEPTHN ;
    C_2ESIpq_Ndepm = 2.0 *`C_ESI/q_Ndepm ;
    C_2ESIpq_Nsub  = 2.0 * `C_ESI / q_Nsub  ;
    NdepmpNsub  = UC_NDEPM / EF_NSUBC ;
    NdepmpNsub_inv1  = 1.0 / (1.0 + NdepmpNsub ) ;
    q_Ndepm_esi_Cox_inv2 = q_Ndepm_esi / ( Cox * Cox ) ;
    C2_q_Ndepm_esi_Cox_inv2 = 2.0 / q_Ndepm_esi_Cox_inv2 ;
    DEPQFN_dlt = 4 ;
    Ps_delta   = 0.1 ;
    VFBOFFSET  = 0.1 ;
    VgpDEP_dlt = Pb2n + DEPVGPSL ;
    VgpDEP_pw  = 3 ;

    // Initialization for hidden states
    phi_s0_DEP = 0.0 ;
    phi_sL_DEP = 0.0 ;
    Q_s0       = 0.0 ;
    Q_sL       = 0.0 ;
    Q_s0_dep   = 0.0 ;
    Q_sL_dep   = 0.0 ;
    Q_b0_dep   = 0.0 ;
    Q_bL_dep   = 0.0 ;
    Q_sub0_dep = 0.0 ;
    Q_subL_dep = 0.0 ;
    phib_ref   = 0.0 ;
    Tnp        = 0.0 ;

    Vbsc = Vbscl ; // Change Vbs vars to Vbsc(internal)

    //---------------------------------------------------*
    //* start of Ps0 calculation. (label)
    //*-----------------//
    Vgp = Vgp + `epsm10 * 1e8 ; // Avoid the numerical noise

    // Calc. Wb of P-N junction
    kjuncpn = C_2ESIpq_Ndepm * EF_NSUBC / ( UC_NDEPM + EF_NSUBC ) ;
    T1 = Vbi_DEP - Vbsz ;  /* Vbs for Symmetry */
    `Fn_SL_CP( T2 , T1 , 0.0 , 0.1, 4 , T0 )
    kjuncpn_Vbs_Vbi = kjuncpn * T2 ;
    W_bsub0 = sqrt( kjuncpn_Vbs_Vbi ) ;

    // Vds dependence of TNDEP
    if ( TNDEPV != 0.0 ) begin
        T1 = UC_DEPTHN * ( 1 - TNDEPV * Vds ) ;
        T2 = 1e-3 * UC_DEPTHN ;
        `Fn_SL(        T1 , T1 , 0.1 * UC_DEPTHN , T2 , T0 )
        `Fn_SU( UC_DEPTHN , T1 , 2.0 * UC_DEPTHN , T2 , T0 )
    end

    Vds_maxb0 = 0.0 ;

    /* fully depleted case */
    if ( W_bsub0 > UC_DEPTHN ) begin
        Wbsub = UC_DEPTHN ;
    end else begin
        Wbsub = W_bsub0 ;
    end

    //---------------------------------------------------*
    //* initial potential Ps0 calculated.
    //*------------------//

    `Fn_SU( phi_s0_DEP_ini , Vgp , 0.3 , 0.01 , T0 )
    `Fn_SL( phi_s0_DEP_ini , phi_s0_DEP_ini , Vbsc - Vbi_DEP , 0.01 , T0 )

    /* Calc. phi_j0 & Tnp */
    phi_j0 = - Vbi_DEP * EF_NSUBC / (EF_NSUBC + UC_NDEPM) ;
    Tnp = UC_DEPTHN - Wbsub + 1e-15 ;

    /*                               */
    /* solve poisson at source side  */
    /*                               */

    flg_conv = 0 ;
    sm_delta = 0.2;

    phi_s0_DEP = phi_s0_DEP_ini ;
    phi_b0_DEP = Vds_maxb0 ;
    phi_j0_DEP = phi_j0 ;

    for ( lp_s0 = 1 ; lp_s0 <= `lp_se_max  ; lp_s0 = lp_s0 + 1 ) begin

        phi_j0_DEP = NdepmpNsub_inv1 * (NdepmpNsub * phi_b0_DEP + Vbsc - Vbi_DEP) ;
        phi_j0_DEP_dPb = NdepmpNsub_inv1 * NdepmpNsub ;

        T1 = phi_b0_DEP - phi_j0_DEP ;
        `Fn_SL_CP( T2 , T1 , 0.0 , 0.1, 2 , T0 )
        W_b0 = sqrt(C_2ESIpq_Ndepm * T2 ) ;
        `Fn_SU_CP( W_b0 , W_b0 , UC_DEPTHN , 1e-8, 2 , T3 )
        Q_b0_dep = W_b0 * q_Ndepm ;
        Q_b0_dep_dPb = `C_ESI / W_b0 * T0 * T3 ;
        Q_b0_dep_dPd = - `C_ESI / W_b0 * T0 * T3 ;

        if (COFIXCSS==0) begin
            phib_ref = ( Tn2 + kjuncpn_Vbs_Vbi - 2.0 * UC_DEPTHN * Wbsub ) / C_2ESIpq_Ndepm + phi_s0_DEP ;
            phib_ref_dPs = 1.0 ;
            phib_ref_dPb = 0.0 ;
        end else begin
            phib_ref = phi_s0_DEP + (Tn2 + W_b0 * (W_b0 - 2 * UC_DEPTHN)) / C_2ESIpq_Ndepm ;
            phib_ref_dPs = 1.0 ;
            phib_ref_dPb = (T0 - UC_DEPTHN /W_b0 * T0) * (1 - phi_j0_DEP_dPb) ;
        end

        `Fn_SU_CP( phib_ref , phib_ref , Vds_maxb0 , sm_delta , 4 , T0 )
        phib_ref_dPs = phib_ref_dPs * T0 ;
        phib_ref_dPb = phib_ref_dPb * T0 ;

        T1 = phi_j0_DEP - Vbsc + Vbi_DEP ;
        `Fn_SL_CP( T2 , T1 , 0.0 , 0.1, 2 , T3 )
        W_sub0 = sqrt(C_2ESIpq_Nsub * T2 ) ;
        Q_sub0_dep = - W_sub0 * q_Nsub ;
        Q_sub0_dep_dPd = - `C_ESI / W_sub0 * T3;

        T1 = beta * (phi_s0_DEP - phi_b0_DEP) ;
        T2 = exp(T1) ;
        if ( phi_s0_DEP >= phi_b0_DEP ) begin
            Q_s0 = - cnst0 * sqrt(T2 - 1.0 - T1 + 1e-15) ;
            Q_s0_dPs = 0.5 * cnst0 * cnst0 / Q_s0 * (beta * T2 - beta ) ;
            Q_s0_dPb = - Q_s0_dPs ;
        end else begin
            T3 = exp( - beta * (phi_s0_DEP - Vbsc)) ;
            T4 = exp( - beta * (phi_b0_DEP - Vbsc)) ;
            Q_s0 = cnst0 * sqrt(T2 - 1.0 - T1 + cnst1 * (T3 - T4) + 1e-15) ;
            T5 = 0.5 * cnst0 * cnst0 / Q_s0 ;
            Q_s0_dPs = T5 * (beta * T2 - beta + cnst1 * ( - beta * T3) ) ;
            Q_s0_dPb = T5 * ( - beta * T2 + beta + cnst1 * beta * T4 ) ;
        end

        if (flg_conv) begin
            lp_s0 = `lp_se_max + 1 ; // exit Newton Loop
        end else begin
            PF1 = Cox * (Vgp - phi_s0_DEP) + Q_s0 + (Q_b0_dep + Q_sub0_dep) ;
            PF11 = - Cox + Q_s0_dPs ;
            PF12 = Q_s0_dPb + (Q_b0_dep_dPb + Q_b0_dep_dPd * phi_j0_DEP_dPb + Q_sub0_dep_dPd * phi_j0_DEP_dPb) ;
            PF2 = phi_b0_DEP - phib_ref ;
            PF21 = - phib_ref_dPs ;
            PF22 = 1.0 - phib_ref_dPb ;
            PDJ = PF11 * PF22 - PF12 * PF21;
            PDJI = ( PDJ > 0.0 ) ? 1.0 / (PDJ + `Small) : 1.0 / (PDJ - `Small) ;
            PJI11 = PF22;
            PJI12 = - PF12;
            PJI21 = - PF21;
            PJI22 = PF11;
            dPs = -PDJI * (PJI11 * PF1 + PJI12 * PF2);
            dPb = -PDJI * (PJI21 * PF1 + PJI22 * PF2);
            T1 = abs(dPs);
            T1 = (T1 < abs(dPb)) ? abs(dPb) : T1 ;
            if (T1 > `dP_max) begin
                dPs = dPs * ( `dP_max / T1 );
                dPb = dPb * ( `dP_max / T1 );
            end
            if (T1 < `ps_conv) begin
                flg_conv = 1 ; // break
            end

            phi_s0_DEP = phi_s0_DEP + dPs ;
            phi_b0_DEP = phi_b0_DEP + dPb ;

        end // End of flg_conv=1

    end // End of Newton Loop

    if ( flg_conv == 0 ) begin
        $write( "*** warning(HiSIM_HV(%m)): Went Over Iteration Maximum(Ps0)\n" ) ;
        $write( " Vbse   = %7.3f Vdse = %7.3f Vgse = %7.3f\n" ,Vbse , Vdse , Vgse ) ;
    end

    T1 = beta * (phi_s0_DEP - phi_b0_DEP) ;
    T2 = exp(T1) ;
    if ( phi_s0_DEP >= phi_b0_DEP ) begin
        Q_n0 = Q_s0 ;
        Q_s0_dep = 0.0 ;
        Q_sub0 = 0.0 ;
    end else begin
        Q_n0 = 0.0 ;
        Q_s0_dep = cnst0 * sqrt(T2 - 1.0e0 - T1 + 1e-15) ;
        if ( W_bsub0 > UC_DEPTHN ) begin
            Q_sub0 = 0.0 ;
        end else begin
            T3 = cnst0 * sqrt( - T1
            + cnst1 * (exp( - beta * (phi_s0_DEP - Vbsc)) - exp( - beta * (phi_b0_DEP - Vbsc)))) ;
            Q_sub0 = T3 - cnst0 * sqrt( - T1)  ;
        end
    end // (phi_s0_DEP >= phi_b0_DEP)

    `Fn_SL_CP( T2 , (phi_s0_DEP - Vds_maxb0) , 0.0, Ps_delta, 4 , T0 )
    T4 = exp(beta * T2) - 1.0 - beta * T2 + 1e-15 ;
    Q_n0_cur = - cnst0 * sqrt(T4) ;

    //-----------------------------------------------------------*
    //* Start point of Psl(= Ps0 + Pds) calculation.(label)
    //*-----------------//

    // start_of_Psl:

    // Vdseff(begin) //
    Vdsorg = Vds ;

    if ( Vds > 1e-6 ) begin
        T10 = `Small ;
        T4 = 1.0e0 + C2_q_Ndepm_esi_Cox_inv2 * ( Vgp -  T10 ) ;
        T5 = 1.0e0 + C2_q_Ndepm_esi_Cox_inv2 ;
        `Fn_SL_CP( T4 , T4 , 0, T5 , 2 , T0 )
        T3 = sqrt(T4) ;
        T10 = Vgp + q_Ndepm_esi_Cox_inv2 * ( 1.0 - T3 )  ;
        `Fn_SL_CP( T10 , T10 , 0.0 , 1 , 2 , T0 )
        T1 = Vds / T10 ;
        T2 = `Fn_Pow( T1 , DDLTe-1.0 ) ;
        T3 = 1.0 + T2 * T1 ;
        T4 = `Fn_Pow( T3 , 1.0 / DDLTe-1.0 ) ;
        T6 = T4 * T3  ;
        Vdseff = Vds / T6 ;
        Vds = Vdseff ;
    end else begin
        Vdseff = Vds ;
    end

    //---------------------------------------------------*
    //* start of Psl calculation. (label)
    //*-----------------//

    if ( Vds < 0.0 ) begin

        phi_sL_DEP = phi_s0_DEP ;
        phi_jL_DEP = phi_j0_DEP ;
        phi_bL_DEP = phi_b0_DEP ;

        Q_subL = Q_sub0 ;
        Q_nL = Q_n0 ;
        Q_nL_cur = Q_n0_cur ;
        Q_bL_dep = Q_b0_dep ;
        Q_subL_dep = Q_sub0_dep ;

    end else begin

        W_bsubL = W_bsub0 ;

        Vds_maxbL = Vds ;

        //---------------------------------------------------*
        //* initial potential Psl calculated.
        //*------------------//

        `Fn_SU( phi_sL_DEP_ini , Vgp , phi_s0_DEP + Vds_maxbL , 0.01 , T0 )
        `Fn_SL( phi_sL_DEP_ini , phi_sL_DEP_ini , Vbsc - Vbi_DEP , 0.01 , T0 )

        /* Calc. Psl_lim */
        fac1 = cnst0 * Cox_inv ;
        fac1p2 = fac1 * fac1 ;
        TX = 1.0e0 + 4.0e0 * ( beta * ( Vgp - Vbsc ) - 1.0e0 ) / ( fac1p2 * beta2 ) ;
        TX = `Fn_Max( TX , `epsm10 ) ;
        Psl_lim = Vgp + fac1p2 * beta * 0.5 * ( 1.0e0 - sqrt( TX ) ) ;

        /*                              */
        /* solve poisson  at drain side */
        /*                              */

        flg_conv = 0 ;

        phi_sL_DEP = phi_sL_DEP_ini ;
        phi_bL_DEP = Vds_maxbL ;

        for ( lp_s0 = 1 ; lp_s0 <= `lp_se_max ; lp_s0 = lp_s0 + 1 ) begin

            phi_jL_DEP  = NdepmpNsub_inv1 * (NdepmpNsub * phi_bL_DEP + Vbsc - Vbi_DEP) ;
            phi_jL_DEP_dPb = NdepmpNsub_inv1 * NdepmpNsub ;

            T1 = phi_bL_DEP - phi_jL_DEP ;
            `Fn_SL_CP( T2 , T1 , 0.0 , 0.1, 2 , T0 )
            W_bL = sqrt(C_2ESIpq_Ndepm * (T2) ) ;
            `Fn_SU_CP( W_bL , W_bL , UC_DEPTHN , 1e-8, 2 , T3 )
            Q_bL_dep = W_bL * q_Ndepm ;
            Q_bL_dep_dPb = `C_ESI / W_bL * T0 * T3 ;
            Q_bL_dep_dPd = - `C_ESI / W_bL * T0 * T3 ;

            if (COFIXCSS==0) begin
                phib_ref = ( Tn2 + kjuncpn_Vbs_Vbi - 2.0 * UC_DEPTHN * Wbsub ) / C_2ESIpq_Ndepm + phi_sL_DEP ;
                phib_ref_dPs = 1.0 ;
                phib_ref_dPb = 0.0 ;
            end else begin
                phib_ref = phi_sL_DEP + (Tn2 + W_bL * (W_bL - 2 * UC_DEPTHN)) / C_2ESIpq_Ndepm ;
                phib_ref_dPs = 1.0 ;
                phib_ref_dPb = (T0 - UC_DEPTHN /W_bL * T0) * (1 - phi_jL_DEP_dPb) ;
            end
            `Fn_SU_CP( phib_ref , phib_ref , Vds_maxbL , sm_delta , 4 , T0 )
            phib_ref_dPs = phib_ref_dPs * T0 ;
            phib_ref_dPb = phib_ref_dPb * T0 ;

            T1 = phi_jL_DEP - Vbsc + Vbi_DEP ;
            `Fn_SL_CP( T2 , T1 , 0.0 , 0.1, 2 , T3 )
            W_subL = sqrt(C_2ESIpq_Nsub * T2 ) ;
            Q_subL_dep = - W_subL * q_Nsub ;
            Q_subL_dep_dPd = - `C_ESI / W_subL * T3 ;

            T1 = beta * (phi_sL_DEP - phi_bL_DEP) ;
            T2 = exp(T1) ;
            if ( phi_sL_DEP >= phi_bL_DEP ) begin
                Q_sL = - cnst0 * sqrt(T2 - 1.0 - T1 + 1e-15) ;
                Q_sL_dPs = 0.5 * cnst0 * cnst0 / Q_sL * (beta * T2 - beta) ;
                Q_sL_dPb = - Q_sL_dPs ;
            end else begin
                T3 = exp( - beta * (phi_sL_DEP - Vbsc)) ;
                T4 = exp( - beta * (phi_bL_DEP - Vbsc)) ;
                Q_sL = cnst0 * sqrt(T2 - 1.0 - T1 + cnst1 * (T3 - T4) + 1e-15) ;
                T5 = 0.5 * cnst0 * cnst0 / Q_sL ;
                Q_sL_dPs = T5 * (beta * T2 - beta + cnst1 * ( - beta * T3) ) ;
                Q_sL_dPb = T5 * ( - beta * T2 + beta + cnst1 * beta * T4 ) ;
            end

            if (flg_conv) begin
                lp_s0 = `lp_se_max + 1 ; // exit Newton Loop
            end else begin
                PF1 = Cox * (Vgp - phi_sL_DEP) + Q_sL + (Q_bL_dep + Q_subL_dep) ;
                PF11 = - Cox + Q_sL_dPs ;
                PF12 = Q_sL_dPb + (Q_bL_dep_dPb + Q_bL_dep_dPd * phi_jL_DEP_dPb + Q_subL_dep_dPd * phi_jL_DEP_dPb) ;
                PF2 = phi_bL_DEP - phib_ref ;
                PF21 = - phib_ref_dPs ;
                PF22 = 1.0  - phib_ref_dPb ;
                PDJ = PF11 * PF22 - PF12 * PF21;
                PDJI = ( PDJ > 0.0 ) ? 1.0 / (PDJ + `Small) : 1.0 / (PDJ - `Small) ;
                PJI11 = PF22;
                PJI12 = - PF12;
                PJI21 = - PF21;
                PJI22 = PF11;
                dPs = -PDJI * (PJI11 * PF1 + PJI12 * PF2);
                dPb = -PDJI * (PJI21 * PF1 + PJI22 * PF2);
                T1 = abs(dPs);
                T1 = (T1 < abs(dPb)) ? abs(dPb) : T1 ;
                if (T1 > `dP_max) begin
                    dPs = dPs * ( `dP_max / T1 );
                    dPb = dPb * ( `dP_max / T1 );
                end
                if (T1 < `ps_conv) begin
                    flg_conv = 1 ; // break
                end

                phi_sL_DEP = phi_sL_DEP + dPs ;
                phi_bL_DEP = phi_bL_DEP + dPb ;

            end // End of flg_conv=1

        end // End of newton loop

        if ( flg_conv == 0 ) begin
            $write( "*** warning(HiSIM_HV(%m)): Went Over Iteration Maximum(Psl)\n" ) ;
            $write( " Vbse   = %7.3f Vdse = %7.3f Vgse = %7.3f\n" ,Vbse , Vdse , Vgse ) ;
        end

        T1 = beta * (phi_sL_DEP - phi_bL_DEP) ;
        T2 = exp(T1) ;
        if ( phi_sL_DEP >= phi_bL_DEP ) begin
            Q_nL = Q_sL ;
            Q_sL_dep = 0.0 ;
            Q_subL = 0.0 ;
        end else begin
            Q_nL = 0.0 ;
            Q_sL_dep = cnst0 * sqrt(T2 - 1.0 - T1 + 1e-15) ;
            if ( W_bsubL > UC_DEPTHN ) begin
                Q_subL = 0.0 ;
            end else begin
                T3 = cnst0 * sqrt( - T1
                + cnst1 * (exp( - beta * (phi_sL_DEP - Vbsc)) - exp( - beta * (phi_bL_DEP - Vbsc))) ) ;
                Q_subL = T3 - cnst0 * sqrt( - T1)  ;
            end
        end // ( phi_sL_DEP >= phi_bL_DEP )

        `Fn_SL_CP( T2 , (phi_sL_DEP - Vds_maxbL) , 0.0, Ps_delta, 4 , T0 )
        T4 = exp(beta * T2) - 1.0 - beta * T2 + 1e-15 ;
        Q_nL_cur = - cnst0 * sqrt(T4) ;

    end

    //---------------------------------------------------*
    //* Assign Pds.
    //*-----------------//
    Ps0 = phi_s0_DEP ;
    Psl = phi_sL_DEP ;
    Pds = phi_sL_DEP - phi_s0_DEP ;

    //-----------------------------------------------------------*
    //* Modified potential and Q_n0 for symmetry.
    //*-----------------//
    T1 = ( Vds - Pds ) / 2 ;
    `Fn_SymAdd( Pzadd , T1 , PZADD0*0.1 , T2 )
`ifdef REPLACE_CLIPPING_WITH_SMOOTHING //revised for continuity (Qn0)
        `Fn_SL_CP(Pzadd, Pzadd, `epsm10, `epsm10, 2, T0)
`else
        if ( Pzadd < `epsm10 ) begin
            Pzadd = `epsm10 ;
        end
`endif
    Ps0z = Ps0 + Pzadd ;
    // Q_n0_Sym
    `Fn_SL_CP( T2 , (Ps0z - Vds_maxb0) , 0.0, Ps_delta, 4 , T0 )
    T4 = exp(beta * T2) - 1.0 - beta * T2 + 1e-15 ;
    Q_n0_sym = - cnst0 * sqrt(T4) ;

    //---------------------------------------------------*
    // Calc. the resister width of source and drain side
    //*-----------------//

    begin : Calc_W_res_with_DD_mode

        real Pb0DEP , dphi_sb , c_sb , Q_s0 , Q_s0_dPs ;

        if ( W_bsub0 > UC_DEPTHN ) begin
            Ws = Tnp ;  // Ids_res = 0
        end else begin

            `Fn_SU_CP( Ps0DEP , Ps0 , 0.0 , 0.1 , VgpDEP_pw , T0 )
            vfb_res = Vgs - Vgp - (UC_VFBC - DEPVFBC - VFBOFFSET) ;
            Vgp_res = Vgs - vfb_res ;
            `Fn_SU_CP( Vgp_res , Vgp_res , 0.0 , VgpDEP_dlt , VgpDEP_pw , T0 )
            flg_conv = 0;

            for ( lp_s0 = 1 ; lp_s0 <= `lp_se_max ; lp_s0 = lp_s0 + 1 ) begin

                T1 = beta * Ps0DEP ;
                T2 = exp(T1) ;
                if ( Ps0DEP >= 0.0 ) begin
                    Q_s0 = - cnst0 * sqrt(T2 - 1.0 - T1 + 1e-15) ;
                    Q_s0_dPs = 0.5 * cnst0 * cnst0 / Q_s0 * (beta * T2 - beta ) ;
                end else begin
                    T3 = exp( - beta * (Ps0DEP - Vbsc)) ;
                    T4 = exp( - beta * (       - Vbsc)) ;
                    Q_s0 = cnst0 * sqrt(T2 - 1.0 - T1 + cnst1 * (T3 - T4) + 1e-15) ;
                    T5 = 0.5 * cnst0 * cnst0 / Q_s0 ;
                    Q_s0_dPs = T5 * (beta * T2 - beta + cnst1 * ( - beta * T3) ) ;
                end

                if (flg_conv) begin
                    lp_s0 = `lp_se_max + 1 ; // exit Newton Loop
                end else begin
                    PF1  = Cox * (Vgp_res - Ps0DEP) + Q_s0 ;
                    PF11 = - Cox + Q_s0_dPs ;
                    dPs  = - PF1 / PF11 ;
                    if (abs(dPs) < `ps_conv2*100) begin
                        flg_conv = 1 ;
                    end else if (dPs > `dP_max) begin
                        dPs = `dP_max ;
                    end else if (dPs < - `dP_max) begin
                        dPs = - `dP_max ;
                    end

                    Ps0DEP = Ps0DEP + dPs ;

                end // End of flg_conv=1

            end // End of Newton Loop

            if ( flg_conv == 0 ) begin
                $write( "*** warning(HiSIM_HV(%m)): Went Over Iteration Maximum(Pres)\n" ) ;
                $write( " Vbse   = %7.3f Vdse = %7.3f Vgse = %7.3f\n" ,Vbse , Vdse , Vgse ) ;
            end

            Ps0DEP = - Ps0DEP ;
            dphi_sb = q_Ndepm * Tnp * Tnp / 2.0 / `C_ESI ;
            T0 = DEPSUBSL * sqrt(2.0 * beta * dphi_sb) ;
            T1 = (exp(T0) + exp(-T0)) / 2 ;
            c_sb = ln(T1) / dphi_sb ;
            TX = c_sb * Ps0DEP ;
            T0 = exp(- c_sb * dphi_sb) ;
            if (abs(TX) > 1E-8) begin
                T1 = exp(TX) * T0 ;
                T2 = T1 - T0 ;
            end else begin
                T1 = (1 + TX) * T0 ;
                T2 = TX * (1 + TX / 2) * T0 ;
            end
            if (abs(T2) > 1E-8) begin
                Pb0DEP = ln(1 + T2) / c_sb ;
            end else begin
                Pb0DEP = T2 / c_sb ;
            end

            if ( (2.0 * `C_ESI * (Ps0DEP - Pb0DEP) / q_Ndepm ) <= 0) begin
                Ws = 0.0;
            end else begin
                Ws = sqrt(2.0 * `C_ESI * ( Ps0DEP - Pb0DEP) / q_Ndepm ) ;
            end

            Ws = (Ws > Tnp) ? Tnp : Ws ;

        end // ( W_bsub0 < UC_DEPTHN )
    end // Calc_W_res_with_DD_mode

    if (Ws < Tnp ) begin
        W_res = Tnp - Ws ;
    end else begin
        W_res = 0.0 ;
    end

    //---------------------------------------------------*
    // Calc. Idd
    //*-----------------//
    Qn_drift = - (Q_n0_cur + Q_nL_cur) ;
    if ( Pds < 0.0 ) begin // take care of numerical noise //
        Pds = 0.0 ;
        phi_sL_DEP = phi_s0_DEP ;
        Idd = 0.0 ;
    end else begin
        Idd = beta * (Qn_drift) / 2.0 * Pds ;
        Idd = (Idd < 0.0) ? 0.0 : Idd ;
    end

    Qn0 = - Q_n0_sym ;
    Lch = Leff ;

    //-----------------------------------------------------------*
    //* Muun : surface universal mobility.  (CGS unit)
    //*-----------------//
    T2 = ninv_o_esi / `C_m2cm ;
    T0 = Ninvde ;
    Pdsz = sqrt(Pds * Pds + VZADD0) - sqrt(VZADD0) ;
    T4 = 1.0 + (Pdsz) * T0 ;   // for DC symmetry

    T5 = T2 * Qn0 ;
    T3 = T5 / T4 ;
    Eeff = T3 ;
    T5 = `Fn_Pow( Eeff , MUEPH0 - 1.0e0 ) ;
    T8 = T5 * Eeff ;
    T7 = `Fn_Pow( Eeff , muesr - 1.0e0 ) ;
    T6 = T7 * Eeff ;
    T9 = `C_QE * `C_m2cm_p2 ;
    Rns = Qn0 / T9 ;

    T2 = UC_MUECB0 ;
    T1 = 1.0e0 / ( T2 + UC_MUECB1 * Rns / 1.0e11 )
        + mphn0 * T8 + T6 / UC_MUESR1 ;

    Muun = 1.0e0 / T1 ;

    //  Change to MKS unit //
    Muun = Muun / `C_m2cm_p2 ;

    //-----------------------------------------------------------*
    //* Mu : mobility
    //*-----------------//
    T2 = beta * (Qn0 + `Small) * Lch ;
    T1 = 1.0e0 / T2 ;
    TY = Idd * T1 ;
    T2 = 0.2 * Vmaxe / Muun ;
    Ey = sqrt( TY * TY + T2 * T2 ) ;
    T4 = 1.0 / Ey ;
    Em = Muun * Ey ;
    T1 = Em / Vmaxe ;
    // note: bb = 2 (electron) ;1 (hole) //
    if ( 1.0e0 - `epsm10 <= BB && BB <= 1.0e0 + `epsm10 ) begin
        T3 = 1.0e0 ;
    end else if ( 2.0e0 - `epsm10 <= BB && BB <= 2.0e0 + `epsm10 ) begin
        T3 = T1 ;
    end else begin
        T3 = `Fn_Pow( T1 , BB - 1.0e0 ) ;
    end
    T2 = T1 * T3 ;
    T4 = 1.0e0 + T2 ;
    if ( 1.0e0 - `epsm10 <= BB && BB <= 1.0e0 + `epsm10 ) begin
        T5 = 1.0 / T4 ;
    end else if ( 2.0e0 - `epsm10 <= BB && BB <= 2.0e0 + `epsm10 ) begin
        T5 = 1.0 / sqrt( T4 ) ;
    end else begin
        T6 = `Fn_Pow( T4 , ( - 1.0e0 / BB - 1.0e0 ) ) ;
        T5 = T4 * T6 ;
    end
    Mu = Muun * T5 ;
    Mu_acc = Mu ;
    Ey_acc = Ey ;

    //-----------------------------------------------------------*
    //*  Vds for resistor region current.
    //*-----------------//
    Vds_res = Vdsorg ;
    if ( Vdsorg > 1e-6 ) begin
        T10 = ( Vbsc + beta_inv ) * DEPVSATR  ;
        T4 = 1.0e0 + C2_q_Ndepm_esi_Cox_inv2 * (Vgp - T10) ;
        T5 = 1.0e0 + C2_q_Ndepm_esi_Cox_inv2 ;
        `Fn_SL_CP( T4 , T4 , 0, T5 , 2 , T0 )
        T3 = sqrt(T4) ;
        T10 = Vgp + q_Ndepm_esi_Cox_inv2 * ( 1.0e0 - T3 )  ;
        `Fn_SL_CP( T10 , T10 , UC_DEPLEAK, DEPQFN_dlt, 2 , T0 )
        T1 = Vds_res / T10 ;
        T2 = `Fn_Pow( T1 , DEPDDLT-1.0 ) ;
        T3 = 1.0 + T2 * T1 ;
        T4 = `Fn_Pow( T3 , 1.0 / DEPDDLT-1.0 ) ;
        T6 = T4 * T3  ;
        Vds_res = Vds_res / T6 ;
    end

    //-----------------------------------------------------------*
    //*  resistor region universal mobility.  (CGS unit)
    //*-----------------//

    T1 = Vgs - Vbsc ;
    `Fn_SL_CP( T1 , T1 , 0 , 1.0 , 2 , T0 )
    Eeff = T1 / UC_DEPTHN ;
    T5 = `Fn_Pow( Eeff , DEPMUEA1 - 1.0e0 ) ;
    T8 = T5 * Eeff ;
    T2 = UC_DEPMUE0 + `Small ;
    T1 = 1.0e0 / T2 + T8 / UC_DEPMUE2 ;
    Muun = 1.0 / T1 ;

    //  Change to MKS unit //
    Muun = Muun / `C_m2cm_p2 ;

    Edri = Vds_res / Lch ;
    `Fn_Sym4( T1 , Vds_res , 0.1 )  /* Edri for Symmetry */
    T1 = T1 / Lch ;
    T1 = Muun * T1 / UC_DEPVMAX ;
    T2 = `Fn_Pow(T1,DEPBB) ;
    T3 = 1.0 + T2 ;
    T4 = `Fn_Pow(T3,1.0 / DEPBB) ;

    Mu_res = Muun / T4 ;

    //  Modification of NDEPM and Qn_dep
    Qn_res  = - W_res * `C_QE  * UC_NDEPM ;
    Ids_res = weff_nf * ( - Qn_res) * Mu_res * Edri ;

    //-----------------------------------------------------------*
    //* Ids: channel current.
    //*-----------------//

    betaWL = weff_nf * beta_inv / Lch ;
    Ids_acc = betaWL * Idd * Mu_acc ;
    Ids0 = Ids_acc + Ids_res ;

    // Vdseff //
    Vds = Vdsorg;

    //-----------------------------------------------------------*
    //* Adding parasitic components to the channel current.
    //*-----------------//
    if ( PTL != 0 ) begin
        T1 =  0.5 * ( Vds - Pds ) ;
        `Fn_SymAdd( T6 , T1 , 0.01 , T2 )
        T1 = 1.1 - ( phi_s0_DEP + T6 );
        `Fn_SZ( T2 , T1 , 0.05 , T0 )
        T2 = T2 + `Small ;
        T0 = beta * ptl0 ;
        T3 = Cox * T0 ;
        T0 = pow( T2 , PTP ) ;
        T9 = T3 * T0 ;
        T4 = 1.0 + Vdsz * PT2 ;
        T0 = pt40 ;
        T5 = phi_s0_DEP + T6 - Vbsz ;
        T4 = T4 + Vdsz * T0 * T5 ;
        T6 = T9 * T4 ;
        T9 = T6 ;
    end else begin
        T9 = 0.0 ;
    end
    if ( GDL != 0 ) begin
        T1 = beta * gdl0 ;
        T2 = Cox * T1 ;
        T8     = T2 * Vdsz ;
    end else begin
        T8 = 0.0 ;
    end
    if (( T9 + T8 ) > 0.0 ) begin
        Idd1 = Pds * ( T9 + T8 ) ;
        Ids0 = Ids0 + betaWL * Idd1 * Mu ;
    end

    if ( flg_rsrd == 2 || flg_rsrd == 3 ) begin
        if ( RD20 > 0.0 ) begin
            T4 = Rd23e ;
            T1 = UC_RD24 * ( Vgse-RD25 ) ;
            `Fn_SL( T2 , T1 , T4 , `delta_rd , T0 )
            T3 = T4 * ( RD20 + 1.0 ) ;
            `Fn_SU( T7 , T2 , T3 , `delta_rd , T0 )
        end else begin
            T7 = Rd23e;
        end

        if (Vdse >= 0.0) begin
            Vdse_eff = Vdse ;
        end else begin
            Vdse_eff = 0.0 ;
        end
        // smoothing of Ra for Vdse_eff close to zero //
        // ... smoothing parameter is Ra_N            //
        if (Vdse_eff < `Ra_N * `Small2) begin
            Ra_alpha = pow( `Ra_N + 1.0 , RD21 - 1.0 )
                  * (`Ra_N + 1.0 - 0.5 * RD21 * `Ra_N)
                  * pow( `Small2,RD21 );
            Ra_beta = 0.5 * RD21
                 * pow( `Ra_N + 1.0 , RD21 - 1.0 ) / `Ra_N
                 * pow( `Small2, RD21 - 2.0 );
            T1 = Ra_alpha + Ra_beta * Vdse_eff * Vdse_eff;
        end else begin
            T1 = pow( Vdse_eff + `Small2 , RD21 ) ;
        end
        T9 = pow( Vdse_eff + `Small2 , RD22D ) ;
        Ra = ( T7 * T1 + Vbse * UC_RD22 * T9 ) / weff_nf ;
        T0 = Ra * Ids0 ;
        T1 = Vds + `Small2 ;
        T2 = 1.0 / T1 ;
        T3 = 1.0 + T0 * T2 ;
        T4 = 1.0 / T3 ;
        Ids = Ids0 * T4 ;
    end else begin
        Ids = Ids0 ;
        Ra = 0.0 ;
    end

    /* charge calculation */

    //---------------------------------------------------*
    //* Qbu : -Qb in unit area.
    //*-----------------//
    Qbu = - 0.5 * (Q_sub0 + Q_subL + Q_sub0_dep + Q_subL_dep ) ;
    Qiu = - 0.5 * (Q_n0 + Q_nL + Q_s0_dep + Q_sL_dep + Q_b0_dep + Q_bL_dep) ;
    Qdrat = 0.5;

    //---------------------------------------------------*
    //set flg_noqi & Qiu_noi
    //---------------------------------------------------*
    Qiu_noi = - 0.5 * (Q_n0 + Q_nL) ;
    Qn0 = -Q_n0 ;
    Ey = Ey_acc ;
    if ( Qn0 < `Small || Qiu < `Small ) begin
`ifdef REPLACE_CLIPPING_WITH_SMOOTHING //removed for continuity (Qn0)
`else
            Qn0 = `Small ;
`endif
        flg_noqi = 1 ;
    end

`ifdef dbgprn3
`include "dbgprn3.cnt"
`endif

end // HSMHV_depmos2

// ---- end `include "HSMHV_depmos2.inc" ----
                end
                3: begin // 2.4.0 new Model
// ---- begin `include "HSMHV_depmos3.inc" ----
/***********************************************************************

 HiSIM (Hiroshima University STARC IGFET Model)
 Copyright (C) 2000-2016 Hiroshima University and STARC
 Copyright (C) 2016-2023 Hiroshima University
 HiSIM_HV (High-Voltage Model)
 Copyright (C) 2007-2016 Hiroshima University and STARC
 Copyright (C) 2016-2023 Hiroshima University

 MODEL NAME : HiSIM_HV
  ( VERSION : 2  SUBVERSION : 5  REVISION : 1 )
 Model Parameter 'VERSION' : 2.51
 FILE : vaFiles/HSMHV_depmos3.inc

 Date : 2023.02.09

 released by Hiroshima University

***********************************************************************/
//
////////////////////////////////////////////////////////////////
//
//
//
//
//Licensed under the Educational Community License, Version 2.0
//(the "License"); you may not use this file except in
//compliance with the License.
//
//You may obtain a copy of the License at:
//
//      http://opensource.org/licenses/ECL-2.0
//
//Unless required by applicable law or agreed to in writing,
//software distributed under the License is distributed on an
//"AS IS" BASIS, WITHOUT WARRANTIES OR CONDITIONS OF ANY KIND,
//either express or implied. See the License for the specific
//language governing permissions and limitations under the
//License.
//
//
//The HiSIM_HV standard has been supported by the members of
//Silicon Integration Initiative's Compact Model Coalition. A
//link to the most recent version of this standard can be found
//at:
//
//http://www.si2.org/cmc
//
////////////////////////////////////////////////////////////////
//

begin : HSMHV_depmos3

    real W_bsub0, W_bsubL ;
    real Vds_maxb0, Vds_maxbL ;
    real phi_s0_DEP, phi_sL_DEP , Vbi_DEP ;
    real phi_b0_DEP, phi_bL_DEP ;
    real phi_j0_DEP, phi_jL_DEP ;
    real phi_s0_DEP_ini , phi_sL_DEP_ini ;
    //
    real Q_s0, Q_sL ;
    //
    real PF1 , PF11 , PF12 , PF2 , PF21 , PF22 ;
    real PDJ , PDJI , PJI11 , PJI12 , PJI21 , PJI22 , dPs , dPb ;
    //
    real q_Ndepm_esi, Edri ;
    real Ey_acc , Vbsc ;
    //
    real Q_n0_cur , Q_nL_cur , Q_n0_sym ;
    real sum_Q_nx_cur ;
    real Q_n0 , Q_nL , Qn_res ;
    //
    real Q_s0_dPs, Q_sL_dPs ;
    real Q_s0_dPb, Q_sL_dPb ;
    real NdepmpNsub_inv1, NdepmpNsub ;
    //
    real Tn , N_res ;
    real q_Ndepm , q_Ndepm_esi_Cox_inv2 , C2_q_Ndepm_esi_Cox_inv2 ;
    real C_2ESIpq_Ndepm ;
    real phib_ref, phib_ref_dPs , phib_ref_dPb , phi_j0_DEP_dPb , phi_jL_DEP_dPb ;
    //
    real VgpDEP_dlt;
    integer VgpDEP_pw;
    real Vgpz , Vgp_res ;
    real Vgp_res_raw; // without Fn_SU_CP (ceiling by 0.0)
    real Ws, Tnp ;
    real Tnp0 , phi_j0_DEP0 , W_bsub00 , wDEPSUBSL ;
    real Ps0_res , Eeff_res , W_res_leak ;

    real phi_vsat , Q_sat , Q_sat_dPs , Vgpsat;
    real Vdssat_ini , Vdssat1d , Vdssat ; // , Vdssat_res ;
    real u, usqr;
    real Pb0DEP , Vds_res0 , Vds_res0_sym , Vds_resz , Edri2 ;
    real depvbs , Ps0DEP0 ; //, Ps0DEP1 ;
    //real Qn_drift , real Idd_drift , Qn_delta ;

    `define C_PHI_1_MINIMUM (1e-7)
    `define C_leak_delta 1e-4
    `define C_sum_Q_nx_cur_delta (`VgVt_Small*`Cox_Small)

    `define CO_WK_VDSATRES1VARNT 0    // "-", 0, 1, "VDSATRES 1varNT(1) or analytical(0); depmos3") // 20170929                                                                MPIcc
    //VAMPyRE NOTICE//`define CO_WK_QNRESWRES      0    // "-", 0, 2, "W_res(0) or W_res_qnres(1) for calculation of Qn_res ; further, W_res replaced by W_res_qnres (2) depmos3") // 20170831   MPIcc
    `define WK_IACC              1.0  // "-", 0, 4.0,"Ids_acc enabler; depmos3")                                                                                       MPRco
    `define WK_IRES              1.0  // "-", 0, 4.0,"Ids_res enabler; depmos3")                                                                                       MPRco
    `define WK_ILEAK             1.0  // "-", 0, 4.0,"Ids_leak enabler; depmos3")                                                                                      MPRco
    `define WK_CO_DEPMUE         1    // "-", "DEPMUE enabler depmos3") // 20170902                                                                                            MPIsw
    `define WK_CO_DEPMUEPH       1    // "-", "DEPMUEPH enabler depmos3") // 20170902                                                                                  MPIsw
    `define WK_CO_NEWVGPRES      0    // "-", 0,2, "Disregard dVth etc for Vgpres (1) furthermore Vgs (2) instead of Vgsz depmos3") // 20170902                        MPIcc
    `define WK_CO_MUECB          1    // "-", "MUECB enabler depmos3") // 20170920                                                                                             MPIsw
    `define WK_CO_MUEPH          1    // "-", "MUEPH enabler depmos3") // 20170920                                                                                             MPIsw
    `define WK_CO_MUESR          1    // "-", "MUESR enabler depmos3") // 20170920                                                                                             MPIsw
    `define WK_CO_DVGPACC        1    // "-", "Vgp acc dVgp on(1)  off(0) depmos3") // 20171002                                                                        MPIsw
    `define WK_CO_VDSSATACC_1VARNT 1  // "-", "Vdssat for Iacc; 1varNT(1) or analytical(0); depmos3") // 20171004                                                      MPIsw
    `define WK_CO_SMOOTHCHARGE_IDD 1  // "-","Smooth Q_n0, Q_nL for IDD using DEPPS (1); depmos3")// 20171006                                                          MPIsw
    //VAMPyRE NOTICE//    `define WK_DVTHRES_MULT          1    // "-", -0.5, 1.5, "dVth multiplier for Vgp_res; depmos3") // 20171015                                                                 MPRco
    `define WK_CO_UWE20171213        0    //"-","Calc Wres 20171213 Uwe depmos3")                                                                                                MPIsw
    // Constants
    Vbi_DEP = Vbipn ;
    q_Ndepm = `C_QE * UC_NDEPM ;
    q_Ndepm_esi = `C_QE * UC_NDEPM * `C_ESI ;
    C_2ESIpq_Ndepm = 2.0 *`C_ESI/q_Ndepm ;
    NdepmpNsub  = UC_NDEPM / EF_NSUBC ;
    NdepmpNsub_inv1  = 1.0 / (1.0 + NdepmpNsub ) ;
    q_Ndepm_esi_Cox_inv2 = q_Ndepm_esi / ( Cox * Cox ) ;
    C2_q_Ndepm_esi_Cox_inv2 = 2.0 / q_Ndepm_esi_Cox_inv2 ;
    VgpDEP_pw  = 2 ;

    UC_CLM2 = (($param_given(CLM2)) ? UC_CLM2 : 5.0e9/(TNDEP * NDEPM));
    `Fn_SL_CP(UC_CLM2, UC_CLM2, 2.0, 0.1, 2, T0)

    // Initialization for hidden states
    phi_s0_DEP = 0.0 ;
    phi_sL_DEP = 0.0 ;
    Q_s0       = 0.0 ;
    Q_sL       = 0.0 ;
    Ps0DEP0    = 0.0 ;
    Vgp_res_raw = 0.0 ;

    Vbsc = Vbscl ; // Change Vbs vars to Vbsc(internal)

    //---------------------------------------------------*
    //* start of Ps0 calculation. (label)
    //*-----------------//
    Vgp = Vgs - Vfb + `WK_CO_DVGPACC*(dVth - dPpg) ; // 20171002
    //---------------------------------------------------*
    //* initial potential Ps0 , Pb0 and etc calculated.
    //*------------------//
    `Fn_SU( phi_s0_DEP_ini , Vgp , 0.3 , 0.01 , T0 )
    `Fn_SL( phi_s0_DEP_ini , phi_s0_DEP_ini , Vbsc - Vbi_DEP , 0.01 , T0 )
    phi_s0_DEP = phi_s0_DEP_ini ;

    Vds_maxb0 = 0.0 ;
    phi_b0_DEP  = Vds_maxb0 ;
    phi_j0_DEP  = NdepmpNsub_inv1 * ( Vbsz - Vbi_DEP) ;
    phi_j0_DEP0 = NdepmpNsub_inv1 * (      - Vbi_DEP) ;

    `Fn_SL_CP(T1, (- phi_j0_DEP) , 0, 1e-3, 2, T3)
    W_bsub0  = sqrt(C_2ESIpq_Ndepm * T1 ) ;  // update for Tnp
    `Fn_SL_CP(T1, (- phi_j0_DEP0), 0, 1e-3, 2, T3)
    W_bsub00 = sqrt(C_2ESIpq_Ndepm * T1 ) ;  // update for Tnp0

    // Intends to vary a landing of W_res to its maximum with Vds
    // Vds dependence of TNDEP
    // imported from depmos2
    if ( TNDEPV != 0.0 ) begin
        T1 = UC_DEPTHN * ( 1 - TNDEPV * Vds ) ;
        T2 = 1e-3 * UC_DEPTHN ;
        `Fn_SL(        T1 , T1 , 0.1 * UC_DEPTHN , T2 , T0 )
        `Fn_SU( UC_DEPTHN , T1 , 2.0 * UC_DEPTHN , T2 , T0 )
    end

    // calc. Tn and Tnp , wDEPSUBSL
    Tn   = UC_DEPTHN ;
    Tnp  = UC_DEPTHN - W_bsub0 ;
    Tnp0 = UC_DEPTHN - W_bsub00 ;
    `Fn_SL_CP(Tnp , Tnp , TNDEPMIN, TNDEPMIN*1e-1, 1, T0)
    `Fn_SL_CP(Tnp0, Tnp0,        0, TNDEPMIN*1e-1, 1, T0)
    wDEPSUBSL = (DEPSUBSL - DEPSUBSL0) * (Tnp / Tnp0) + DEPSUBSL0 ;

    /*                               */
    /* solve poisson at source side  */
    /*                               */

    flg_conv = 0 ;
    phi_j0_DEP_dPb = NdepmpNsub_inv1 * NdepmpNsub ;

    for ( lp_s0 = 1 ; lp_s0 <= `lp_se_max  ; lp_s0 = lp_s0 + 1 ) begin  // {

        phi_j0_DEP = NdepmpNsub_inv1 * (NdepmpNsub * phi_b0_DEP + Vbsc - Vbi_DEP) ;

        T1 = phi_b0_DEP - phi_j0_DEP ;
        `Fn_SL_CP(T1, T1, 0, 1e-3, 2, T2)
        W_bsub0 = sqrt(C_2ESIpq_Ndepm * T1) ;
        `Fn_SU_CP( W_bsub0 , W_bsub0 , Tn , 1e-12, 2 , T3 )
        T3 = T2 * T3 ;

        phib_ref = phi_s0_DEP + (Tn*Tn + W_bsub0 * (W_bsub0 - 2 * Tn)) / C_2ESIpq_Ndepm ;
        phib_ref_dPs = 1.0 ;
        phib_ref_dPb = (T3 - Tn /W_bsub0 * T3 ) * (1.0 - phi_j0_DEP_dPb) ;

        `Fn_SU_CP( phib_ref , phib_ref , Vds_maxb0 , DEPFDPD, 4 , T0 )
        phib_ref_dPs = phib_ref_dPs * T0 ;
        phib_ref_dPb = phib_ref_dPb * T0 ;

        T5 = beta * ( phi_s0_DEP - phi_b0_DEP );
        T6 = exp( T5 ) ;
        T10 = T6 - 1.0 - T5 ;
        if ( T5 >= `C_PHI_1_MINIMUM ) begin
            flg_zone = -1 ;
            Q_s0 = - cnst0 * sqrt( T10 ) ;
            T11 = 0.5 * cnst0 * cnst0 * beta / Q_s0 ;
            Q_s0_dPs = T11 * (   T6 - 1 ) ;
            Q_s0_dPb = T11 * ( - T6 + 1 ) ;
        end else if ( T5 < -`C_PHI_1_MINIMUM) begin //  T5 < -`C_PHI_1_MINIMUM
            flg_zone = 1 ;
            T8 = exp( - beta * (phi_s0_DEP - DEPRBR * Vbsc )) ;
            T9 = exp( - beta * (phi_b0_DEP - DEPRBR * Vbsc )) ;
            Q_s0 =  cnst0 * sqrt( T10 + cnst1 * ( T8 - T9 + T5 ) ) ;
            T11 = 0.5 * cnst0 * cnst0 * beta / Q_s0 ;
            Q_s0_dPs = T11 * (   T6 - 1 + cnst1 * ( - T8 + 1) ) ;
            Q_s0_dPb = T11 * ( - T6 + 1 + cnst1 * (   T9 - 1) ) ;
        end else if ( T5 > 0 ) begin //  `C_PHI_1_MINIMUM > T5 > 0
            u = 0.5 * (1.0 + T5 * `C_1o3);
            usqr = sqrt(u);
            Q_s0 = -cnst0 * sqrt(u) * T5;
            Q_s0_dPs = -cnst0 *beta* ( usqr + T5/12.0/usqr );
            Q_s0_dPb = -Q_s0_dPs;
        end else begin              //   -`C_PHI_1_MINIMUM < T5 < 0
            u = 0.5 * (1.0 + T5 * `C_1o3);
            usqr = sqrt(u);
            Q_s0 = -cnst0 * sqrt(u) * T5;
            Q_s0_dPs = -cnst0 *beta* ( usqr + T5/12.0/usqr );
            Q_s0_dPb = -Q_s0_dPs;
        end // else: !if( T5 > 0 )

        if (flg_conv) begin
            lp_s0 = `lp_se_max + 1 ; // exit Newton Loop
        end else begin
            PF1  = Cox * (Vgp - phi_s0_DEP) + Q_s0 ;
            PF11 = - Cox + Q_s0_dPs ;
            PF12 = Q_s0_dPb ;

            PF2  = phi_b0_DEP - phib_ref ;
            PF21 = - phib_ref_dPs ;
            PF22 = 1.0 - phib_ref_dPb ;

            PDJ  = PF11 * PF22 - PF12 * PF21;
            PDJI = ( PDJ > 0.0 ) ? 1.0 / (PDJ + `Small) : 1.0 / (PDJ - `Small) ;
            PJI11 = PF22;
            PJI12 = - PF12;
            PJI21 = - PF21;
            PJI22 = PF11;
            dPs = -PDJI * (PJI11 * PF1 + PJI12 * PF2);
            dPb = -PDJI * (PJI21 * PF1 + PJI22 * PF2);
            T1 = abs(dPs);
            T1 = (T1 < abs(dPb)) ? abs(dPb) : T1 ;
            if (T1 > `dP_max) begin
                dPs = dPs * ( `dP_max / T1 );
                dPb = dPb * ( `dP_max / T1 );
            end
            if (T1 < `ps_conv2) begin
                flg_conv = 1 ; // break
            end

            phi_s0_DEP = phi_s0_DEP + dPs ;
            phi_b0_DEP = phi_b0_DEP + dPb ;

        end // End of flg_conv=1

    end // End of Newton Loop }

    if ( flg_conv == 0 ) begin
        $write( "*** warning(HiSIM_HV(%m)): Went Over Iteration Maximum(Ps0)\n" ) ;
        $write( " Vbse   = %7.3f Vdse = %7.3f Vgse = %7.3f\n" ,Vbse , Vdse , Vgse ) ;
    end

    T5 = beta * ( phi_s0_DEP - phi_b0_DEP );
    T6 = exp( T5 );
    T10 = T6 - 1.0 - T5 + 1e-15 ;
    Q_n0 = ( T5 > 0 ) ? -cnst0 * sqrt( T10 ) : cnst0 * sqrt( T10 ) ;

    if (`WK_CO_SMOOTHCHARGE_IDD == 1 ) begin
        `Fn_SL_CP( T2 , (phi_s0_DEP - Vds_maxb0) , 0.0, DEPPS, 6 , T0 )
        T4 = exp(beta * T2) - 1.0 - beta * T2 + 1e-15 ;
        Q_n0_cur = - cnst0 * sqrt(T4) ;

    end else begin
        Q_n0_cur = Q_n0;
    end

    //-----------------------------------------------------------*
    //* Start point of Psl(= Ps0 + Pds) calculation.(label)
    //*-----------------//

    // start_of_Psl:
    if ( `WK_CO_VDSSATACC_1VARNT == 1 ) begin // 20171004
        // calculate Vdssat by 1D Newton
        Vgpsat = Vgp ;
        T4 = 1.0e0 + C2_q_Ndepm_esi_Cox_inv2 * ( Vgpsat ) ;
        T3 = (T4 > 0) ?  sqrt(T4) : -sqrt(-T4) ;
        Vdssat_ini = Vgpsat + q_Ndepm_esi_Cox_inv2 * ( 1.0 - T3 ) + DEPVSATA ; // 20171004 revert
        phi_vsat = Vdssat_ini ;

        flg_conv = 0 ;

        for ( lp_s0 = 1 ; lp_s0 <= `lp_se_max  ; lp_s0 = lp_s0 + 1 ) begin  // {

            T1 = - beta * phi_vsat ;
            T2 = exp(T1) ;
            T4 = sqrt(2.0*q_Ndepm_esi/beta) ;
            T10 = T2 - T1 - 1 ;
            Q_sat = T4 * sqrt( T10 + 1e-15 ) ;
            if ( T1 > 0 ) Q_sat = - Q_sat ;
            T11 = 0.5 * T4 * T4 * beta / Q_sat ;
            Q_sat_dPs = T11 * ( -T2 + 1 ) ;

            if (flg_conv) begin
                lp_s0 = `lp_se_max + 1 ; // exit Newton Loop
            end else begin
                PF1 = -Cox * (Vgpsat - phi_vsat + DEPVSATA ) + Q_sat ; // 20171004 revert
                PF11 = Cox + Q_sat_dPs ;
                dPs  = - PF1 / PF11 ;

                if (abs(dPs) < `ps_conv2) begin
                    flg_conv = 1 ;
                end else if (dPs > `dP_max) begin
                    dPs = `dP_max ;
                end else if (dPs < - `dP_max) begin
                    dPs = - `dP_max ;
                end

                phi_vsat = phi_vsat + dPs ;

            end //  flg_conv == 0
        end // End of phi_vsat loop

        Vdssat1d = phi_vsat ;
        // Smoothing for small Vds
        `Fn_SZ(Vdssat , Vdssat1d , DEPQF, T0 )

    end else begin // analytical
        //T10 = `Small ; redundant?
        //T4 = 1.0e0 + C2_q_Ndepm_esi_Cox_inv2 * ( Vgp -  T10 ) ; // redundant?
        T4 = 1.0e0 + C2_q_Ndepm_esi_Cox_inv2 *  Vgp ;
        T5 = 1.0e0 + C2_q_Ndepm_esi_Cox_inv2 ;
        `Fn_SL_CP( T4 , T4 , 0, T5 , 2 , T0 )
        T3 = sqrt(T4) ;
        T10 = Vgp + q_Ndepm_esi_Cox_inv2 * ( 1.0 - T3 )  ;
        `Fn_SL_CP( Vdssat , T10 , 0.0 , DEPQF , 2 , T0 )
    end // else: !if( `WK_CO_VDSSATACC_1VARNT == 1 )

    //---------------------------------------------------*
    // calculate Vdseff //
    //*-----------------//
    Vdsorg = Vds ;
    // Smoothing for small Vds
    //`Fn_SZ(Vdssat , Vdssat1d , DEPQF, T0 )
    T1 = Vds / Vdssat ;
    T2 = `Fn_Pow( T1 , DDLTe ) ;
    T3 = 1.0 + T2 ;
    T4 = `Fn_Pow( T3 , 1.0 / DDLTe ) ;
    Vdseff = Vds / T4 ;
    Vds = Vdseff ;

    //---------------------------------------------------*
    //* start of Psl calculation. (label)
    //*-----------------//

    if ( Vds < 0.0 ) begin

        phi_sL_DEP = phi_s0_DEP ;
        phi_jL_DEP = phi_j0_DEP ;
        phi_bL_DEP = phi_b0_DEP ;

        Q_nL = Q_n0 ;
        Q_nL_cur = Q_n0_cur ;

    end else begin

        //---------------------------------------------------*
        //* initial potential Psl calculated.
        //*------------------//
        Vds_maxbL  = Vds ;

        `Fn_SU( phi_sL_DEP_ini , Vgp , phi_s0_DEP + Vds_maxbL , 0.01 , T0 )
        `Fn_SL( phi_sL_DEP_ini , phi_sL_DEP_ini , Vbsc - Vbi_DEP , 0.01 , T0 )

        phi_bL_DEP = Vds_maxbL ;
        phi_sL_DEP = phi_sL_DEP_ini ;

        /*                              */
        /* solve poisson  at drain side */
        /*                              */

        flg_conv = 0 ;
        phi_jL_DEP_dPb = NdepmpNsub_inv1 * NdepmpNsub ;

        for ( lp_sl = 1 ; lp_sl <= `lp_se_max  ; lp_sl = lp_sl + 1 ) begin  // {

            phi_jL_DEP  = NdepmpNsub_inv1 * (NdepmpNsub * phi_bL_DEP + Vbsc - Vbi_DEP) ;

            T1 = phi_bL_DEP - phi_jL_DEP ;
            `Fn_SL_CP(  T1, T1, 0, 1e-3, 2, T2)
            W_bsubL = sqrt(C_2ESIpq_Ndepm * T1 ) ;
            `Fn_SU_CP( W_bsubL , W_bsubL , Tn , 1e-12, 2 , T3 )
            T3 = T2 * T3 ;

            phib_ref = phi_sL_DEP + (Tn*Tn + W_bsubL * (W_bsubL - 2 * Tn)) / C_2ESIpq_Ndepm ;
            phib_ref_dPs = 1.0 ;
            phib_ref_dPb = (T3 - Tn /W_bsubL * T3 ) * (1.0 - phi_jL_DEP_dPb) ;

            `Fn_SU_CP( phib_ref , phib_ref , Vds_maxbL , DEPFDPD , 4 , T0 )
            phib_ref_dPs = phib_ref_dPs * T0 ;
            phib_ref_dPb = phib_ref_dPb * T0 ;

            T5 = beta * ( phi_sL_DEP - phi_bL_DEP );
            T6 = exp( T5 ) ;
            T10 = T6 - 1.0 - T5;
            if ( T5 >= `C_PHI_1_MINIMUM ) begin
                flg_zone = -1 ;
                Q_sL = - cnst0 * sqrt( T10 ) ;
                T11 = 0.5 * cnst0 * cnst0 * beta / Q_sL ;
                Q_sL_dPs = T11 * (  T6 - 1);
                Q_sL_dPb = T11 * ( -T6 + 1);
            end else if ( T5 < -`C_PHI_1_MINIMUM) begin //  T5 < -`C_PHI_1_MINIMUM
                flg_zone = 1 ;
                T8 = exp( - beta * (phi_sL_DEP - DEPRBR * Vbsc) ) ;
                T9 = exp( - beta * (phi_bL_DEP - DEPRBR * Vbsc) ) ;
                Q_sL =  cnst0 * sqrt( T10 + cnst1 * ( T8 - T9 + T5 ) ) ;
                T11 = 0.5 * cnst0 * cnst0 * beta / Q_sL ;
                Q_sL_dPs = T11 * (   T6 - 1 + cnst1 * ( - T8 + 1) ) ;
                Q_sL_dPb = T11 * ( - T6 + 1 + cnst1 * (   T9 - 1) ) ;
            end else if ( T5 > 0 ) begin                 //  `C_PHI_1_MINIMUM > T5 > 0
                u = 0.5 * (1.0 + T5 * `C_1o3);
                usqr = sqrt(u);
                Q_sL = -cnst0 * sqrt(u) * T5;
                Q_sL_dPs = -cnst0 *beta* ( usqr + T5/12.0/usqr );
                Q_sL_dPb = -Q_sL_dPs;
            end else begin
                u = 0.5 * (1.0 + T5 * `C_1o3);
                usqr = sqrt(u);
                Q_sL = -cnst0 * sqrt(u) * T5;
                Q_sL_dPs = -cnst0 *beta* ( usqr + T5/12.0/usqr );
                Q_sL_dPb = -Q_sL_dPs;
            end

            if (flg_conv) begin
                lp_sl = `lp_se_max + 1 ; // exit Newton Loop
            end else begin
                PF1  = Cox * (Vgp - phi_sL_DEP) + Q_sL ;
                PF11 = - Cox + Q_sL_dPs ;
                PF12 = Q_sL_dPb ;

                PF2  = phi_bL_DEP - phib_ref ;
                PF21 = - phib_ref_dPs ;
                PF22 = 1.0 - phib_ref_dPb ;

                PDJ  = PF11 * PF22 - PF12 * PF21;
                PDJI = ( PDJ > 0.0 ) ? 1.0 / (PDJ + `Small) : 1.0 / (PDJ - `Small) ;
                PJI11 = PF22;
                PJI12 = - PF12;
                PJI21 = - PF21;
                PJI22 = PF11;
                dPs = -PDJI * (PJI11 * PF1 + PJI12 * PF2);
                dPb = -PDJI * (PJI21 * PF1 + PJI22 * PF2);
                T1 = abs(dPs);
                T1 = (T1 < abs(dPb)) ? abs(dPb) : T1 ;
                if (T1 > `dP_max) begin
                    dPs = dPs * ( `dP_max / T1 );
                    dPb = dPb * ( `dP_max / T1 );
                end
                if (T1 < `ps_conv2) begin
                    flg_conv = 1 ; // break
                end

                phi_sL_DEP = phi_sL_DEP + dPs ;
                phi_bL_DEP = phi_bL_DEP + dPb ;

            end // End of flg_conv=1

        end // End of Newton Loop }

        if ( flg_conv == 0 ) begin
            $write( "*** warning(HiSIM_HV(%m)): Went Over Iteration Maximum(PsL)\n" ) ;
            $write( " Vbse   = %7.3f Vdse = %7.3f Vgse = %7.3f\n" ,Vbse , Vdse , Vgse ) ;
        end

        T5 = beta * ( phi_sL_DEP - phi_bL_DEP );
        T6 = exp( T5 ) ;
        T10 = T6 - 1.0 - T5 + 1e-15 ;
        Q_nL = ( phi_sL_DEP > phi_bL_DEP ) ? -cnst0 * sqrt( T10 ) : cnst0 * sqrt( T10 ) ;

        if (`WK_CO_SMOOTHCHARGE_IDD == 1 ) begin
            `Fn_SL_CP( T2 , (phi_sL_DEP - Vds_maxbL) , 0.0, DEPPS, 6 , T0 )
            T4 = exp(beta * T2) - 1.0 - beta * T2 + 1e-15 ;
            Q_nL_cur = - cnst0 * sqrt(T4) ;
        end else begin
            Q_nL_cur = Q_nL;
        end

    end // Vds > 0

    //---------------------------------------------------*
    //* Assign Pds.
    //*-----------------//
    Ps0 = phi_s0_DEP ;
    Psl = phi_sL_DEP ;
    Pds = phi_sL_DEP - phi_s0_DEP ;

    //-----------------------------------------------------------*
    //* Modified potential and Q_n0 for symmetry.
    //*-----------------//
    T1 = ( Vds - Pds ) / 2 ;
    `Fn_SymAdd( Pzadd , T1 , PZADD0*0.1 , T2 )
`ifdef REPLACE_CLIPPING_WITH_SMOOTHING //revised for continuity (Qn0)
        `Fn_SL_CP(Pzadd, Pzadd, `epsm10, `epsm10, 2, T0)
`else
        if ( Pzadd < `epsm10 ) begin
            Pzadd = `epsm10 ;
        end
`endif
    Ps0z = Ps0 + Pzadd ;

    // Q_n0_sym for Symmetry
    //`Fn_SZ( T2 , (Ps0z - Vds_maxb0) , DEPPS, T0 )
    `Fn_SL_CP( T2, (Ps0z - Vds_maxb0), 0.0, DEPPS, 6, T0)
    T4 = exp(beta * T2) - 1.0 - beta * T2 + 1e-15 ;
    Q_n0_sym = - cnst0 * sqrt(T4) ;

    //---------------------------------------------------*
    // Calc. Idd
    //*-----------------//

`ifdef REPLACE_CLIPPING_WITH_SMOOTHING
        `Fn_SZ(sum_Q_nx_cur, - (Q_nL_cur + Q_n0_cur), `C_sum_Q_nx_cur_delta, T1)
        sum_Q_nx_cur = - sum_Q_nx_cur;
`else
        sum_Q_nx_cur = (Q_nL_cur + Q_n0_cur);
        if ( - sum_Q_nx_cur < `epsm10 ) sum_Q_nx_cur = 0.0;
`endif
    Idd = - beta * sum_Q_nx_cur / 2.0 * Pds ;

    //---------- End of Idd ------------*

    Qn0 = - Q_n0_sym ;
    Lch = Leff ;

    // Vdseff //
    Vds = Vdsorg;

    //-----------------------------------------------------------*
    //* Channel Length Modulation. Lred: \Delta L
    //*-----------------//
    if ( UC_CLM2 < `epsm10 && UC_CLM3 < `epsm10  ) begin
        Lred = 0.0e0 ;
        Psdl = Psl ;
`ifdef REPLACE_CLIPPING_WITH_SMOOTHING //revised for continuity (Psdl)
            `Fn_SU_CP(Psdl, Psdl, (Ps0 + Vds - `epsm10), `epsm10, 2, T0)
`else
            if ( Psdl > Ps0 + Vds - `epsm10 ) begin
                Psdl = Ps0 + Vds - `epsm10 ;
            end
`endif
    end else begin
        //T8 = Psl - Vbs ;
        T8 = Psl - Vbsc ;
        //`Fn_SZ(T8, T8,  1e-3, T0)
        `Fn_SL_CP(T8, T8, 0.2, (-Vbsc+0.8), 1, T0)
        T9 = C_2ESIpq_Ndepm*(T8);
        Wd = sqrt(T9);
        T0 = 1.0 / Wd ;
        T1 = Qn0 * T0 ;
        T2 = UC_CLM3 * T1 ;
        T3 = UC_CLM3 * T0 ;
        T5 = UC_CLM2 * q_Ndepm + T2 ;
        T1 = 1.0 / T5 ;
        T4 = `C_ESI * T1 ;
        T1 = (1.0e0 - UC_CLM1) ;
        Psdl = UC_CLM1 * (Vds + Ps0z) + T1 * Psl ;
`ifdef REPLACE_CLIPPING_WITH_SMOOTHING //revised for continuity (Psdl and Lred)
            `Fn_SU_CP(Psdl, Psdl, (Ps0z + Vds - `epsm10), `epsm10, 2, T0)
`else
            if ( Psdl > Ps0z + Vds - `epsm10 ) begin
                Psdl = Ps0z + Vds - `epsm10 ;
            end
`endif
        T6 = Psdl - Psl ;
        T3 = beta * Qn0 ;
        T1 = 1.0 / T3 ;
        T5 = Idd * T1 ; //  Iaccum only; no contribution of Ires-based Idd
        T10 = q_Ndepm / `C_ESI ;
        T1 = 1.0e5 ;
        T2 = 1.0 / Leff ;
        T11 = (2.0 * T5 + 2.0 * T10 * T6 * T4 + T1 * T4) * T2 ;
        T7 = T11 * T4 ;
        T11 = 4.0 * (2.0 * T10 * T6 + T1) ;
        T8 = T11 * T4 * T4 ;
        T9 = sqrt (T7 * T7 + T8);
        Lred = 0.5 * (- T7 + T9) ;

        //---------------------------------------------------*
        //* Modify Lred for symmetry.
        //*-----------------//
        T1 = Lred ;
        Lred = FMDVDS * T1 ;
    end

    // CLM5 & CLM6 //
    Lred = Lred * clmmod ;

    Lch = Lch - Lred ;

    //-----------------------------------------------------------*
    //* Muun : surface universal mobility for Iacc.  (CGS unit)
    //*-----------------//
    T2 = ninv_o_esi / `C_m2cm ; // [m/F]*(1e-2) = [cm/F]*(1e-4)
    T0 = Ninvde ;
    Pdsz = sqrt(Pds * Pds + VZADD0) - sqrt(VZADD0) ;
    T4 = 1.0 + (Pdsz) * T0 ;   // Pdsz for DC symmetry

    T5 = T2 * Qn0 ;  // Note Qn0 in [C/m2]=[C/cm2]*(1e4);  [cm/F]*(1e-4)*[C/cm2]*(1e4) = [C/F]][1/cm]
    T3 = T5 / T4 ;   // [C/F][1/cm]/[1] = [V/cm]
    Eeff = T3 ;      // [V/cm]
    T8 = `Fn_Pow( Eeff , MUEPH0 ) ;
    T6 = `Fn_Pow( Eeff , muesr ) ;
    T9 = `C_QE * `C_m2cm_p2 ; //  [C]*(1e4)
    Rns = Qn0 / T9 ;  // [C/m2]/[C]/(1e4) = [1/cm2]

    T2 = UC_MUECB0 ;
    T1 = `WK_CO_MUECB* 1.0e0 / ( T2 + UC_MUECB1 * T4 * Rns / 1.0e11 )
        + `WK_CO_MUEPH* mphn0 * T8 + `WK_CO_MUESR*T6 / UC_MUESR1 ;     // [cm2/V/s][1/cm2]/[1/cm2]=[cm2/V/s]

    Muun = 1.0e0 / T1 ;

    //  Change to MKS unit //
    Muun = Muun / `C_m2cm_p2 ;  // [cm2/V/s] -> [m2/V/s]

    //-----------------------------------------------------------*
    //* Mu : mobility
    //*-----------------//
    T2 = beta * (Qn0 + `Small) * Lch ;
    T1 = 1.0e0 / T2 ;
    TY = Idd * T1 ;
    T2 = 0.2 * Vmaxe / Muun ;
    Ey = sqrt( TY * TY + T2 * T2 ) ;
    T4 = 1.0 / Ey ;
    Em = Muun * Ey ;
    T1 = Em / Vmaxe ;
    // note: bb = 2 (electron) ;1 (hole) //
    if ( 1.0e0 - `epsm10 <= BB && BB <= 1.0e0 + `epsm10 ) begin
        T2 = T1;
    end else if ( 2.0e0 - `epsm10 <= BB && BB <= 2.0e0 + `epsm10 ) begin
        T2 = T1*T1;
    end else begin
        T2 = `Fn_Pow( T1 , BB ) ;
    end
    T4 = 1.0e0 + T2 ;
    if ( 1.0e0 - `epsm10 <= BB && BB <= 1.0e0 + `epsm10 ) begin
        T5 = 1.0 / T4 ;
    end else if ( 2.0e0 - `epsm10 <= BB && BB <= 2.0e0 + `epsm10 ) begin
        T5 = 1.0 / sqrt( T4 ) ;
    end else begin
        T5 = `Fn_Pow( T4 , ( - 1.0e0 / BB ) ) ;
    end
    Mu = Muun * T5 ;
    Mu_acc = Mu ;
    Ey_acc = Ey ;

    begin : Calc_W_res_with_DD_mode
        //1D Newton specific for calculating W_res

        real dphi_sb , c_sb , Q_s0 , lp_ws , Vgp_ws , Vgp_leak ;

        Vgp_ws = 0.0 ; //protection against hidden state
        W_res_leak = 0.0 ;
        W_res = 0.0 ;
        Ws = 0.0 ;
        Q_s0 = 0.0 ;
        Vgpz    = Vgsz - Vfb + dVth - dPpg ;
        if ( `WK_CO_NEWVGPRES == 0 ) begin
            Vgp_res = Vgpz - DEPDVFBC ; // original
        end else if ( `WK_CO_NEWVGPRES == 1) begin
            Vgp_res = Vgsz - Vfb - DEPDVFBC ; // 20170902
        end else begin
            Vgp_res = Vgp - DEPDVFBC ; // 20171002
        end

        if ( abs(Tnp) <= 0 ) begin  // modified because of VAMPyRE ERROR
            Ps0_res = 0.0 ;
        end else begin

            Ps0DEP  = Ps0 ;
            depvbs  = DEPVLEAK*Vbsc ;
            Vgp_leak = (Vfb + DEPDVFBC) - 3.0 ; // Vgp_leak for W_res_leak

            for ( lp_ws = 1 ; lp_ws <= 2 ; lp_ws = lp_ws + 1 ) begin
                if ( lp_ws == 1 ) begin  // modified because of VAMPyRE ERROR
                    depvbs = DEPVLEAK*Vbsc ;
                    Ps0DEP = depvbs - 1 ;
                    Vgp_ws = Vgp_leak ;
                    Vgp_res_raw = Vgp_leak;
                end
                else begin
                    depvbs = DEPVLEAK*Vbsc - 0.1 ;
                    Ps0DEP = Ps0 ;
                    Vgp_ws = Vgp_res ;
                    Vgp_res_raw = Vgp_res;
                end

                flg_conv = 0 ;

                for ( lp_s0 = 1 ; lp_s0 <= `lp_se_max ; lp_s0 = lp_s0 + 1 ) begin

                    T1 = beta * Ps0DEP ;
                    T2 = exp(T1) ;
                    if ( Ps0DEP >= 0.0 ) begin
                        Q_s0 = - cnst0 * sqrt(T2 - 1.0 - T1 + 1e-15) ;
                        Q_s0_dPs = 0.5 * cnst0 * cnst0 / Q_s0 * (beta * T2 - beta ) ;
                    end else begin
                        T3 = exp( - beta * (Ps0DEP - depvbs) ) ;
                        T4 = exp(   beta *           depvbs  ) ;
                        Q_s0 = cnst0 * sqrt(T2 - 1.0 - T1 + cnst1 * (T3 - T4) + 1e-15) ;
                        T5 = 0.5 * cnst0 * cnst0 / Q_s0 ;
                        Q_s0_dPs = T5 * (beta * T2 - beta + cnst1 * ( - beta * T3) ) ;
                    end

                    if (flg_conv) begin
                        lp_s0 = `lp_se_max + 1 ; // exit Newton Loop
                    end else begin
                        PF1  = Cox * (Vgp_ws - Ps0DEP) + Q_s0 ;
                        PF11 = - Cox + Q_s0_dPs ;
                        dPs  = - PF1 / PF11 ;
                        if (abs(dPs) < `ps_conv2*100) begin
                            flg_conv = 1 ;
                        end else if (dPs > `dP_max) begin
                            dPs = `dP_max ;
                        end else if (dPs < - `dP_max) begin
                            dPs = - `dP_max ;
                        end

                        Ps0DEP = Ps0DEP + dPs ;

                    end // End of flg_conv=1

                end // End of Newton Loop

                if ( flg_conv == 0 ) begin
                    $write( "*** warning(HiSIM_HV(%m)): Went Over Iteration Maximum(Pres)\n" ) ;
                    $write( " Vbse   = %7.3f Vdse = %7.3f Vgse = %7.3f\n" ,Vbse , Vdse , Vgse ) ;
                end

                if ( lp_ws == 1 ) begin  // modified because of VAMPyRE ERROR
                    Ps0DEP0 = Ps0DEP ;
                end
                else begin
                    `Fn_SL_CP( Ps0DEP , Ps0DEP , Ps0DEP0 , 0.2 , 2 , T0 )
                end
                Ps0_res = Ps0DEP ; // save to Ps0_res;
                // As all sorts of charge were taken into account for
                // the solution of Poisson equation, Ps0_res does not serve right for estimation of Vdssat where mobile carriers
                // are depleted. A separate iteration loop will be setup for this purpose although it should look alike to the codes for the
                // Vdssat1d calculation.  Vgp_res and Vgp can be different by a small amount due to Vgs or Vgsz and due to dVth-dPpg.

                // calc. the pseudo Pb0DEP in FD condition
                VgpDEP_dlt = `Fn_Max(1E-6,DEPVGPSL) ;
                `Fn_SU_CP( Ps0DEP , Ps0_res , 0.0 , VgpDEP_dlt , VgpDEP_pw , T0 )  // for Wres
                Ps0DEP = - Ps0DEP ;
                dphi_sb = q_Ndepm * Tnp * Tnp / 2.0 / `C_ESI ;
                T0 = wDEPSUBSL * sqrt(2.0 * beta * dphi_sb) ;
                T1 = (exp(T0) + exp(-T0)) / 2 ; //  greater or equal to 1; positive
                if ( abs(T0) > 1e-4 ) begin
                    c_sb = ln(T1) / dphi_sb ;  // positive
                end else begin
                    // ln(cosh(T0)) = (1/2)*T0^2-(1/12)*T0^4; dphi_sb
                    //              = (1/2)*(1/beta)*(1/DEPSUBSL)^2 * T0^2; to avoid 0/0 indefinite evaluation
                    c_sb = wDEPSUBSL*wDEPSUBSL*beta*(1-`C_1o6*T0*T0);
                end
                TX = c_sb * Ps0DEP ;
                if ( TX > 500 ) begin // bypass ln(1+exp(big))
                    Pb0DEP = Ps0DEP - dphi_sb;
                end else begin
                    T0 = exp(- c_sb * dphi_sb) ;
                    if (abs(TX) > 1E-8) begin
                        `Fn_DExp(T1,TX,T3)
                        T1 = T1 * T0 ;
                        T2 = T1 - T0 ;
                    end else begin
                        T1 = (1 + TX) * T0 ;
                        T2 = TX * (1 + TX / 2) * T0 ;
                    end
                    if (abs(T2) > 1E-8) begin
                        Pb0DEP = ln(1 + T2) / c_sb ;
                    end else begin
                        Pb0DEP = T2 / c_sb ;
                    end
                end

                // callc. Ws and Wres
                T2 = Ps0DEP - Pb0DEP ;
                if (`WK_CO_UWE20171213 == 0) begin  // original implementation as of 20171212
                    Ws = ( T2 < 0 ) ? - sqrt(-C_2ESIpq_Ndepm*T2) : sqrt(C_2ESIpq_Ndepm*T2) ; // Ws
                end else begin
                    if ( T2 < 0 ) begin
                        T3 = beta * T2;
                        Ws = -sqrt((C_2ESIpq_Ndepm*beta_inv)*(exp(T3)-T3-1.0));
                    end
                    else begin
                        T3 = -beta* T2;
                        Ws =  sqrt((C_2ESIpq_Ndepm*beta_inv)*(exp(T3)-T3-1.0));
                    end
                end
                W_res = Tnp - Ws ; // equivalent to Tn - ( W_bsub0 + W_b0_new ) ;
                `Fn_SL_CP( W_res  , W_res  , 0 , 1e-16 , 2 , T0 )

                if ( lp_ws == 1 ) begin
                    W_res_leak = W_res ;
                end

            end // End of for ( lp_ws=1-2 )
            //=======
            //        // callc. Ws and Wres
            //        T2 = Ps0DEP - Pb0DEP ;
            //        Ws = ( T2 < 0 ) ? - sqrt(-C_2ESIpq_Ndepm*T2) : sqrt(C_2ESIpq_Ndepm*T2) ; // Ws
            //        W_res = Tnp - Ws ; // equivalent to Tn - ( W_bsub0 + W_b0_new ) ;
            //        `Fn_SL_CP( W_res  , W_res  , 1e-16 , 1e-16 , 2 , T0 )
            //
            //        if( lp_ws == 1 ) begin
            //           W_res_leak = W_res ;
            //        end
            //
            //      end // End of for ( lp_ws=1-2 )
            //
            //      if (`CO_WK_NEWWRESSCHEME == 1) begin // 20171003 kiku, HSMHV_depmos3_Wres_new.inc
            //       begin : W_res_new
            //        real Ws_org , Ws_dlt , Q_s0_max , Q_s0_smo ;
            //
            //        //T1 = beta * 0.05 ; // beta * Ps0DEP
            //        T1 = beta * `WK_WSDLT_PS0MAX ; // beta * Ps0DEP 20171004
            //        T2 = exp(T1) ;
            //        Q_s0_max = cnst0 * sqrt(T2 - 1.0 - T1 + 1e-15) ;
            //        //`Fn_SL_CP( Q_s0_smo  , Q_s0_res  , -Q_s0_max , Q_s0_max , 1 , T0 ) // Q_s0_res local within HSMHV_depmos3. Use this
            //        // when block W_res_new will be placed outside the block Calc_W_res_with_DD_mode.
            //        //`Fn_SL_CP( Q_s0_smo  , Q_s0  , -Q_s0_max , Q_s0_max , 1 , T0 ) // Q_s0 local within Calc_W_res_with_DD_mode.
            //        `Fn_SL_CP( Q_s0_smo  , Q_s0  , -Q_s0_max , Q_s0_max* `WK_QS0MAX_DLT , 1 , T0 ) // Q_s0 local within Calc_W_res_with_DD_mode.
            //        //`Fn_Sigmoid( T1, (Vgp_res+0.5)*10 )
            //        `Fn_Sigmoid( T1, (Vgp_res+ `WK_WSDLT_VGPRESSHIFT)*`WK_WSDLT_VGPRESMULT ) // 20171004
            //        Ws_org = Ws ;
            //        Ws_dlt = Ws_org * T1 * 0.1 ;
            //        Ws = Q_s0_smo / q_Ndepm ;
            //        `Fn_SU_CP( Ws  , (Ws*1.05)  , Ws_org ,   Ws_dlt , 2 , T0 )
            //
            //        W_res = Tnp - Ws  ;
            //        `Fn_SL_CP( W_res  , W_res  , 1e-16 , 1e-16 , 2 , T0 )
            //>>>>>>> 1.12
            //
            //       end // block: W_res_new
            //      end // if (`CO_WK_NEWWRESSCHEME == 1)

        end // else: !if( Tnp == 0 )

    end // block: Calc_W_res_with_DD_mode

    //-----------------------------------------------------------*
    //*  Vds for resistor region current.
    //*-----------------//

    if (`CO_WK_VDSATRES1VARNT == 0) begin  // 20170929
        begin :  Calc_Vdsatres_analytical // 20170929 import from hisim2 300b5
            Vds_res = Vdsorg ;
            T10 = ( Vbsc + beta_inv ) * DEPVSATR  ;
            T4 = 1.0e0 + C2_q_Ndepm_esi_Cox_inv2 * (Vgp - T10) ;
            T5 = 1.0e0 + C2_q_Ndepm_esi_Cox_inv2 ;
            `Fn_SL_CP( T4 , T4 , 0, T5 , 2 , T0 )
            T3 = sqrt(T4) ;
            T10 = Vgp + q_Ndepm_esi_Cox_inv2 * ( 1.0e0 - T3 )  ;
            `Fn_SL_CP(  Vdssat_res , T10 , UC_DEPLEAK, DEPQFRES, 2 , T0 )
        end

    end else begin
        begin :  Calc_Vdsatres_1varNT  // 20170929
            // Vgp_res can be slightly different from Vgp for acc.
            // calculate Vdssat by 1D Newton
            Vgpsat = Vgp_res ;
            T4 = 1.0e0 + C2_q_Ndepm_esi_Cox_inv2 * ( Vgpsat ) ;
            T3 = (T4 > 0) ?  sqrt(T4) : -sqrt(-T4) ;
            Vdssat_ini = Vgpsat + q_Ndepm_esi_Cox_inv2 * ( 1.0 - T3 ) ;
            phi_vsat = Vdssat_ini ;

            flg_conv = 0 ;

            for ( lp_s0 = 1 ; lp_s0 <= `lp_se_max  ; lp_s0 = lp_s0 + 1 ) begin  // {

                T1 = - beta * phi_vsat ;
                T2 = exp(T1) ;
                T4 = sqrt(2.0*q_Ndepm_esi/beta) ;
                T10 = T2 - T1 - 1 ;
                Q_sat = T4 * sqrt( T10 + 1e-15 ) ;
                if ( T1 > 0 ) Q_sat = - Q_sat ;
                T11 = 0.5 * T4 * T4 * beta / Q_sat ;
                Q_sat_dPs = T11 * ( -T2 + 1 ) ;

                if (flg_conv) begin
                    lp_s0 = `lp_se_max + 1 ; // exit Newton Loop
                end else begin
                    PF1 = -Cox * (Vgpsat - phi_vsat) + Q_sat ;
                    PF11 = Cox + Q_sat_dPs ;
                    dPs  = - PF1 / PF11 ;

                    if (abs(dPs) < `ps_conv2) begin
                        flg_conv = 1 ;
                    end else if (dPs > `dP_max) begin
                        dPs = `dP_max ;
                    end else if (dPs < - `dP_max) begin
                        dPs = - `dP_max ;
                    end

                    phi_vsat = phi_vsat + dPs ;

                end //  flg_conv == 0
            end // End of phi_vsat loop
        end // block: Calc_Vdsatres_1varNT 20170929

        //Vdssat1d = phi_vsat ;
        Ps0_res = phi_vsat; // 20170929

        Vds_res = Vdsorg ;
        `Fn_SZ( Vdssat_res , Ps0_res , DEPQFRES, T0 )
    end // else: !if(`CO_WK_VDSATRES1VARNT == 0)

    T1 = Vds_res / Vdssat_res ;
    T2 = `Fn_Pow( T1 , DEPDDLT-1.0 ) ;
    T3 = 1.0 + T2 * T1 ;
    T4 = `Fn_Pow( T3 , 1.0 / DEPDDLT-1.0 ) ;
    T6 = T4 * T3  ;

    `Fn_SU_CP( Vds_res0 , Vdsorg , UC_DEPLEAK, UC_DEPLEAK*0.5 , 2 , T0 )
    Vds_res = Vds_res / T6 + Vds_res0 ;

    // Vds_res0_sym for Symmetry
    T4 = Vds_res0 * Vds_res0 * Vds_res0 ;
    T0 = T4 + `C_leak_delta ;
    Vds_res0_sym = T4 / T0 ;

    if ( COVDSRES == -1) begin // Vdsres=Vds as in hisim2 300
        Vds_res0_sym = 0.0;
        Vds_res = Vdsorg;
    end
    else begin
        if ( COVDSRES == 2) begin // 20180429
            Vds_res = Vdsorg;
            Vds_res0 = 0.0;
            Vds_res0_sym = 0.0;

            T1 = Vgp_res_raw - UC_DEPLEAK;
            Vdssat_res= 0.5*( T1 + ln(cosh(T1)) + ln(2.0) ) + UC_DEPLEAK;
        end
        else if ( COVDSRES == 3) begin // 20180526
            Vdssat_res = ln(1+exp(Vgp_res_raw - UC_DEPLEAK)) +UC_DEPLEAK;
        end

        T1 = Vds_res / Vdssat_res ;
        T2 = `Fn_Pow( T1 , DEPDDLT-1.0 ) ;
        T3 = 1.0 + T2 * T1 ;
        T4 = `Fn_Pow( T3 , 1.0 / DEPDDLT-1.0 ) ;
        T6 = T4 * T3  ;
        Vds_res = Vds_res / T6 + Vds_res0 ;
    end // else: !if( COVDSRES == -1)

    //  resistor region universal mobility for Ires.  (CGS unit)

    Qn_res = W_res * q_Ndepm ; // (1/m^2) Used for Coulomb scat mobility for resistor

    T9 = `C_QE * `C_m2cm_p2 ;  //
    Rns = Qn_res / T9 ;        // (1/cm^2)

    // calc. Eeff,res
    // Ninvdec,hRES for high-field correction for universal mobility; DEPNINVDC,H
    // Vds_resz for DC symmetry;
    Vds_resz = sqrt(Vds_res * Vds_res + VZADD0) - sqrt(VZADD0) ;
    T4 = 1.0 + Vds_resz * NinvdecRES ;
    T5 = 1.0 + Vds_resz * NinvdehRES ;
    if ( $param_given(DEPPB0)) begin
        Eeff_res = ( DEPPB0 - phi_b0_DEP ) / (`C_m2cm *UC_DEPTHN) / T5; // (HiSIM2 3.0.0 compatible)
    end
    else begin // when DEPPB0 is not supplied.
        Eeff_res = Qn_res / `C_ESI / T5 ; // (same as HiSIM2 3.1.0 or later)
    end

    T8 = `Fn_Pow( Eeff_res, DEPMUEPH0 ); // phonon scat mobility
    T1 = `WK_CO_DEPMUE * 1.0e0 / (UC_DEPMUE0 + UC_DEPMUE1 * T4 * Rns / 1.0e10 + `Small ) + `WK_CO_DEPMUEPH * depmphn0 * T8;
    Muun = 1.0 / T1 ;
    //  Change to MKS unit //
    Muun = Muun / `C_m2cm_p2 ; // 2nd term revived.

    // for Symmetry */
    Edri = Vds_res  / (Leff+DEPRDRDL1) ;
    `Fn_Sym4( T0 , Vds_res , 0.01 )  /* Edri for Symmetry */
    Edri2 = T0 / (Leff-DEPRDRDL2) ;
    T1 = Muun * Edri2 / UC_DEPVMAX;
    T2 = `Fn_Pow(T1,DEPBB) ;
    T3 = 1.0 + T2 ;
    T4 = `Fn_Pow(T3,1.0 / DEPBB) ;
    Mu_res = Muun / T4 ;
    //  Modification of NDEPM and Qn_dep
    N_res  = UC_NDEPM * ( 1.0 + DEPCAR * Edri  * (1.0 - 1.0 / ( 1.0 + Muun * Edri  / UC_DEPVMAX ))) ;

    //-----------------------------------------------------------*
    //* Ids0: Ids_acc + Ids_res + Ires_leak .
    //*-----------------//
    T1 = W_res * `C_QE  * N_res ;
    T2 = pow( Weff / Leff , UC_DEPWLP ) * NF ;
    Ids_res   = weff_nf * T1 * Mu_res  * Edri ;
    Ires_leak = T2 * W_res_leak * DEPJLEAK * Vds_res0_sym ;

    betaWL = weff_nf * beta_inv / Lch ;
    Ids_acc =  betaWL * Idd * Mu_acc ;
    Ids0 = `WK_IACC*Ids_acc + `WK_IRES*Ids_res + `WK_ILEAK*Ires_leak ;

    // Vdseff //
    Vds = Vdsorg;

    //-----------------------------------------------------------*
    //* Adding parasitic components to the channel current.
    //*-----------------//
    if ( PTL != 0 ) begin
        T1 =  0.5 * ( Vds - Pds ) ;
        `Fn_SymAdd( T6 , T1 , 0.01 , T2 )
        T1 = 1.1 - ( phi_s0_DEP + T6 );
        `Fn_SZ( T2 , T1 , 0.05 , T0 )
        T2 = T2 + `Small ;
        T0 = beta * ptl0 ;
        T3 = Cox * T0 ;
        T0 = pow( T2 , PTP ) ;
        T9 = T3 * T0 ;
        T4 = 1.0 + Vdsz * PT2 ;
        T0 = pt40 ;
        T5 = phi_s0_DEP + T6 - Vbsz ;
        T4 = T4 + Vdsz * T0 * T5 ;
        T6 = T9 * T4 ;
        T9 = T6 ;
    end else begin
        T9 = 0.0 ;
    end
    if ( GDL != 0 ) begin
        T1 = beta * gdl0 ;
        T2 = Cox * T1 ;
        T8     = T2 * Vdsz ;
    end else begin
        T8 = 0.0 ;
    end
    if (( T9 + T8 ) > 0.0 ) begin
        Idd1 = Pds * ( T9 + T8 ) ;
        Ids0 = Ids0 + betaWL * Idd1 * Mu ;
    end
    Ids = Ids0 ;

    /* charge calculation */

    //---------------------------------------------------*
    //* Qbu : -Qb in unit area.
    //*-----------------//
    Qbu = - 0.5 * (Q_s0 - Q_n0 + Q_sL - Q_nL);
    Qiu = - 0.5 * (Q_n0 + Q_nL );
    Qdrat = 0.5;

    //---------------------------------------------------*
    //set flg_noqi & Qiu_noi
    //---------------------------------------------------*
    Qiu_noi = - 0.5 * (Q_n0 + Q_nL) ;
    Qn0 = -Q_n0 ;
    Ey = Ey_acc ;
    if ( Qn0 < `Small || Qiu < `Small ) begin
`ifdef REPLACE_CLIPPING_WITH_SMOOTHING //removed for continuity (Qn0)
`else
            Qn0 = `Small ;
`endif
        flg_noqi = 1 ;
    end

    //`include "dbgprn3.cnt"

end // HSMHV_depmos3

// ---- end `include "HSMHV_depmos3.inc" ----
                end
            endcase // case (CODEP)

        end else begin

            //-----------------------------------------------------------*
            //  normal mode
            //* Accumulation zone. (zone-A)
            //* - evaluate basic characteristics and exit from this part.
            //*-----------------//
            if ( Vgs < Vgs_fb ) begin
                flg_zone = -1 ;

                //---------------------------------------------------*
                //* Evaluation of Ps0.
                //* - Psa : Analytical solution of
                //*             Cox( Vgp - Psa ) = cnst0 * Qacc
                //*         where Qacc is the 3-degree series of(fdep)^begin1/2end.
                //*         The unknown  is transformed to Chi=beta(Ps0-Vbs).
                //* - Ps0_min : |Ps0_min| when Vbs=0.
                //*-----------------//
                // Ps0_min: approx. solution of Poisson equation at Vgs_min //
                //          ( easy to improve, if necessary  )              //
                //    Ps0_min = Eg - Pb2 ;
                //    Ps0_min_dT = Eg_dT - Pb2_dT ;
                Ps0_min = 2.0 * beta_inv * ln (-Vgs_min/fac1) ;
                TX = beta * ( Vgp - Vbscl ) ;

                T1 = 1.0 / ( beta * cnst0 ) ;
                TY = T1 * Cox ;
                Ac41 = 2.0 + 3.0 * `C_SQRT_2 * TY ;
                Ac4 = 8.0 * Ac41 * Ac41 * Ac41 ;
                T4 = ( TX - 2.0 ) ;
                T5 = 9.0 * TY * T4 ;
                Ac31 = 7.0 * `C_SQRT_2 - T5 ;
                Ac3 = Ac31 * Ac31 ;
                if ( Ac4 < Ac3*1.0e-8 ) begin
                    Ac1 = 0.5 * Ac4 / Ac31 ;
                end else begin
                    Ac2 = sqrt( Ac4 + Ac3 ) ;
                    Ac1 = -Ac31 + Ac2 ;
                end
                Acd = `Fn_Pow( Ac1 , `C_1o3 ) ;
                Acn = -4.0 * `C_SQRT_2 - 12.0 * TY + 2.0 * Acd + `C_SQRT_2 * Acd * Acd ;
                T1 = 1.0 / Acd ;
                Chi = Acn * T1 ;

                Psa = Chi * beta_inv + Vbscl ;
                T1 = Psa - Vbscl ;
                T2 = T1 / Ps0_min ;
                T3 = sqrt( 1.0 + ( T2 * T2 ) ) ;
                Ps0 = T1 / T3 + Vbscl ;

                //---------------------------------------------------*
                //* Characteristics.
                //*-----------------//
                Psl = Ps0 ;

                Pds = 0.0 ;
                T2 = ( Vgp - Ps0 ) ;
                Qbu = Cox * T2 ;
                Qiu = 0.0e0 ;
                Qdrat = 0.0e0 ;
                Lred = 0.0e0 ;
                Ids = 0.0e0 ;
                VgVt = 0.0 ;
                flg_noqi = 1 ;
                end_of_part_1 = 1 ;
            end
            if (end_of_part_1 == 0) begin

                //---------------------------------------------------*
                //* Ps0_iniA: solution of subthreshold equation assuming zone-D1/D2.
                //*-----------------//
                TX = 1.0e0 + 4.0e0 * ( beta * ( Vgp - Vbscl ) - 1.0e0 ) / ( fac1p2 * beta2 ) ;
                TX = `Fn_Max( TX , `epsm10 ) ;
                Ps0_iniA = Vgp + fac1p2 * beta * 0.5 * ( 1.0e0 - sqrt( TX ) ) ;

                if ( flg_pprv == 0 ) begin

                    //---------------------------------------------------*
                    //* Analytical initial guess.
                    //*-----------------//
                    //-------------------------------------------*
                    //* Common part.
                    //*-----------------//
                    Chi = beta * ( Ps0_iniA - Vbscl ) ;
                    if ( Chi < `znbd3 ) begin
                        //-----------------------------------*
                        //* zone-D1/D2
                        //* - Ps0_ini is the analytical solution of Qs=Qb0 with
                        //*   Qb0 being approximated to 3-degree polynomial.
                        //*-----------------//
                        TY = beta * ( Vgp - Vbscl ) ;
                        T1 = 1.0e0 / ( `cn_nc3 * beta * fac1 ) ;
                        T2 = 81.0 + 3.0 * T1 ;
                        T3 = -2916.0 - 81.0 * T1 + 27.0 * T1 * TY ;
                        T4 = 1458.0 - 81.0 * ( 54.0 + T1 ) + 27.0 * T1 * TY ;
                        T4 = T4 * T4 ;
                        T5 = `Fn_Pow( T3 + sqrt( 4 * T2 * T2 * T2 + T4 ) , `C_1o3 ) ;
                        TX = 3.0 - ( `C_2p_1o3 * T2 ) / ( 3.0 * T5 )
                        + 1 / ( 3.0 * `C_2p_1o3 ) * T5 ;
                        Ps0_iniA = TX * beta_inv + Vbscl ;
                        Ps0_ini = Ps0_iniA ;
                    end else if ( Vgs <= Vth ) begin
                        //-----------------------------------*
                        //* Weak inversion zone.
                        //*-----------------//
                        Ps0_ini = Ps0_iniA ;
                    end else begin
                        //-----------------------------------*
                        //* Strong inversion zone.
                        //* - Ps0_iniB : upper bound.
                        //*-----------------//
                        T1 = 1.0 / cnst1 / cnstCoxi ;
                        T2 = T1 * Vgp * Vgp ;
                        T3 = beta + 2.0 / Vgp ;
                        Ps0_iniB = ln ( T2 ) / T3 ;
                        `Fn_SU( Ps0_ini , Ps0_iniA, Ps0_iniB, `c_ps0ini_2, T1)
                    end
                end
                TX = Vbscl + `ps_conv / 2 ;
                if ( Ps0_ini < TX ) Ps0_ini = TX ;

                //---------------------------------------------------*
                //* Assign initial guess.
                //*-----------------//
                Ps0 = Ps0_ini ;
                Psl_lim = Ps0_iniA ;

`ifdef _AGING_
                    ftr0_qs = 0.0 ; ftr0_qs_dPs0 = 0.0 ;
                    ftrl_qs = 0.0 ; ftrl_qs_dPsl = 0.0 ;
`endif

                //---------------------------------------------------*
                //* Calculation of Ps0. (beginning of Newton loop)
                //* - Fs0 : Fs0 = 0 is the equation to be solved.
                //* - dPs0 : correction value.
                //*-----------------//
                exp_bVbs = exp( beta * Vbscl ) ;
                cfs1 = cnst1 * exp_bVbs ;
                flg_conv = 0 ;
                for ( lp_s0 = 1 ; lp_s0 <= lp_s0_max + 1 ; lp_s0 = lp_s0 + 1 ) begin
                    OP_lp_s0 = lp_s0 - 1 ;
`ifdef _AGING_
                        if ( nt0s > 0.0 ) begin
                            T1 = ( Ps0 - Vbs ) * 0.5 ;
                            T2 = beta / Nsub * nt0s ;
                            ftr0_qs      = T2 * T1 ;
                            ftr0_qs_dPs0 = T2 * 0.5 ;
                            if ( ftr0_qs < 0.0 ) begin
                                ftr0_qs = 0.0 ; ftr0_qs_dPs0 = 0.0 ;
                            end
                        end
`endif
                    Chi = beta * ( Ps0 - Vbscl ) ;
                    if ( Chi < `znbd5 ) begin
                        //-------------------------------------------*
                        //* zone-D1/D2.  (Ps0)
                        //* - Qb0 is approximated to 5-degree polynomial.
                        //*-----------------//
                        fi = Chi * Chi * Chi * ( `cn_im53 + Chi * ( `cn_im54 + Chi * `cn_im55 ) ) ;
                        fi_dChi = Chi * Chi * ( 3 * `cn_im53 + Chi * ( 4 * `cn_im54 + Chi * 5 * `cn_im55 ) ) ;
                        fs01 = cfs1 * fi * fi ;
                        fs01_dPs0 = cfs1 * beta * 2 * fi * fi_dChi ;
                        fb = Chi * ( `cn_nc51 + Chi * ( `cn_nc52 + Chi * ( `cn_nc53 + Chi * ( `cn_nc54 + Chi * `cn_nc55 ) ) ) ) ;
                        fb_dChi = `cn_nc51
                        + Chi * ( 2 * `cn_nc52
                        + Chi * ( 3 * `cn_nc53
                        + Chi * ( 4 * `cn_nc54 + Chi * 5 * `cn_nc55 ) ) ) ;
`ifdef _AGING_
                            fs02 = sqrt( fb * fb + fs01 + ftr0_qs );
                            fs02_dPs0 = ( beta * fb_dChi * 2 * fb + fs01_dPs0 + ftr0_qs_dPs0 ) / ( fs02 + fs02 ) ;
`else
                            fs02 = sqrt( fb * fb + fs01 ) ;
                            fs02_dPs0 = ( beta * fb_dChi * 2 * fb + fs01_dPs0 ) / ( fs02 + fs02 ) ;
`endif
                    end else begin
                        //-------------------------------------------*
                        //* zone-D3.  (Ps0)
                        //*-----------------//
                        if ( Chi < `large_arg ) begin // avoid exp_Chi to become extremely large //
                            exp_Chi = exp( Chi ) ;
                            fs01 = cfs1 * ( exp_Chi - 1.0e0 ) ;
                            fs01_dPs0 = cfs1 * beta * ( exp_Chi ) ;
                        end else begin
                            exp_bPs0 = exp( beta*Ps0 ) ;
                            fs01     = cnst1 * ( exp_bPs0 - exp_bVbs ) ;
                            fs01_dPs0 = cnst1 * beta * exp_bPs0 ;
                        end
`ifdef _AGING_
                            fs02 = sqrt( Chi - 1.0 + fs01 + ftr0_qs ) ;
                            fs02_dPs0 = ( beta + fs01_dPs0  + ftr0_qs_dPs0 ) / ( fs02 + fs02 ) ;
`else
                            fs02 = sqrt( Chi - 1.0 + fs01 ) ;
                            fs02_dPs0 = ( beta + fs01_dPs0 ) / ( fs02 + fs02 ) ;
`endif
                    end // end of if( Chi ... ) else block //
                    Fs0 = Vgp - Ps0 - fac1 * fs02 ;
                    Fs0_dPs0 = - 1.0e0 - fac1 * fs02_dPs0 ;
                    if ( flg_conv == 1 ) flg_brk1 = 1 ; // break
                    if (flg_brk1 == 0) begin
                        dPs0 = - Fs0 / Fs0_dPs0 ;

                        //-------------------------------------------*
                        //* Update Ps0 .
                        //* - clamped to Vbscl if Ps0 < Vbscl .
                        //*-----------------//
                        dPlim = 0.5*`dP_max*(1.0 + `Fn_Max(1.0e0,abs(Ps0))) ;
                        if ( abs( dPs0 ) > dPlim ) dPs0 = dPlim * `Fn_Sgn( dPs0 ) ;
                        Ps0 = Ps0 + dPs0 ;

                        //-------------------------------------------*
                        //* Check convergence.
                        //* NOTE: This condition may be too rigid.
                        //*-----------------//
                        if ( abs( dPs0 ) <= `ps_conv && abs( Fs0 ) <= `gs_conv ) begin
                            flg_conv = 1 ;
                        end

                    end if(flg_brk1)  lp_s0 = lp_s0_max + 1 ;
                    flg_brk1 = 0; // end of flg_brk1
                end // end of Ps0 Newton loop //

                // Reduce loop count to exclude the sweep for derivative calculation //
                lp_s0 = lp_s0 - 1 ;

                //-------------------------------------------*
                //* Procedure for diverged case.
                //*-----------------//
                if ( flg_conv == 0 ) begin
                    $write( "*** warning(HiSIM_HV(%m)): Went Over Iteration Maximum(Ps0)\n" ) ;
                    $write( " Vbse   = %7.3f Vdse = %7.3f Vgse = %7.3f\n" ,Vbse , Vdse , Vgse ) ;
                end

                if ( Chi < `znbd5 ) begin
                    //-------------------------------------------*
                    //* zone-D1/D2. (Ps0)
                    //* Xi0 := fdep0^2 = fb * fb  [D1,D2]
                    //*-----------------//
                    Xi0 = fb * fb + `epsm10 ;
                    Xi0p12 = fb + `epsm10 ;
                    Xi0p32 = fb * fb * fb + `epsm10 ;
                end else begin
                    //-------------------------------------------*
                    //* zone-D3. (Ps0)
                    //*-----------------//
                    flg_zone = 3 ;
                    flg_noqi = 0 ;

                    //-----------------------------------*
                    //* Xi0 := fdep0^2 = Chi - 1 = beta * ( Ps0 - Vbscl ) - 1 [D3]
                    //*-----------------//
                    Xi0 = Chi - 1.0e0 ;
                    Xi0p12 = sqrt( Xi0 ) ;
                    Xi0p32 = Xi0 * Xi0p12 ;
                end // end of if( Chi  ... ) block //

                //-----------------------------------------------------------*
                //* Qb0 : Qb at source side.
                //* Qn0 : Qi at source side.
                //*-----------------//
`ifdef _AGING_
                    Qt0 = (ftr0_qs <= 0) ? 0.0 : cnst0 * sqrt( ftr0_qs ) ;
`endif
                Qb0 = cnst0 * Xi0p12 ;
                T1 = 1.0 / ( fs02 + Xi0p12 ) ;
                Qn0 = cnst0 * fs01 * T1 + `Small ;

                //-----------------------------------------------------------*
                //* zone-D1 and D2
                //*-----------------//
                if ( Chi < `znbd5 ) begin
                    if ( Chi < `znbd3 ) begin
                        //-------------------------------------------*
                        //* zone-D1. (Ps0)
                        //*-----------------//
                        flg_zone = 1 ;
                        flg_noqi = 1 ; //* !! to be revisited !! *//
                        Qiu = Qn0 ;
                        Qbu = Qb0 ;
                        Qdrat = 0.5 ;
                        Lred = 0.0e0 ;

                    end else begin
                        //-------------------------------------------*
                        //* zone-D2 (Ps0)
                        //*-----------------//
                        flg_zone = 2 ;
                        flg_noqi = 0 ;
                        //-----------------------------------------------------------*
                        //* FD2 : connecting function for zone-D2.
                        //* - Qiu, Qbu, Qdrat and Lred should be interpolated later.
                        //*-----------------//
                        T1 = 1.0 / ( `znbd5 - `znbd3 ) ;
                        TX = T1 * ( Chi - `znbd3 ) ;
                        FD2 = TX * TX * TX * ( 10.0 + TX * ( -15.0 + TX * 6.0 ) ) ;

                    end // end of zone-D2 //
                end

                //---------------------------------------------------*
                //* VgVt : Vgp - Vth_qi. ( Vth_qi is Vth for Qi evaluation. )
                //*-----------------//
                VgVt = Qn0 * Cox_inv ;

                //-----------------------------------------------------------*
                //* Start point of Psl(= Ps0 + Pds) calculation.(label)
                //*-----------------//
                // start_of_Psl:

                // Vdseff(begin) //
                Vdsorg = Vds ;
                T2 = qnsub_esi / ( Cox * Cox ) ;
                T0 = Vgp - beta_inv - Vbsz ;
                T1 = 1.0e0 + 2.0e0 / T2 * T0 ;
                `Fn_SZ( T9, T1, 1e-3, TX )
                T9 = T9 + `Small ;
                T3 = sqrt( T9 ) ;
                T10 = Vgp + T2 * ( 1.0e0 - T3 ) ;
                `Fn_SZ( T10 , T10 , 0.01 , T0 )
                T10 = T10 + `epsm10 ;
                T1 = Vds / T10 ;
                T2 = `Fn_Pow( T1 , DDLTe - 1.0 ) ;
                T3 = 1.0 + T2 * T1 ;
                T4 = `Fn_Pow( T3 , 1.0 / DDLTe - 1.0 ) ;
                T6 = T4 * T3 ;
                Vdseff = Vds / T6 ;
                Vds = Vdseff ;
                // Vdseff(end) //
                OP_Vdseff = Vdseff ;

                exp_bVbsVds = exp( beta * ( Vbscl - Vds ) ) ;

                //---------------------------------------------------*
                //* Skip Psl calculation when Vds is very Small.
                //*-----------------//
                if ( Vds <  0.0 ) begin
                    Pds = 0.0 ;
                    Psl = Ps0 ;
                    //       flg_conv = 1 ;
                    start_of_loopl = 1 ;
                end
                if (start_of_loopl == 0) begin

                    //-----------------------------------------------------------*
                    //* Initial guess for Pds( = Psl - Ps0 ).
                    //*-----------------//
                    if ( flg_pprv == 0 ) begin
                        //---------------------------------------------------*
                        //* Analytical initial guess.
                        //*-----------------//
                        Pds_max = `Fn_Max( Psl_lim - Ps0 , 0.0e0 ) ;
                        if ( (1.0e0 + `c_pslini_1) * Pds_max > `c_pslini_2 ) begin // conventional case:
                            `Fn_SU( Pds_ini , Vds, (1.0e0 + `c_pslini_1) * Pds_max, `c_pslini_2, T1 )
                        end else begin // bugfix for glitches in Ids under very low bias condition:
                            Pds_ini = (1.0e0 + `c_pslini_1) * Pds_max ;
                        end
                        Pds_ini = `Fn_Min( Pds_ini , Pds_max ) ;
                    end
                    if ( Pds_ini < 0.0 ) Pds_ini = 0.0 ;
                    else if ( Pds_ini > Vds ) Pds_ini = Vds ;
                    OP_Pds_ini  = Pds_ini ;

                    //---------------------------------------------------*
                    //* Assign initial guess.
                    //*-----------------//
                    Pds = Pds_ini ;
                    Psl = Ps0 + Pds ;

                    //---------------------------------------------------*
                    //* Calculation of Psl by solving Poisson eqn.
                    //* (beginning of Newton loop)
                    //* - Fsl : Fsl = 0 is the equation to be solved.
                    //* - dPsl : correction value.
                    //*-----------------//
                    flg_conv = 0 ;

                    //---------------------------------------------------*
                    //* start of Psl calculation. (label)
                    //*-----------------//
                end if(start_of_loopl)  start_of_loopl = 0; // end of start_of_loopl
                // start_of_loopl:
                for ( lp_sl = 1 ; lp_sl <= `lp_sl_max + 1 ; lp_sl = lp_sl + 1 ) begin
                    OP_lp_sl = lp_sl - 1 ;
`ifdef _AGING_
                        if ( ntls > 0.0 ) begin
                            T1 = ( Psl - Vbs ) * 0.5 ;
                            T2 = beta / Nsub * ntls ;
                            ftrl_qs      = T2 * T1 ;
                            ftrl_qs_dPsl = T2 * 0.5 ;
                            if ( ftrl_qs < 0.0 ) begin
                                ftrl_qs = 0.0 ; ftrl_qs_dPsl = 0.0 ;
                            end
                        end
`endif

                    Chi = beta * ( Psl - Vbscl ) ;
                    if ( Chi  < `znbd5 ) begin
                        //-------------------------------------------*
                        //* zone-D2.  (Psl)
                        //* - Qb0 is approximated to 5-degree polynomial.
                        //*-----------------//
                        fi = Chi * Chi * Chi * ( `cn_im53 + Chi * ( `cn_im54 + Chi * `cn_im55 ) ) ;
                        fi_dChi = Chi * Chi * ( 3 * `cn_im53 + Chi * ( 4 * `cn_im54 + Chi * 5 * `cn_im55 ) ) ;
                        cfs1 = cnst1 * exp_bVbsVds ;
                        fsl1 = cfs1 * fi * fi ;
                        fsl1_dPsl = cfs1 * beta * 2 * fi * fi_dChi ;
                        fb = Chi * ( `cn_nc51 + Chi * ( `cn_nc52 + Chi * ( `cn_nc53 + Chi * ( `cn_nc54 + Chi * `cn_nc55 ) ) ) ) ;
                        fb_dChi = `cn_nc51
                        + Chi * ( 2 * `cn_nc52
                        + Chi * ( 3 * `cn_nc53
                        + Chi * ( 4 * `cn_nc54 + Chi * 5 * `cn_nc55 ) ) ) ;
`ifdef _AGING_
                            fsl2 = sqrt( fb * fb + fsl1 + ftrl_qs ) ;
                            fsl2_dPsl = ( beta * fb_dChi * 2 * fb + fsl1_dPsl + ftrl_qs_dPsl ) / ( fsl2 + fsl2 ) ;
`else
                            fsl2 = sqrt( fb * fb + fsl1 ) ;
                            fsl2_dPsl = ( beta * fb_dChi * 2 * fb + fsl1_dPsl ) / ( fsl2 + fsl2 ) ;
`endif
                    end else begin
                        //-------------------------------------------*
                        //* zone-D3.  (Psl)
                        //*-----------------//
                        Rho = beta * ( Psl - Vds ) ;
                        exp_Rho = exp( Rho ) ;
                        fsl1 = cnst1 * ( exp_Rho - exp_bVbsVds ) ;
                        fsl1_dPsl = cnst1 * beta * ( exp_Rho ) ;
                        Xil = Chi - 1.0e0 ;
`ifdef _AGING_
                            fsl2 = sqrt( Xil + fsl1  + ftrl_qs ) ;
                            fsl2_dPsl = ( beta + fsl1_dPsl + ftrl_qs_dPsl ) / ( fsl2 + fsl2 ) ;
`else
                            fsl2 = sqrt( Xil + fsl1 ) ;
                            fsl2_dPsl = ( beta + fsl1_dPsl ) / ( fsl2 + fsl2 ) ;
`endif
                    end
                    Fsl = Vgp - Psl - fac1 * fsl2 ;
                    Fsl_dPsl = - 1.0e0 - fac1 * fsl2_dPsl ;
                    if ( flg_conv == 1 ) flg_brk2 = 1 ; // break
                    if (flg_brk2 == 0) begin
                        dPsl = - Fsl / Fsl_dPsl ;

                        //-------------------------------------------*
                        //* Update Psl .
                        //* - clamped to Vbscl if Psl < Vbscl .
                        //*-----------------//
                        dPlim = 0.5*`dP_max*(1.0 + `Fn_Max(1.0e0,abs(Psl))) ;
                        if ( abs( dPsl ) > dPlim ) dPsl = dPlim * `Fn_Sgn( dPsl ) ;
                        Psl = Psl + dPsl ;

                        //-------------------------------------------*
                        //* Check convergence.
                        //* NOTE: This condition may be too rigid.
                        //*-----------------//
                        if ( abs( dPsl ) <= `ps_conv && abs( Fsl ) <= `gs_conv ) begin
                            flg_conv = 1 ;
                        end
                    end if(flg_brk2)  lp_sl = `lp_sl_max + 1 ;
                    flg_brk2 = 0; // end of flg_brk2
                end // end of Psl Newton loop //

                // Reduce loop count to exclude derivative calculation sweep //
                lp_sl = lp_sl - 1 ;

                //-------------------------------------------*
                //* Procedure for diverged case.
                //*-----------------//
                if ( flg_conv == 0 ) begin
                    $write( "*** warning(HiSIM_HV(%m)): Went Over Iteration Maximum(Psl)\n" ) ;
                    $write( " Vbse   = %7.3f Vdse = %7.3f Vgse = %7.3f\n" ,Vbse , Vdse , Vgse ) ;
                end

                if ( Chi < `znbd5 ) begin
                    //-------------------------------------------*
                    //* zone-D1/D2. (Psl)
                    //*-----------------//
                    Xil = fb * fb + `epsm10 ;
                    Xilp12 = fb + `epsm10 ;
                    Xilp32 = fb * fb * fb + `epsm10 ;
                end else begin
                    //-------------------------------------------*
                    //* zone-D3. (Psl)
                    //*-----------------//
                    Xil = Chi - 1.0e0 ;
                    Xilp12 = sqrt( Xil ) ;
                    Xilp32 = Xil * Xilp12 ;
                end

                //---------------------------------------------------*
                //* Assign Pds.
                //*-----------------//
                Pds = Psl - Ps0; // Linearized patch for |Vdsi| < `ps_conv is canceled due to derivative problem.

                // Vdseff //
                Vds = Vdsorg;

                //-----------------------------------------------------------*
                //* Evaluate Idd.
                //* - Eta : substantial variable of QB'/Pds and Idd/Pds.
                //* - note: Eta   = 4 * GAMMA_{hisim_0}
                //*-----------------//
                T1 = beta / Xi0 ;
                Eta = T1 * Pds ;

                // ( Eta + 1 )^n //
                Eta1 = Eta + 1.0e0 ;
                Eta1p12 = sqrt( Eta1 ) ;
                Eta1p32 = Eta1p12 * Eta1 ;
                Eta1p52 = Eta1p32 * Eta1 ;

                // 1 / ( ( Eta + 1 )^n + 1 ) //
                Zeta12 = 1.0e0 / ( Eta1p12 + 1.0e0 ) ;
                Zeta32 = 1.0e0 / ( Eta1p32 + 1.0e0 ) ;
                Zeta52 = 1.0e0 / ( Eta1p52 + 1.0e0 ) ;

                //---------------------------------------------------*
                //* F00 := PS00/Pds(n=1/2)
                //*-----------------//
                F00 = Zeta12 / Xi0p12 ;

                //---------------------------------------------------*
                //* F10 := PS10/Pds(n=3/2)
                //*-----------------//
                T1 = 3.0e0 + Eta * ( 3.0e0 + Eta ) ;
                F10 = `C_2o3 * Xi0p12 * Zeta32 * T1 ;

                //---------------------------------------------------*
                //* F30 := PS30/Pds(n=5/2)
                //*-----------------//
                T1 = 5e0 + Eta * ( 10e0 + Eta * ( 10e0 + Eta * ( 5e0 + Eta ) ) ) ;
                F30 = 4e0 / ( 15e0 * beta ) * Xi0p32 * Zeta52 * T1 ;

                //---------------------------------------------------*
                //* F11 := PS11/Pds.
                //*-----------------//
                F11 = Ps0 * F10 + `C_2o3 * beta_inv * Xilp32 - F30 ;

                //---------------------------------------------------*
                //* Fdd := Idd/Pds.
                //*-----------------//
                T1 = Vgp + beta_inv - 0.5e0 * ( 2.0e0 * Ps0 + Pds ) ;
                T2 = - F10 + F00 ;
                T3 = beta * Cox ;
                T4 = beta * cnst0 ;
                Fdd = T3 * T1 + T4 * T2 ;

                //---------------------------------------------------*
                //*  Idd:
                //*-----------------//
                Idd = Pds * Fdd ;
                //-----------------------------------------------------------*
                //* Skip CLM and integrated charges if zone==D1
                //*-----------------//
                if ( flg_zone == 1 ) begin
                    start_of_mobility = 1 ;
                end
                if (start_of_mobility == 0) begin

                    //-----------------------------------------------------------*
                    //* Channel Length Modulation. Lred: \Delta L
                    //*-----------------//
                    if ( UC_CLM2 < `epsm10 && UC_CLM3 < `epsm10 ) begin
                        Lred = 0.0e0 ;
                        Psdl = Psl ;
`ifdef REPLACE_CLIPPING_WITH_SMOOTHING //revised for continuity (Psdl)
                            `Fn_SU_CP(Psdl, Psdl, (Ps0 + Vds - `epsm10), `epsm10, 2, T0)
`else
                            if ( Psdl > Ps0 + Vds - `epsm10 ) begin
                                Psdl = Ps0 + Vds - `epsm10 ;
                            end
`endif
                    end else begin
                        T1 = wdpl ;
                        T8 = sqrt (Psl - Vbscl) ;
                        Wd = T1 * T8 ;
                        T9 = 0.5 * T1 / T8 ;
                        T0 = 1.0 / Wd ;
                        T1 = Qn0 * T0 ;
                        T2 = UC_CLM3 * T1 ;
                        T3 = UC_CLM3 * T0 ;
                        T5 = UC_CLM2 * q_Nsub + T2 ;
                        T1 = 1.0 / T5 ;
                        T4 = `C_ESI * T1 ;
                        T1 = (1.0e0 - UC_CLM1) ;
                        Psdl = UC_CLM1 * (Vds + Ps0) + T1 * Psl ;
`ifdef REPLACE_CLIPPING_WITH_SMOOTHING //revised for continuity (Psdl and Lred)
                            `Fn_SU_CP(Psdl, Psdl, (Ps0 + Vds - `epsm10), `epsm10, 2, T0)
`else
                            if ( Psdl > Ps0 + Vds - `epsm10 ) begin
                                Psdl = Ps0 + Vds - `epsm10 ;
                            end
`endif
                        T6 = Psdl - Psl ;
                        T3 = beta * Qn0 ;
                        T1 = 1.0 / T3 ;
                        T5 = ((Pds + `epsm10) * Fdd) * T1 ; //local protection of Pds
                        T2 = T5 * beta ;
                        T10 = q_Nsub / `C_ESI ;
                        T1 = 1.0e5 ;
                        T2 = 1.0 / Leff ;
                        T11 = (2.0 * T5 + 2.0 * T10 * T6 * T4 + T1 * T4) * T2 ;
                        T3 = T2 * T4 ;
                        T7 = T11 * T4 ;
                        T11 = 4.0 * (2.0 * T10 * T6 + T1) ;
                        T1 = 8.0 * T10 * T4 * T4 ;
                        T2 = 2.0 * T11 * T4 ;
                        T8 = T11 * T4 * T4 ;
                        T9 = sqrt (T7 * T7 + T8);
                        Lred = 0.5 * (- T7 + T9) ;
                        //---------------------------------------------------*
                        //* Modify Lred for symmetry.
                        //*-----------------//
                        T1 = Lred ;
                        Lred = FMDVDS * T1 ;
                    end

                    // CLM5 & CLM6 //
                    Lred = Lred * clmmod ;

                    //---------------------------------------------------*
                    //* Qbu : -Qb in unit area.
                    //*-----------------//
                    T1 = Vgp + beta_inv ;
                    T2 = T1 * F10 - F11 ;

                    Qbnm = cnst0 * ( cnst0 * ( 1.5e0 - ( Xi0 + 1.0e0 ) - 0.5e0 * beta * Pds )
                    + Cox * T2 ) ;
                    T1 = beta ;
                    Qbu = T1 * Qbnm / Fdd ;

                    //---------------------------------------------------*
                    //* preparation for Qi and Qd.
                    //* - DtPds: Delta * Pds ;
                    //* - Achi: (1+Delta) * Pds ;
                    //*-----------------//
                    T1 = 2.0e0 * fac1 ;
                    DtPds = T1 * ( F10 - Xi0p12 ) ;
                    T2 = 2.0 * ( F10 - Xi0p12 ) ;
                    Achi = Pds + DtPds ;

                    //-----------------------------------------------------------*
                    //* Alpha : parameter to evaluate charges.
                    //* - Achi: (1+Delta) * Pds ;
                    //* - clamped to 0 if Alpha < 0.
                    //*-----------------//
                    T1 = 1.0 / VgVt ;
                    T2 = Achi * T1 ;
                    T3 = 1.0e0 - T2 ;
                    TX = 1.0 - T3 ;
                    `Fn_CP( TY , TX , 1.0 , 4 , T4 )
                    Alpha = 1.0 - TY ;

                    //-----------------------------------------------------------*
                    //* Qiu : -Qi in unit area.
                    //*-----------------//
                    Qinm = 1.0e0 + Alpha * ( 1.0e0 + Alpha ) ;
`ifdef REPLACE_CLIPPING_WITH_SMOOTHING //revised for continuity (Qiu and Qdrat)
                        `Fn_SL_CP(Qidn, (1.0e0 + Alpha), `epsm10, `epsm10, 2, T0)
`else
                        T1 = 1.0e0 + Alpha + Alpha ;
                        Qidn = `Fn_Max( 1.0e0 + Alpha , `epsm10 ) ;
`endif
                    T1 = `C_2o3 * VgVt * Qinm / Qidn ;
                    Qiu = T1 * Cox ;

                    //-----------------------------------------------------------*
                    //* Qdrat : Qd/Qi
                    //*-----------------//
                    Qdnm = 0.5e0 + Alpha ;
                    Qddn = Qidn * Qinm ;
                    Quot = 0.4e0 * Qdnm  / Qddn ;
                    Qdrat = 0.6e0 - Quot ;
                    if ( Qdrat > 0.5e0 ) begin
                        Qdrat = 0.5e0 ;
                    end

                    //-----------------------------------------------------------*
                    //* Interpolate charges and CLM for zone-D2.
                    //*-----------------//
                    if ( flg_zone == 2 ) begin
                        T1 = Qbu ;
                        Qbu = FD2 * Qbu + ( 1.0 - FD2 ) * Qb0 ;
                        if ( Qbu < 0.0 ) begin
                            Qbu = 0.0 ;
                        end
                        T1 = Qiu ;
                        Qiu = FD2 * Qiu + ( 1.0 - FD2 ) * Qn0 ;
                        if ( Qiu < 0.0 ) begin
                            Qiu = 0.0 ;
                        end
                        T1 = Qdrat ;
                        Qdrat = FD2 * Qdrat + ( 1.0 - FD2 ) * 0.5e0 ;

                        // note: Lred=0 in zone-D1 //
                        T1 = Lred ;
                        Lred = FD2 * Lred ;

                    end // end of flg_zone==2 if-block //

                end if(start_of_mobility)  start_of_mobility = 0; // end of start_of_mobility
                // start_of_mobility:
                Lch = Leff - Lred ;
                if ( Lch < 1.0e-9 ) begin
                    $write("*** warning(HiSIM_HV(%m)): actual channel length is too Small. (Lch=%e[m])\n" , Lch ) ;
                    $write("                    CLM5 and/or CLM6 might be too large.\n" ) ;
                    Lch = 1.0e-9 ;
                end

                //-----------------------------------------------------------*
                //* Muun : universal mobility.  (CGS unit)
                //*-----------------//

                T1 = ndep_o_esi / `C_m2cm  ;
                T2 = ninv_o_esi / `C_m2cm ;
                T0 = Ninvde ;
                T4 = 1.0 + ( Psl - Ps0 ) * T0 ;
`ifdef _AGING_
                    T3 = TRAPN / `C_ESI / `C_m2cm ;
                    T11 = TRAPP * TRAPDVTH / Tox0 ;
                    T5 = T1 * Qbu + T2 * Qiu + T3 * Qt0 + T11 ;
`else
                    T5 = T1 * Qbu + T2 * Qiu ;
`endif
                T3 = T5 / T4 ;
                Eeff = T3 * ( 1.0 + MUEEFB * Vbsz ) ;
                T5 = `Fn_Pow( Eeff , MUEPH0 - 1.0e0 ) ;
                T8 = T5 * Eeff ;
                T7 = `Fn_Pow( Eeff , muesr - 1.0e0 ) ;
                T6 = T7 * Eeff ;
                T9 = `C_QE * `C_m2cm_p2 ;
                Rns = Qiu / T9 ;
                T1 = 1.0e0 / ( UC_MUECB0 + UC_MUECB1 * Rns / 1.0e11 )
                + mphn0 * T8 + T6 / UC_MUESR1 ;

                Muun = 1.0e0 / T1 ;

                //  Change to MKS unit //
                Muun = Muun / `C_m2cm_p2 ;

                //-----------------------------------------------------------*
                //* Mu : mobility
                //*-----------------//
                T2 = beta * (Qn0 + `Small) * Lch ;
                T1 = 1.0e0 / T2 ;
                T3 = T1 * T1 ;
                T4 =  - beta * T3 ;
                T5 = T4 * Lch ;
                T6 = T4 * (Qn0 + `Small) ;
                TY = ((Pds + `epsm10) * Fdd) * T1 ; //local protection of Pds
                T2 = 0.2 * Vmaxe /  Muun ;
                T3 = - T2 / Muun ;
                Ey = sqrt( TY * TY + T2 * T2 ) ;
                T4 = 1.0 / Ey ;
                Em = Muun * Ey ;
                T1  = Em / Vmaxe ;
                // note: bb = 2 (electron) ;1 (hole) //
                if ( 1.0e0 - `epsm10 <= BB && BB <= 1.0e0 + `epsm10 ) begin
                    T3 = 1.0e0 ;
                end else if ( 2.0e0 - `epsm10 <= BB && BB <= 2.0e0 + `epsm10 ) begin
                    T3 = T1 ;
                end else begin
                    T3 = `Fn_Pow( T1 , BB - 1.0e0 ) ;
                end
                T2 = T1 * T3 ;
                T4 = 1.0e0 + T2 ;
                if ( 1.0e0 - `epsm10 <= BB && BB <= 1.0e0 + `epsm10 ) begin
                    T5 = 1.0 / T4 ;
                end else if ( 2.0e0 - `epsm10 <= BB && BB <= 2.0e0 + `epsm10 ) begin
                    T5 = 1.0 / sqrt( T4 ) ;
                end else begin
                    T6 = `Fn_Pow( T4 , ( - 1.0e0 / BB - 1.0e0 ) ) ;
                    T5 = T4 * T6 ;
                end
                Mu = Muun * T5 ;

                // end_of_mobility:

                //-----------------------------------------------------------*
                //* Ids: channel current.
                //*-----------------//
                betaWL = weff_nf * beta_inv / Lch ;
                T1 = - betaWL / Lch ;
                Ids0 = betaWL * Idd * Mu ;
                //-----------------------------------------------------------*
                //* Adding parasitic components to the channel current.
                //*-----------------//
                if ( PTL != 0 ) begin
                    T1 =  0.5 * ( Vds - Pds ) ;
                    `Fn_SymAdd( T6 , T1 , 0.01 , T2 )
                    T2 = T2 * 0.5 ;
                    T1 = 1.1 - ( Ps0 + T6 );
                    `Fn_SZ( T2 , T1 , 0.05 , T0 )
                    T2 = T2 + `Small ;
                    T0 = beta * ptl0 ;
                    T3 = Cox * T0 ;
                    T0 = pow( T2 , PTP ) ;
                    T9 = T3 * T0 ;
                    T4 = 1.0 + Vdsz * PT2 ;
                    T0 = pt40 ;
                    T5 = Ps0 + T6 - Vbsz ;
                    T4 = T4 + Vdsz * T0 * T5 ;
                    T6 = T9     * T4 ;
                    T9 = T6 ;
                end else begin
                    T9 = 0.0 ;
                end
                if ( GDL != 0 ) begin
                    T1 = beta * gdl0 ;
                    T2 = Cox * T1 ;
                    T8 = T2 * Vdsz ;
                end else begin
                    T8 = 0.0 ;
                end
                if (( T9 + T8 ) > 0.0 ) begin
                    Idd1 = Pds * ( T9 + T8 ) ;
                    //       Ids0 = Ids0 + betaWL * Idd1 * Mu ;
                    IdsPT0 = betaWL * Idd1 * Mu ;
                    Ids0   = Ids0 + IdsPT0 ;
                end else begin
                    IdsPT0 = 0.0 ;
                end
                //HV1{
                if ( flg_rsrd == 2 || flg_rsrd == 3 ) begin
                    if ( RD20 > 0.0 ) begin
                        T4 = Rd23e ;
                        T1 = UC_RD24 * ( Vgse - RD25 ) ;
                        `Fn_SL( T2 , T1 , T4 , `delta_rd , T0 )
                        T3 = T4 * ( RD20 + 1.0 ) ;
                        `Fn_SU( T7 , T2 , T3 , `delta_rd , T0 )
                    end else begin
                        T7 = Rd23e;
                    end

                    if (Vdse >= 0.0) begin
                        Vdse_eff = Vdse ;
                    end else begin
                        Vdse_eff = 0.0 ;
                    end

                    // smoothing of Ra for Vdse_eff close to zero //
                    // ... smoothing parameter is Ra_N            //
                    if (Vdse_eff < `Ra_N * `Small2) begin
                        Ra_alpha = pow( `Ra_N+1.0 , RD21-1.0 )
                        * (`Ra_N+1.0-0.5*RD21*`Ra_N)
                        * pow( `Small2,RD21 );
                        Ra_beta = 0.5*RD21
                        * pow( `Ra_N+1.0 , RD21-1.0 ) / `Ra_N
                        * pow( `Small2, RD21-2.0 );
                        T1 = Ra_alpha + Ra_beta*Vdse_eff*Vdse_eff;
                    end else begin
                        T1 = pow( Vdse_eff + `Small2 , RD21 ) ;
                    end
                    T9 = pow( Vdse_eff + `Small2 , RD22D ) ;
                    Ra = ( T7 * T1 + Vbse * UC_RD22 * T9 ) / weff_nf ;
                    T0 = Ra * Ids0 ;
                    T1 = Vds + `Small2 ;
                    T2 = 1.0 / T1 ;
                    T3 = 1.0 + T0 * T2 ;
                    T4 = 1.0 / T3 ;
                    Ids = Ids0 * T4 ;
                end else begin
                    Ids = Ids0 ;
                    Ra = 0.0 ;
                end //}HV1

                //-----------------------------------------------------------*
                //* STI
                //*-----------------//
                if ( COISTI != 0 ) begin
                    //---------------------------------------------------*
                    //* dVthSCSTI : Short-channel effect induced by Vds(STI).
                    //*-----------------//
                    T1 = `C_ESI * Cox_inv ;
                    T2 = wdpl ;
                    T3 =  lgatesm - PARL2 ;
                    T4 = 1.0 / (T3 * T3) ;
                    T5 = 2.0 * (VBI - Pb20b) * T1 * T2 * T4 ;
                    dVth0 = T5 * sqrt_Pbsum ;
                    T6 = T5 * 0.5 / sqrt_Pbsum ;
                    T7 = 2.0 * (VBI - Pb20b) * `C_ESI * T2 * T4 * sqrt_Pbsum ;
                    T8 = - 2.0 * T1 * T2 * T4 * sqrt_Pbsum ;
                    T4 = UC_SCSTI1 ;
                    T6 = UC_SCSTI2 ;
                    T1  = T4 + T6 * Vdsz ;
                    dVthSCSTI = dVth0 * T1 ;
                    T1 = UC_VTHSTI - VDSTI * Vds ;
                    Vgssti = Vgsz - Vfb + T1 + dVthSCSTI ;

                    costi3 = costi0_p2 * Cox_inv * Cox_inv ;
                    costi4 = costi3 * beta * 0.5 ;
                    costi5 = costi4 * beta * 2.0 ;
                    T11 = beta * 0.25 ;
                    T10 = beta_inv - costi3 * T11 + Vfb - UC_VTHSTI - dVthSCSTI + `Small ;
                    T1 = Vgsz - T10 - `psisti_dlt ;
                    T0 = `Fn_Sgn(T10) ;
                    T2 = sqrt (T1 * T1 + T0 * 4.0 * T10 * `psisti_dlt) ;
                    T3 = T10 + 0.5 * (T1 + T2) - Vfb + UC_VTHSTI + dVthSCSTI - Vbsz ;
                    T4 = beta * T3 - 1.0 ;
                    T5 = 4.0 / costi5 ;
                    T1 = 1.0 + T4 * T5 ;
                    T6 = beta * T5 ;
                    T7 = T4 * T5 ;
                    `Fn_SZ( T1 , T1, 1.0e-2, T2)
                    T1 = T1 + `Small ;
                    costi6 = sqrt(T1) ;
                    T0 = costi4 * (1.0 - costi6) ;
                    Psasti = Vgssti + T0 ;
                    T0 = 1.0 / (beta + 2.0 / (Vgssti + `Small)) ;
                    Psbsti = ln (1.0 / costi1 / costi3 * (Vgssti * Vgssti)) * T0 ;
                    Psab = Psbsti - Psasti - `sti2_dlt ;
                    T0 = sqrt (Psab * Psab + 4.0 * `sti2_dlt * Psbsti) ;
                    Psti = Psbsti - 0.5 * (Psab + T0) ;
                    T0 = costi1 * exp (beta * Psti) ;
                    T1 = beta * (Psti - Vbsz) - 1.0 + T0 ;
                    `Fn_SZ( T1 , T1, 1.0e-2, T0)
                    T1 = T1 + `Small ;

                    sq1sti = sqrt (T1);
                    T1 = beta * (Psti - Vbsz) - 1.0;
                    `Fn_SZ( T1 , T1, 1.0e-2, T0)
                    T1 = T1 + `Small ;

                    sq2sti = sqrt (T1);
                    T2 = 0.5 / sq2sti ;
                    Qn0sti = costi0 * (sq1sti - sq2sti) ;

                    // T1: Vdsatsti //
                    T1 = Psasti - Psti ;
                    `Fn_SZ( T1 , T1 , 1.0e-1 , T2 )
                    T1 = T1 + `Small ;

                    TX = Vds / T1 ;
                    T2 = 1.0 / ( T1 * T1 ) ;
                    `Fn_CP( TY , TX , 1.0 , 4 , T2 )
                    costi7 = 2.0 * UC_WSTI * NF * beta_inv ;
                    T1 = Lch ;
                    Idssti = costi7 * Mu * Qn0sti * TY / T1 ;
                    Ids = Ids + Idssti ;

                end

                //----------------------------------------------------------*
                //* induced gate noise. ( Part 1/3 )
                //*----------------------//
                if ( COIGN != 0 && COTHRML != 0 && UC_CODEP == 0) begin
                    kusai00 = VgVt * VgVt ;
                    kusaidd = 2.0e0 * beta_inv * Cox_inv * Idd ;
                    kusaiL = kusai00 - kusaidd ;
                    `Fn_SZ( kusai00 , kusai00 , 1.0e-3 , T0 )
                    `Fn_SZ( kusaiL , kusaiL , 1.0e-3 , T0 )

                    kusai00L = kusai00 - kusaiL ;
                    if ( Qn0 < `epsm10 || kusai00L < `epsm10 ) flg_ign = 0 ;
                    else flg_ign = 1 ;
                end

                //-----------------------------------------------------------*
                //* End of PART-1. (label)
                //*-----------------//
            end if(end_of_part_1)  end_of_part_1 = 0; // end of end_of_part_1
            // end_of_part_1:

            //-----------------------------------------------------------*
            //* Implicit quantities related to Alpha.
            //*-----------------//
            if ( flg_noqi == 0 && VgVt > `VgVt_Small ) begin
                Delta = fac1 * beta / ( 2 * Xi0p12 ) ;
                Pslsat = VgVt / ( 1.0 + Delta ) + Ps0 ;
            end else begin
                Pslsat = 0.0 ;
            end
            Vdsat = Pslsat - Pb2 ;
            if ( Vdsat < 0.0 ) begin
                Vdsat = 0.0 ;
            end

            //-----------------------------------------------------------*
            //* Adding punchthrough current.
            //*-----------------//
            Idsorg = Ids ;
            IdsPT1 = 0.0 ;
            if (COPT > 0 && MUPT > 0.0) begin
// ---- begin `include "HSMHV_eval_newPT.inc" ----
/***********************************************************************

 HiSIM (Hiroshima University STARC IGFET Model)
 Copyright (C) 2000-2016 Hiroshima University and STARC
 Copyright (C) 2016-2023 Hiroshima University
 HiSIM_HV (High-Voltage Model)
 Copyright (C) 2007-2016 Hiroshima University and STARC
 Copyright (C) 2016-2023 Hiroshima University

 MODEL NAME : HiSIM_HV
 ( VERSION : 2  SUBVERSION : 5  REVISION : 1 )
 Model Parameter 'VERSION' : 2.51
 FILE : HSMHV_eval_newPT.inc

 Date : 2023.02.09

 released by Hiroshima University

***********************************************************************/

begin : HSMHV_eval_newPT
    // Use this module when COPT > 0 and MUPT > 0.0.
`define C_PHI__MINIMUM (1e-7)

    real Ec , T1w , wk ;
    real Ps0 , t_SUB , Vgp , wk_Vth ;       // protect external Ps0 and beta
    real conpt00 , conpt0 ;
    real sq1npt  , Qn0npt ;

    real wfactor; // accounts for diminished influence exerted by gate; in aid of depletion width
    real wQbu, Wdep, delta;    // depletion width in association with Ps0//
    real T5abs;
    real Vpositive;
    real Qbu;    // localizes Qbu not to affect AC characteristics (Nov/29/2021) //

    t_SUB = 10e-6 ;
    Vgp   = Vgs - Vfb + dVth - dPpg - VFBPT ;
    wk_Vth = Vth + VFBPT ;

    `Fn_SZtemp(Vpositive, (Vbipn - Vbscl), `deepPT_dlt)
    Ec = sqrt( 2 * `C_QE * Vpositive/`C_ESI* Nsub * UC_NJUNC/(Nsub+UC_NJUNC)); //
    // Potential build-up (lowering potential barrier seen from source) due to Vds.
    wk = Ec * Leff;                        // [V] positive
    dphi_vds = -0.25 * wk*wk / (Vds + wk); // [V] negative

    if ( PS0PT > 0.0 ) begin //constant Ps0:
        Ps0 = PS0PT;
    end else begin //original Ps0:
// ---- begin `include "HSMHV_analyticalPs0.inc" ----
/***********************************************************************

 HiSIM (Hiroshima University STARC IGFET Model)
 Copyright (C) 2000-2016 Hiroshima University and STARC
 Copyright (C) 2016-2023 Hiroshima University
 HiSIM_HV (High-Voltage Model)
 Copyright (C) 2007-2016 Hiroshima University and STARC
 Copyright (C) 2016-2023 Hiroshima University

 MODEL NAME : HiSIM_HV
 ( VERSION : 2  SUBVERSION : 5  REVISION : 1 )
 Model Parameter 'VERSION' : 2.51
 FILE : HSMHV_analyticalPs0.inc

 Date : 2023.02.09

 released by Hiroshima University

***********************************************************************/

begin : HSMHV_analyticalPs0

    real Vbscl , Vth ; // different from outside

    Vbscl = dphi_vds ;
    Vth   = wk_Vth ;

    //-----------------------------------------------------------*
    //* Initial guess for Ps0. (start)
    //*-----------------//
    //---------------------------------------------------*
    //* Ps0_iniA: solution of subthreshold equation assuming zone-D1/D2.
    //*-----------------//
    TX = 1.0e0 + 4.0e0 * ( beta * ( Vgp - Vbscl ) - 1.0e0 ) / ( fac1p2 * beta2 ) ;
    TX = `Fn_Max( TX , `epsm10 ) ;
    Ps0_iniA = Vgp + fac1p2 * beta * 0.5 * ( 1.0e0 - sqrt( TX ) ) ;

    // use analytical value in subthreshold region. //
    //       if( Vgs <( Vfb + Vth ) * 0.5 ) begin
    //           flg_pprv = 0 ;
    //       end

    //       if( 1 ) begin

    //---------------------------------------------------*
    //* Analytical initial guess.
    //*-----------------//
    //-------------------------------------------*
    //* Common part.
    //*-----------------//
    Chi = beta * ( Ps0_iniA - Vbscl ) ;
    if ( Chi < `znbd3 ) begin
        //-----------------------------------*
        //* zone-D1/D2
        //* - Ps0_ini is the analytical solution of Qs=Qb0 with
        //*   Qb0 being approximated to 3-degree polynomial.
        //*-----------------//
        TY = beta * ( Vgp - Vbscl ) ;
        T1 = 1.0e0 / ( `cn_nc3 * beta * fac1 ) ;
        T2 = 81.0 + 3.0 * T1 ;
        T3 = -2916.0 - 81.0 * T1 + 27.0 * T1 * TY ;
        T4 = 1458.0 - 81.0 * ( 54.0 + T1 ) + 27.0 * T1 * TY ;
        T4 = T4 * T4 ;
        T5 = `Fn_Pow( T3 + sqrt( 4 * T2 * T2 * T2 + T4 ) , `C_1o3 ) ;
        TX = 3.0 - ( `C_2p_1o3 * T2 ) / ( 3.0 * T5 )
              + 1 / ( 3.0 * `C_2p_1o3 ) * T5 ;
        Ps0_iniA = TX * beta_inv + Vbscl ;
        Ps0_ini = Ps0_iniA ;
    end else if ( Vgs <= Vth ) begin
        //-----------------------------------*
        //* Accumulation & Weak inversion zone.
        //*-----------------//
        Ps0_ini = Ps0_iniA ;
    end else begin
        //-----------------------------------*
        //* Strong inversion zone.
        //* - Ps0_iniB : upper bound.
        //*-----------------//
        T1 = 1.0 / cnst1 / cnstCoxi ;
        T2 = T1 * Vgp * Vgp ;
        T3 = beta + 2.0 / Vgp ;
        Ps0_iniB = ln ( T2 ) / T3 + PSLIMPT ;
        `Fn_SUtemp( Ps0_ini , Ps0_iniA, Ps0_iniB, `c_ps0ini_2)
    end

    TX = Vbscl + `ps_conv / 2 ;
    if ( Ps0_ini < TX ) Ps0_ini = TX ;

    //---------------------------------------------------*
    //* Assign initial guess.
    //*-----------------//
    Ps0 = Ps0_ini ;

    // Initial guess for Ps0. (end) //

end // block: HSMHV_analyticalPs0
// ---- end `include "HSMHV_analyticalPs0.inc" ----
        if (COPSPT==1) begin
            Ps0_ini = Ps0 ;
// ---- begin `include "HSMHV_iterativePs0.inc" ----
/***********************************************************************

 HiSIM (Hiroshima University STARC IGFET Model)
 Copyright (C) 2000-2016 Hiroshima University and STARC
 Copyright (C) 2016-2023 Hiroshima University
 HiSIM_HV (High-Voltage Model)
 Copyright (C) 2007-2016 Hiroshima University and STARC
 Copyright (C) 2016-2023 Hiroshima University

 MODEL NAME : HiSIM_HV
 ( VERSION : 2  SUBVERSION : 5  REVISION : 1 )
 Model Parameter 'VERSION' : 2.51
 FILE : HSMHV_iterativePs0.inc

 Date : 2023.02.09

 released by Hiroshima University

***********************************************************************/

begin : HSM2_iterativePs0

    real Vbscl , phi_s0 ;
    real dphi_sb , c_sb , phi_0 , Chib , phi_b , phi_b_dPss , fb_dPss ;

    //-----------------------------------------------------------*
    //Solve Poisson's equation
    //----------------//
    Vbscl = dphi_vds ;

    //-----------------------------------------------------------*
    //* Accumulation zone. (zone-A)
    //* - evaluate basic characteristics and exit from this part.
    //*-----------------//
    Vgs_fb = Vfb - dVth + dPpg + Vbscl + VFBPT ;
    if ( Vgs < Vgs_fb ) begin
        flg_zone = -1 ;

        //---------------------------------------------------*
        //* Evaluation of Ps0.
        //* - Psa : Analytical solution of
        //*             Cox( Vgp - Psa ) = cnst0 * Qacc
        //*         where Qacc is the 3-degree series of(fdep)^{1/2}.
        //*         The unknown  is transformed to Chi=beta(Ps0-Vbs).
        //* - Ps0_min : |Ps0_min| when Vbs=0.
        //*-----------------//
        // Ps0_min: approx. solution of Poisson equation at Vgs_min //
        //          ( easy to improve, if necessary  )              //
        //    Ps0_min = Eg - Pb2 ;
        Ps0_min = 2.0 * beta_inv * ln (-Vgs_min/fac1) ;
        TX = beta * ( Vgp - Vbscl ) ;
        T1 = 1.0 / ( beta * cnst0 ) ;
        TY = T1 * Cox ;
        Ac41 = 2.0 + 3.0 * `C_SQRT_2 * TY ;
        Ac4 = 8.0 * Ac41 * Ac41 * Ac41 ;
        T4 = ( TX - 2.0 ) ;
        T5 = 9.0 * TY * T4 ;
        Ac31 = 7.0 * `C_SQRT_2 - T5 ;
        Ac3 = Ac31 * Ac31 ;
        if ( Ac4 < Ac3 * 1.0e-8 ) begin
            Ac1 = -7.0 * `C_SQRT_2 + Ac31 + 0.5 * Ac4 / Ac31 + T5 ;
        end else begin
            Ac2 = sqrt( Ac4 + Ac3 ) ;
            Ac1 = -7.0 * `C_SQRT_2 + Ac2 + T5 ;
        end
        Acd = `Fn_Pow( Ac1 , `C_1o3 ) ;
        Acn = -4.0 * `C_SQRT_2 - 12.0 * TY + 2.0 * Acd + `C_SQRT_2 * Acd * Acd ;
        T1 = 1.0 / Acd ;
        Chi = Acn * T1 ;
        Psa = Chi * beta_inv + Vbscl ;
        T1 = Psa - Vbscl ;
        T2 = T1 / Ps0_min ;
        T3 = sqrt( 1.0 + ( T2 * T2 ) ) ;
        Ps0 = T1 / T3 + Vbscl ;

    end else begin //if( Vgs < Vgs_fb ) begin

        //---------------------------------------------------*
        //* Calculation of Ps0. (beginning of Newton loop)
        //* - Fs0 : Fs0 = 0 is the equation to be solved.
        //* - dPs0 : correction value.
        //*-----------------//
        exp_bVbsVds = exp( beta * ( Vbscl - PSLIMPT ) ) ;
        flg_conv = 0 ;

        phi_s0 = Ps0_ini ;

        dphi_sb = q_Nsub * t_SUB * t_SUB / 2.0 / `C_ESI ;
        T0 = sqrt(2.0 * beta * dphi_sb) ;
        T1 = (lexp(T0) + lexp(-T0)) / 2 ;
        c_sb = ln(T1) / dphi_sb ;

        for ( lp_s0 = 1 ; lp_s0 <= lp_s0_max + 1 ; lp_s0 = lp_s0 + 1 ) begin
            phi_0 = phi_s0 - Vbscl ;
            Chi = beta * phi_0 ;

            TY = c_sb * (phi_0 - dphi_sb) ;
            if ( TY < `large_arg ) begin
                T1 = exp(TY) ;
                T0 = exp(- c_sb * dphi_sb) ;
                T2 = T1 - T0 ;
                phi_b = ln(1 + T2) / c_sb ;
                phi_b_dPss = T1 / (1 + T2) ;
            end else begin
                phi_b = phi_0 - dphi_sb ;
                phi_b_dPss = 1 ;
            end
            Chib = beta * phi_b ;

            if (abs(Chi) < 1E-16) begin
                T0 = sqrt((1 - phi_b_dPss * phi_b_dPss) / 2) ;
                fb = Chi * T0 ;
                fb_dPss = beta * T0 ;
                if (Chi < 0) begin
                    fb = -fb ;
                    fb_dPss = -fb_dPss ;
                end
            end else if (abs(Chi) < 5E-3) begin

                T0 = Chi * Chi / 2 * (1 - Chi / 3 * (1 - Chi / 4 * (1 - Chi / 5))) ;
                T1 = Chi * (1 - Chi / 2 * (1 - Chi / 3 * (1 - Chi / 4))) ;
                T2 = Chib * Chib / 2 * (1 - Chib / 3 * (1 - Chib / 4 * (1 - Chib / 5))) ;
                T3 = Chib * (1 - Chib / 2 * (1 - Chib / 3 * (1 - Chib / 4))) ;
                fb = sqrt(T0 - T2) ;
                fb_dPss = beta * 0.5 * (T1 - phi_b_dPss * T3) / fb ;
            end else begin
                //-------------------------------------------*
                //* zone-D3.  (phi_s0)
                //*-----------------//

                T0 = exp(-Chi) ;
                T1 = exp(-Chib) ;
                fb = sqrt(Chi - Chib + (T0 - T1)) ;
                fb_dPss = beta * 0.5 * (1 - T0 - phi_b_dPss * (1 - T1)) / fb ;
            end // check nest level. ok. //if (abs(Chi) < 1E-8) begin

            if (flg_conv == 1 && Chi < 0.0) begin
                flg_zone = -1 ;
            end

            if (Chi < 0) begin
                fs02 = -fb ;
                fs02_dPs0 = -fb_dPss ;
            end else if (Chi < 1E-7) begin
                fs02 = fb ;
                fs02_dPs0 = fb_dPss ;
            end else begin
                Rho = beta * ( phi_s0 - PSLIMPT ) ;
                exp_Rho = exp( Rho ) ;
                fs01 = cnst1 * ( exp_Rho - exp_bVbsVds * (Chi + 1) ) ;
                fs01_dPs0 = cnst1 * beta * ( exp_Rho - exp_bVbsVds ) ;
                fs02 = sqrt(fb * fb + fs01) ;
                fs02_dPs0 = 0.5 * (2 * fb_dPss * fb + fs01_dPs0) / fs02 ;
            end

            // Revised Fs0 //
            Fs0 = - Vgp + phi_s0 + fac1 * fs02 ;
            Fs0_dPs0 = 1.0 + fac1 * fs02_dPs0 ;
            if ( flg_conv == 1 ) begin
                lp_s0 = lp_s0_max+1 ; // break
            end else begin
                dPs0 = - Fs0 / Fs0_dPs0 ;

                //-------------------------------------------*
                //* Update Ps0 .
                //* - clamped to Vbscl if Ps0 < Vbscl .
                //*-----------------//
                dPlim = 0.5*`dP_max*(1.0 + `Fn_Max(1.0e0,abs(phi_s0))) ;
                if ( abs( dPs0 ) > dPlim ) dPs0 = dPlim * `Fn_Sgn( dPs0 ) ;
                phi_s0 = phi_s0 + dPs0 ;

                //-------------------------------------------*
                //* Check convergence.
                //* NOTE: This condition may be too rigid.
                //*-----------------//
                if ( abs( dPs0 ) <= `ps_conv && abs( Fs0 ) <= `gs_conv ) begin
                    flg_conv = 1 ;
                end

            end
        end // end of phi_s0 Newton loop //

        Ps0 = phi_s0 ;

    end // end of if( Vgs < Vgs_fb )

end // HSMHV_iterativePs0
// ---- end `include "HSMHV_iterativePs0.inc" ----
        end
    end

    // From Ps0 here, depletion width will be estimated.
    T5 = -beta *(Ps0 - dphi_vds);
    T5abs = abs(T5);
    T6 = exp(T5);
    T7= T6 - 1.0 - T5;
    if (T5 > `C_PHI__MINIMUM) begin
        Qbu = -cnst0*sqrt(T7); // sign inverted; accumulation side
    end else if (T5abs >`C_PHI__MINIMUM)  begin
        Qbu =  cnst0*sqrt(T7); // sign inverted; depletion, inversion side
    end else begin // avoid loss of accuracy
        Qbu = -T5 * `C_1oSQRT2 * sqrt(1.0+ T5abs*`C_1o3*(1.0+0.25*T5abs));
    end
    `Fn_SZtemp(wQbu, Qbu, 1e-6)
    Wdep = wQbu / (`C_QE * Nsub) ;
    T1 = Wdep - XJPT ;
    delta = Wdep*0.01;
    `Fn_SZtemp(T2, T1, delta)  // protection against negative T1 ( i.e. Wdep < XJPT)
    wfactor = T2/Wdep*T2/Wdep; // area ratio between small and large triangles

    phim = (Ps0 - dphi_vds) * wfactor + dphi_vds; // measured from source
    TY = exp(beta*(phim-(Vbipn-Vbscl))) * ( 1 - exp(-beta*Vds) );

    // calculate NPTA based on STI model
    conpt00 = sqrt (2.0 * `C_QE * UC_NJUNC * `C_ESI );
    conpt0 = conpt00 * sqrt(beta_inv) ;
    T1w = beta * (phim - dphi_vds) ;
    `Fn_SL_CP( T1 , T1w , 0 , 0.2*beta , 1 , T0 )
    sq1npt = sqrt (T1 + `epsm10);
    Qn0npt = conpt0 * sq1npt ;
    WK_JNPT_A = 2.0 * beta_inv / Leff * Qn0npt * MUPT ;

    IdsPT1 = WK_JNPT_A * weff_nf * TY ;    // thermoionic emission-like
    Ids    = Idsorg + IdsPT1;

end // HSMHV_eval_newPT
// ---- end `include "HSMHV_eval_newPT.inc" ----
            end //
            Ids    = Idsorg + IdsPT1 ;
            IdsPT  = IdsPT0 + IdsPT1 ;

            // Qiu for noise calc.
            Qiu_noi = Qiu ;

        end // else: !if( UC_CODEP != 0 )

        //----------------------------------------------------------*
        //* Evaluate integrated charges in unit [C].
        //*----------------------//

        T1 = - weffcv_nf * Leff ;
        Qb = T1 * Qbu ;
        Qi = T1 * Qiu ;
        Qd = Qi * Qdrat ;

        // Qiu for noise calc.
        Qi_noi = T1*Qiu_noi ;

        //-----------------------------------------------------------*
        //* Modified potential for symmetry.
        //*-----------------//
        T1 =  ( Vds - Pds ) / 2 ;
        `Fn_SymAdd( Pzadd , T1 , PZADD0 , T2 )
`ifdef REPLACE_CLIPPING_WITH_SMOOTHING //revised for continuity (Isub and Igate)
            `Fn_SL_CP(Pzadd, Pzadd, `epsm10, `epsm10, 2, T0)
`else
            if ( Pzadd  < `epsm10 ) begin
                Pzadd = `epsm10 ;
            end
`endif
        Ps0z = Ps0 + Pzadd ;

        //-----------------------------------------------------------*
        //* Channel leakage current.
        //*-----------------//
        Ids = Ids + Weff/Leff * GDSLEAK * Vds ;

        //++++++++++++++++++++++++++++++++++++++++++++++++++++++++++++
        //* PART-2: Substrate / gate / leak currents
        //*++++++++++++++++++++++++++++++++++++++++++++++++++++++++++++//

        //-----------------------------------------------------------*
        //* Isub : substrate current induced by impact ionization.
        //*-----------------//
        if ( COISUB == 0 ) begin //{
            // Accumulation zone or nonconductive case, in which Ids==0. //
            Isub = 0.0e0 ;  wk_ii=0.0; // wk_ii stows impact ionization coeff.
        end else begin //{
            //-------------------------------------------*
            //* Conductive case.
            //*-----------------//
            if ( UC_SUB1 > 0.0e0 && UC_VMAX > 0.0e0 ) begin //{
                T1 = vg2const * Vgp ;
                T3 = qnsub_esi / (Cox0 * Cox0) ;
                T4 = 2.0 / qnsub_esi * (Cox0 * Cox0) ;
                T5 = T1 - beta_inv - xvbs * Vbsz ;
                T6 = 1.0 + T4 * T5 ;
                T7 = 2.0 * ( 1.0 + T4 ) ;
                `Fn_SL_CP( T6 , T6 , 1e-6 , T7 , 4 , T0 )
                T6 = sqrt( T6 ) ;
                Psislsat = T1 + T3 * ( 1.0 - T6 ) ;
                T2 = Lgate / (xgate + Lgate) ;
                Psisubsat = UC_SVDS * Vdsz + Ps0z - T2 * Psislsat ;
`ifdef _AGING__
                    $write(" UC_SVDS %g Vdsz %g Ps0z %g Psislsat %g T2 %g \n", UC_SVDS , Vdsz , Ps0z , Psislsat , T2 );
`endif
                `Fn_SZ( Psisubsat , Psisubsat, 1.0e-3, T9 )
                Psisubsat = Psisubsat + `Small ;
                xsubtmp = 1.0 + UC_SUBTMP * (TTEMP-KTNOM) ;
                xsubtmp = ( xsubtmp <= 1.0e-3 ) ? 1.0e-3  : xsubtmp ;
                T5 = xsub1 / xsubtmp ;
                T6 = xsub2 * xsubtmp ;
                T2 = exp( - T6 / Psisubsat ) ;
                Isub = T5 * Psisubsat * Ids * T2 ;
                wk_ii = T5 * Psisubsat * T2; // 20180413
            end else begin //{
                Isub = 0.0e0 ;
            end // end of if( UC_SUB1 ... ) else block. //}

`ifdef _AGING__
                $write(" Isub %g T5 %g Psisubsat %g Ids %g T2 %g \n",Isub , T5 , Psisubsat , Ids , T2 );
`endif

            //---------------------------------------------------*
            //* Impact-Ionization Current in the Drift Region
            //*-----------------//
            if ( UC_SUBLD1 != 0.0 ) begin  // modified because of VAMPyRE ERROR
                T0 = Vddp ;
                `Fn_SZ( T0, T0, 1e-6, T1 )
                T1 = sqrt( VgVt + `Small  ) ;
                T3 = 1.0 / ( 2.0 * T1 ) ;
                T4 = T0 - XPVDTH * ( 1.0 + XPVDTHG * Vgs ) ;
                `Fn_SZ( T4, T4, 1.0e-2, T9 )
                T4 = T4 + `Small ;
                T10 = UC_XPDV * UC_XLDLD * exp( - 1.0e0 / T4 ) ;
                T11 = T10 * ( 1.0 + 1.0 / T4 ) ;
                T3 = T4 * T10 ;
                T0 = T0 - T3 ;
                `Fn_SZ( T0, T0, 1.0e-2 , T9 )
                T0 = T0 + `Small;

                T4 = 1.0 / ( T0 * T1 ) ;
                T7 = Ldrift0 * MKS_SUBLD2 ;
                T2 = exp( - T7 * T4 );
                T6 = T7 * T2 * T4 * T4 ;
                IsubLD = UC_SUBLD1 * Ids * T0 * T2 ;

            end
        end

`ifdef _AGING_
            // ---------------------------------------------------//
            // * stress simulation
// ---- begin `include "HSMHV_eval_aging.inc" ----
/***********************************************************************

 HiSIM (Hiroshima University STARC IGFET Model)
 Copyright (C) 2000-2016 Hiroshima University and STARC
 Copyright (C) 2016-2023 Hiroshima University
 HiSIM_HV (High-Voltage Model)
 Copyright (C) 2007-2016 Hiroshima University and STARC
 Copyright (C) 2016-2023 Hiroshima University

 MODEL NAME : HiSIM_HV
  ( VERSION : 2  SUBVERSION : 5  REVISION : 1 )
 Model Parameter 'VERSION' : 2.51
 FILE : HSMHV_eval_aging.inc

 Date : 2023.02.09

 released by Hiroshima University

***********************************************************************/
//
////////////////////////////////////////////////////////////////
//
//
//
//
//Licensed under the Educational Community License, Version 2.0
//(the "License"); you may not use this file except in
//compliance with the License.
//
//You may obtain a copy of the License at:
//
//      http://opensource.org/licenses/ECL-2.0
//
//Unless required by applicable law or agreed to in writing,
//software distributed under the License is distributed on an
//"AS IS" BASIS, WITHOUT WARRANTIES OR CONDITIONS OF ANY KIND,
//either express or implied. See the License for the specific
//language governing permissions and limitations under the
//License.
//
//
//The HiSIM_HV standard has been supported by the members of
//Silicon Integration Initiative's Compact Model Coalition. A
//link to the most recent version of this standard can be found
//at:
//
//http://www.si2.org/cmc
//
////////////////////////////////////////////////////////////////
//

begin : HSMHV_eval_aging

   real gc1deg0 , e1deg0 ;
   real gc_time1 , gc_time2 , gc_time , e_time1 , e_time2 , Isub_fac ;
`ifdef _AGING_DEBUG_
   real NtK1 ;
`endif

// Macro definition
`define C2p72_GCTIME1     2.72/TRAPGCTIME1
`define C2p72_GCTIME1_dlt 2.72/TRAPGCTIME1*1e-3
`define C2p72_ESTIME1     2.72/TRAPESTIME1
`define C2p72_ESTIME1_dlt 2.72/TRAPESTIME1*1e-3
`define C2p72_DTIME1      2.72/TRAPDTIME1
`define C2p72_DTIME1_dlt  2.72/TRAPDTIME1*1e-3
`define IsubT_min         2.72
`define IsubpW_min        1e-6

`define Fn_calcGC1ES1(gc1deg,e1deg,isub)  begin \
    T2 = isub / Weff ; \
    `Fn_Sigmoid( Isub_fac , (T2-`IsubpW_min)/`IsubpW_min*15 ) \
    `Fn_SLtemp( T2 , T2 , `C2p72_GCTIME1 , `C2p72_GCTIME1_dlt )  \
    T3 = T2  * TRAPGCTIME1 ;  \
    `Fn_SLtemp( T4 , (T2 * DEGTIME) , `IsubT_min , 1e-3 )  \
    `Fn_SLtemp( T5 , (T2 * TRAPGCTIME2) , `IsubT_min , 1e-3 )  \
    gc_time  = ln(T4) ; \
    gc_time1 = ln(T3) ; \
    gc_time2 = ln(T5) ; \
    T8 = (gc_time - gc_time2)/gc_time1 ; \
    T5 = - 0.5 * T8 * T8 ; \
    `Fn_DExp( T6 , T5 , T0 )   \
    gc1deg = gc1deg0 + MKS_GC1MAX / gc_time1 * T6 * Isub_fac ; \
    T2 = isub / Weff ; \
    `Fn_SLtemp( T2 , T2 , `C2p72_ESTIME1 , `C2p72_ESTIME1_dlt )  \
    T3 = T2  * TRAPESTIME1 ;  \
    `Fn_SLtemp( T5 , (T2 * TRAPESTIME2) , `IsubT_min , 1e-3 )  \
    e_time1 = ln(T3) ; \
    e_time2 = ln(T5) ; \
    T8 = (gc_time - e_time2)/e_time1 ; \
    T5 = - 0.5 * T8 * T8 ; \
    `Fn_DExp( T6 , T5 , T0 )   \
    e1deg = e1deg0 + TRAPES1MAX / e_time1 * T6 * Isub_fac ; \
    `Fn_SU( e1deg, e1deg, 1.0, 1e-2, T0 ) \
 end

`define Fn_calcGC1ES1_drift(DVddp ,ids) begin \
    T2 = ids / Weff ; \
    `Fn_SLtemp( T2 , T2 , `C2p72_DTIME1 , `C2p72_DTIME1_dlt )  \
    T3 = T2  * TRAPDTIME1 ;  \
    `Fn_SLtemp( T4 , (T2 * DEGTIME) , `IsubT_min , 1e-3 )  \
    `Fn_SLtemp( T5 , (T2 * TRAPDTIME2) , `IsubT_min , 1e-3 )  \
    gc_time  = ln(T4) ; \
    gc_time1 = ln(T3) ; \
    gc_time2 = ln(T5) ; \
    T8 = (gc_time - gc_time2)/gc_time1 ; \
    T5 = - 0.5 * T8 * T8 ; \
    `Fn_DExp( T6 , T5, T0 )   \
    DVddp = TRAPD1MAX / gc_time1 * T6 ; \
 end

   // Initilization variables
   gc1deg0   = TRAPGC1 / `C_cm2m_p3 ;
   e1deg0    = TRAPES1 ;
   abstime   = ($abstime - `pretime) + `Small ;
   Isub_trap = 0.0 ;

   if( CODEG == 1 && TRAPGC1MAX > 0 ) begin

     if( CODEGSTEP == 0 ) begin // DC simulation
       // DC simulation with Isub
       Isub_trap = Isub ;
       Ids_trap  = Ids ;
     end else begin
       // transient simulation with idt( Isuba )
       Isub_trap = V(idtag1) / abstime ;  // idt( Isuba  );
       Ids_trap  = V(idtag2) / abstime ;  // idt( Ids );
     end

     //-----------------------------------------------------------*
     //* Calculation of trap density gc1, e1 and DVddp
     //*-----------------//
     `Fn_calcGC1ES1(gc1,e1,Isub_trap)
     `Fn_calcGC1ES1_drift(DVddp, Ids_trap)

      if ( TRAPA > 0 && ($abstime > pretime0 || CODEGSTEP==0) ) begin
         if( TRAPBTI > 0.0 ) begin
           tcycle = (CODEGSTEP == 1) ? V(idtag3) / abstime : 1 ;
           ontime = abstime * tcycle ;
           Vgsonave = (CODEGSTEP == 1 && ontime > 0 ) ? V(idtag4) / ontime : Vgs ;
           ts_bti = tcycle * DEGTIME ;
           exp_time = 1.0 - lexp( -ts_bti / TRAPBTI ) ;
         end else begin
           exp_time = 1.0 ;
         end
//       Eox = ( Vgp - Pb2 ) / TOX ;
         Vgpon = Vgsonave - Vfb ; // Vfb = VFBC + dVth_bti ; calc. in main module
         Eox = ( Vgpon - Pb2 ) / TOX ;
         dVth_bti = TRAPA * lexp( TRAPB * Eox ) * exp_time ;
`ifdef _AGING_DEBUG_
  $write(" %M abstime %g ts_bti %g tcycle %g exp_time %g dVth_bti %g TRAPA %g TRAPB %g Eox %g T1 %g \n",
  abstime , ts_bti , tcycle , exp_time , dVth_bti , TRAPA , TRAPB , Eox , T1 );
`endif
      end else begin
         dVth_bti = 0.0 ;
      end

`ifdef _AGING_DEBUG_
       // check the convergency of Ntrap
       `Fn_calcNKT(NtK1,gc1,e1)
       T1 = (NtK1 <= 0 ) ? 0.0 : abs(NtK1 - NtK10) /NtK1 * 100 ;
       $write("%M Isub = %g Isub_trap = %g gc1 %g e1 %g NtK10 %g NtK1 %g Err: %g \n",
       Isub , Isub_trap, gc1, e1 , NtK10, NtK1,T1 );
       $write("%m abstime = %g DVddp = %g <Ids> = %g Ids = %g Vgse = %g Vdse = %g\n",
       abstime , DVddp, Ids_trap , Ids , Vgse , Vdse) ;
`endif

   end // (CODEG == 1 )

end // HSMHV_eval_aging.inc

// ---- end `include "HSMHV_eval_aging.inc" ----
            //*-----------------//

            // restore Ps0 , Vtraplx
            Ps0_prv = Ps0 ;                      // in conjunction with aging
            Vtraplx_prv = Vdseff + Ps0 - Psl ;   // in conjunction with aging

`endif

        //---------------------------------------------------*
        //* Breakdown currents (Ibreake,Ibreakhe,Ibreakse)
        //*-----------------//
        // Hard Breakdown Current specified by user
        if ( COHBD == 0 ) begin
            Ibreakhe = 0.0 ;
        end else begin
            // calc. Hard Breakdown Voltage
            if ( COHBD * (Vgse - HBDB) < 0 ) begin
                HBdv = HBDCeff ;
            end else begin
                HBdv = HBDA * pow(Vgse - HBDB,2) + HBDCeff ;
            end
            Ibreakhe = HBDF * lexp( beta * ( Vdse - HBdv ) ) ;
        end

        // Total Breakdown Current
        if ( Ibreakhe > 0 ) begin
            `Fn_SU_CP( T2 , Ibreakhe , 1.0e5 , 5e4, 1 , T0 )
            Ibreake = Mfactor * weff_nf * T2 ;
        end else begin
            Ibreake = 0.0 ;
        end

        //---------------------------------------------------*
        //* Impact-Ionization Induced Bulk Potential Change(IBPC)
        //*-----------------//
        if ( (Isub + IsubLD) > 0e0 && UC_IBPC1 != 0e0 && UC_CODEP == 0 ) begin //{

            // delta Vbs //
            T0 = 1e0 + UC_IBPC2 * dVth ;
            T1 = Isub + IsubLD ;
            dVbsIBPC = UC_IBPC1 * T0 * T1 ;

            // dG3 & dG4 //
            T10 = 1e0 / Xi0 ;
            T1 = beta * dVbsIBPC * T10 ;
            T11 = T10 * T10;
            T10 = 1e0 / Xil ;
            T2 = beta * dVbsIBPC * T10 ;
            T11 = T10 * T10;
            dG3 = cnst0 * ( Xilp32 * T2 - Xi0p32 * T1 ) ;
            dG4 = cnst0 * 0.5 * ( - Xilp12 * T2 + Xi0p12 * T1 ) ;

            // Add IBPC current into Ids //
            dIdd = dG3 + dG4 ;
            IdsIBPC = betaWL * dIdd * Mu ;
            IsubIBPC = wk_ii * IdsIBPC; // 20180413

        end // End if(IBPC) //}

        //-----------------------------------------------------------*
        //* Igate : Gate current induced by tunneling.
        //*-----------------//
        if ( COIIGS != 0 ) begin
            // Igate //
            if ( flg_noqi == 0 ) begin
                Psdlz = Ps0z + Vdsz - `epsm10 ;
                T1 = Vgsz - Vfb + MKS_GLEAK4 * (dVth - dPpg) * Leff - Psdlz * UC_GLEAK3 ;
                T1 = T1 * T1 ;
                T3 = 1.0 / Tox0 ;
                T2 = T1 * T3 ;
                T3 = 1.0 / MKS_GLEAK5 ;
                T7 = 1.0 + Ey * T3 ;
                Etun = T2 * T7 ;
                `Fn_SZ( Etun , Etun , `igate_dlt , T5 )
                `Fn_SZ( T3 , Vgsz , 1.0e-3 , T4 )
                T3 = T3 - VZADD0 ;
                TX = T3 / `cclmmdf ;
                T2 = 1.0 +  TX * TX ;
                T1 = 1.0 - 1.0 / T2 ;
                Etun = Etun * T1 ;
                T0 = Leff * weff_nf ;
                T7 = MKS_GLEAK7 / (MKS_GLEAK7 + T0) ;
                T6 = UC_GLEAK6 ;
                T9 = T6 / (T6 + Vdsz) ;
                T4 = 1 / (Etun + `Small ) ;
                T1 = - UC_GLEAK2 * Egp32 * T4 ;
                T3 =  UC_GLEAK2 * T4 * T4;
                if ( T1 < - `EXP_THR ) begin
                    Igate = 0.0 ;
                end else begin
                    T2 = exp ( T1 ) ;
                    T3 = UC_GLEAK1 / Egp12 * `C_QE * T0 ;
                    T5 = 1 / cnst0 ;
                    T6 =  sqrt ((Qiu_noi + Cox0 * `VgVt_Small )* T5 ) ;
                    T4 =  T2 * T3 * T6 ;
                    T5 = T4 * Etun ;
                    T10 = T5 * Etun ;
                    Igate = T7 * T9 * T10 ;
                end
            end

            // Igs //
            T0 = - UC_GLKSD2 * Vgs + MKS_GLKSD3 ;
            T2 = exp (Tox0 * T0);
            T0 = Vgs / Tox0 / Tox0 ;
            T3 = Vgs * T0 ;
            T4 = UC_GLKSD1 / 1.0e6 * weff_nf ;
            Igs = T4 * T2 * T3 ;
            if ( Vgs >= 0.0e0 ) begin
                Igs = Igs * -1.0 ;
            end

            // Igd //
            T1 = Vgs - Vds ;
            T0 = - UC_GLKSD2 * T1 + MKS_GLKSD3 ;
            T2 = exp (Tox0 * T0);
            T0 = T1 / Tox0 / Tox0 ;
            T3 = T1 * T0 ;
            T4 = UC_GLKSD1 / 1.0e6 * weff_nf ;
            Igd = T4 * T2 * T3 ;
            if ( T1 >= 0.0e0 ) begin
                Igd = Igd * -1.0 ;
            end

            // Igb //
            Etun = ( - ( Vgs - Vbs ) + Vfb + GLKB3 ) / Tox0 ;
            `Fn_SZ( Etun , Etun, `igate_dlt, T5)
            Etun = Etun + `Small ;
            T1 = - UC_GLKB2 / Etun ;
            if ( T1 < - `EXP_THR ) begin
                Igb = 0.0 ;
            end else begin
                T2 = exp ( T1 );
                T3 =  UC_GLKB2 / ( Etun * Etun ) * T2 ;
                T3 = UC_GLKB1 * weff_nf * Leff ;
                Igb = T3 * Etun * Etun * T2 ;
            end

            // Ifn: Fowler-Nordheim tunneling current //
            Eg12 = sqrt_eg ;
            Eg32 = Eg * Eg12 ;
            T2 = - ( UC_FVBS * Vbsz - Vgsz + dVthSC + dVthLP - UC_FN3 ) / Tox0 ;
            T0 = T2 * T2 ;
            T1 = UC_FN2 * Eg32 ;
            T3 = - T1 / T2  ;
            if ( T3 < - `EXP_THR ) begin
                T5 = 0.0 ;
            end else begin
                T5 = exp( T3 ) ;
            end
            T4 = `C_QE * UC_FN1 * weff_nf * Lgate / Eg12 ;
            if ( 2e0 * T2 + T1 < 0e0 ) begin
                Ifn = 0.25e0 * T4 * T1 * T1 * `c_exp_2 ; // minimum value //
            end else begin
                Ifn = T4 * T0 * T5 ;
            end
            Igb = Igb - Ifn ;
        end // if( coiigs == 0 ) //

        //-----------------------------------------------------------*
        //* Vdsp : Vds modification for GIDL/GISL
        //*-----------------//
        if ( COGIDL != 0 ) begin
            T1 = Vds * (1.0 - `gidla * Vds) - `gidlvds_dlt ;
            T2 = sqrt (T1 * T1 + 4.0 * `gidlvds_dlt * Vds) ;
            Vdsp = Vds - 0.5 * (T1 + T2) ;
        end

        //-----------------------------------------------------------*
        //* Igidl : GIDL
        //*-----------------//
        if ( COGIDL == 0 ) begin
            Igidl = 0.0e0 ;
        end else begin
            T1 = GIDL3 * (Vdsp + GIDL4) - Vgs + (dVthSC + dVthLP) * GIDL5 ;
            T2 = 1.0 / Tox0 ;
            E1 = T1 * T2 ;
            `Fn_SZ( Egidl , E1, `eef_dlt, T5)
            T3 = 1 / (Egidl + `Small) ;
            T0 = - UC_GIDL2 * Egp32 * T3 ;
            if ( T0 < - `EXP_THR ) begin
                Igidl = 0.0 ;
            end else begin
                T1 = exp ( T0 ) ;
                T2 = UC_GIDL1 / Egp12 * `C_QE * weff_nf ;
                Igidl = T2 * Egidl * Egidl * T1 ;
            end

            // bug-fix //
            Vdb = Vds - Vbs ;
            if ( Vdb > 0.0 ) begin
                T2 = Vdb * Vdb ;
                T4 = T2 * Vdb ;
                T0 = T4 + `C_gidl_delta ;
                T5 = T4 / T0 ;
                T7 = ( 3.0 * T2 * T0 - T4 * 3.0 * T2 ) / ( T0 * T0 ) ;
                Igidl = Igidl * T5 ;
            end else begin
                Igidl = 0.0 ;
            end
        end

        //-----------------------------------------------------------*
        //* Igisl : GISL
        //*-----------------//
        if ( COGIDL == 0) begin
            Igisl = 0.0e0 ;
        end else begin
            T1 = GIDL3 * ( - Vdsp + GIDL4 )
            - ( Vgs - Vdsp ) + ( dVthSC + dVthLP ) * GIDL5 ;
            T2 = 1.0 / Tox0 ;
            E1 = T1 * T2 ;
            `Fn_SZ( Egisl , E1, `eef_dlt, T5)
            T3 =  1  / (Egisl + `Small) ;

            T0 = - UC_GIDL2 * Egp32 * T3 ;
            if ( T0 < - `EXP_THR ) begin
                Igisl = 0.0 ;
            end else begin
                T1 = exp ( T0 ) ;
                T3 = 1 / Egp12 ;
                T2 = UC_GIDL1 * T3 * `C_QE * weff_nf ;
                Igisl = T2 * Egisl * Egisl * T1 ;
            end

            // bug-fix //
            Vsb = - Vbs ;
            if ( Vsb > 0.0 ) begin
                T2 = Vsb * Vsb ;
                T4 = T2 * Vsb ;
                T0 = T4 + `C_gidl_delta ;
                T5 = T4 / T0 ;
                T7 = ( 3.0 * T2 * T0 - T4 * 3.0 * T2 ) / ( T0 * T0 ) ;
                Igisl = Igisl * T5 ;
            end else begin
                Igisl = 0.0 ;
            end
        end

        //-----------------------------------------------------------*
        //* End of PART-2. (label)
        //*-----------------//
        // end_of_part_2:

        //++++++++++++++++++++++++++++++++++++++++++++++++++++++++++++
        //* PART-3: Overlap charge
        //*++++++++++++++++++++++++++++++++++++++++++++++++++++++++++++//
        //-----------------------------------------------------------*
        //* Overlap charges
        //*-----------------//
        begin:  evalOverlap
            integer flg_COOVLPS, i_over, flg_calcqover, flg_COOVLP;
// ---- begin `include "HSMHV_eval_Overlap.inc" ----
/***********************************************************************

 HiSIM (Hiroshima University STARC IGFET Model)
 Copyright (C) 2000-2016 Hiroshima University and STARC
 Copyright (C) 2016-2023 Hiroshima University
 HiSIM_HV (High-Voltage Model)
 Copyright (C) 2007-2016 Hiroshima University and STARC
 Copyright (C) 2016-2023 Hiroshima University

 MODEL NAME : HiSIM_HV
 ( VERSION : 2  SUBVERSION : 5  REVISION : 1 )
 Model Parameter 'VERSION' : 2.51
 FILE : HSMHS_eval_Overlap.inc

 Date : 2023.02.09

 released by Hiroshima University

***********************************************************************/

//-----------------------------------*
//* Surface potential model
//*------------------------//
flg_COOVLPS = 0;
flg_COOVLP = 0;
i_over = 0;
flg_calcqover = 0;
flg_never_reach_vfbover = 0;
for (i_over=1;i_over<=4;i_over=i_over+1) begin
    flg_calcqover = 0 ;
    case (i_over) // calc. the terminal biases and etc.
        1: if( COOVLPS == 1 && LOVERS > 0.0 && UC_NOVERS > 0.0 ) begin
            //-------------------------------------*
            //* Source side Qovs( V(gP,bP), V(sP,bP) )
            //*-----------------//
            flg_calcqover = 1 ;
            flg_COOVLPS = 1;
            Vgbgmt = Vgsi- Vbsi;
            Vxbgmt = - Vbsi;
            Nover_func = UC_NOVERS  ;
            Lover_func = LOVERS ;
            Wdep_func  = 0.0;
            cnst0over_func = cnst0overs ;
            Cox0_func = Cox0; //added

        end // flg_COOVLPS = 1;
        2: if( COOVLPS == 1 && LOVERS > 0.0 && UC_NOVERS > 0.0 && UC_CVDSOVER != 0.0 && COTRENCH != 1 ) begin
            //--------------------------------------*
            //* Source side Qovsext( V(gP,bP), V(s,bP) )
            //*-----------------//
            flg_calcqover = 1 ;
            Vgbgmt = Vgsei - Vbsei ;
            Vxbgmt = - Vbsei ;
        end
        3: if( COOVLP == 1 && LOVERLD > 0.0 && UC_NOVER > 0.0 ) begin
            //--------------------------------------*
            //* Drain side Qovd( V(gP,bP), V(dP,bP) )
            //*-----------------//
            flg_calcqover = 1 ;
            flg_COOVLP = 1;
            Vgbgmt = Vgsi - Vbsi ;
            Vxbgmt = Vdsi - Vbsi ;
            Nover_func = UC_NOVER ;
            Lover_func = LOVERLD  + WTRENCH * COTRENCH ;
            Wdep_func  = Wdep ;
            cnst0over_func = cnst0over ;
            Cox0_func = Coxb0; //added

            Lover_func = - Lover_func ;

            begin : HSMHVeval_loverLim
// ---- begin `include "HSMHV_eval_loverLim.inc" ----
/***********************************************************************

 HiSIM (Hiroshima University STARC IGFET Model)
 Copyright (C) 2000-2016 Hiroshima University and STARC
 Copyright (C) 2016-2023 Hiroshima University
 HiSIM_HV (High-Voltage Model)
 Copyright (C) 2007-2016 Hiroshima University and STARC
 Copyright (C) 2016-2023 Hiroshima University

 MODEL NAME : HiSIM_HV
 ( VERSION : 2  SUBVERSION : 5  REVISION : 1 )
 Model Parameter 'VERSION' : 2.51
 FILE : HSMHV_eval_loverLim.inc

 Date : 2023.02.09

 released by Hiroshima University

***********************************************************************/

// calc. bias dependent Lover for 2.4.0
if ( Lover_func < 0.0 && QOVJUNC > 0 && COTRENCH == 1 ) begin
    Lover_func = - Lover_func ; // now, Lover_func positive.
    T1 = LOVERLD ;
    Vxb_lim = (T1 * T1 / kjunc) - VBI ;
    if ( OLMDLT > 0 ) begin
        `Fn_SU_POW( Vxbgmt , Vxbgmt , Vxb_lim , OLMDLT )
        `Fn_SZ( T2 , (Vxbgmt + VBI) , 0.1 , T9 )
        Wjunc0 = sqrt ( kjunc * T2 ) * QOVJUNC ;
        Lover_func = Lover_func - Wjunc0 ;
    end
end // if ( Lover_func < 0.0 && QOVJUNC > 0 && COTRENCH == 1 )
// ---- end `include "HSMHV_eval_loverLim.inc" ----
            end

        end // flg_COOVLP = 1;
        4: if( COOVLP == 1 && LOVERLD > 0.0 && UC_NOVER > 0.0 && UC_CVDSOVER != 0.0 && COTRENCH != 1 ) begin
            //--------------------------------------*
            //* Drain side Qovdext( V(gP,bP), V(d,bP) )
            //*-----------------//
            flg_calcqover = 1 ;
            Vgbgmt = Vgsei - Vbsei ;
            Vxbgmt = Vdsei - Vbsei ;
        end
    endcase // end of case

    if (flg_calcqover) begin
        begin : HSMHVevalQover_qov
// ---- begin `include "HSMHV_eval_qover.inc" ----
/***********************************************************************

 HiSIM (Hiroshima University STARC IGFET Model)
 Copyright (C) 2000-2016 Hiroshima University and STARC
 Copyright (C) 2016-2023 Hiroshima University
 HiSIM_HV (High-Voltage Model)
 Copyright (C) 2007-2016 Hiroshima University and STARC
 Copyright (C) 2016-2023 Hiroshima University

 MODEL NAME : HiSIM_HV
 ( VERSION : 2  SUBVERSION : 5  REVISION : 1 )
 Model Parameter 'VERSION' : 2.51
 FILE : HSMHV_eval_qover.inc

 Date : 2023.02.09

 released by Hiroshima University

***********************************************************************/
//
////////////////////////////////////////////////////////////////
//
//
//
//
//Licensed under the Educational Community License, Version 2.0
//(the "License"); you may not use this file except in
//compliance with the License.
//
//You may obtain a copy of the License at:
//
//      http://opensource.org/licenses/ECL-2.0
//
//Unless required by applicable law or agreed to in writing,
//software distributed under the License is distributed on an
//"AS IS" BASIS, WITHOUT WARRANTIES OR CONDITIONS OF ANY KIND,
//either express or implied. See the License for the specific
//language governing permissions and limitations under the
//License.
//
//
//The HiSIM_HV standard has been supported by the members of
//Silicon Integration Initiative's Compact Model Coalition. A
//link to the most recent version of this standard can be found
//at:
//
//http://www.si2.org/cmc
//
////////////////////////////////////////////////////////////////
//

// begin : HSMHVevalQover //
real WdLD , Q_dep_LD , q_NsubLD ;
real Vx; // auxiliary
integer flg_ovzone_intheloop;
real Pb2over, Vbs_max_over, Vbs_bnd_over;
`ifdef _COFDISPLAY_
    real QsuLD_ini , QbuLD_ini ;
    integer probe_lp_s0;
`endif
integer flg_FD_mode;
real Ps0LD_ini; //for fully iterative Ps0LD (COQOVSM=4)
real fbsq, fbsq_dPss; //for fully iterative Ps0LD (COQOVSM=4)
Vbs_bnd_over = 0.4; //necessary initial value
flg_ovzone_intheloop = 0;
`ifdef _COFDISPLAY_
    probe_lp_s0 = 0; //initialized for debug printing
`endif
flg_FD_mode = 0; //necessary initial value
fb = 0.0 ; fs01 = 0.0 ; fs02 = 0.0 ; //initialized for debug printing
Fs0 =0.0; dPs0=0.0; //initialized for debug printing
Fs0_dPs0 = 0.0; fs02_dPs0 = 0.0; fb_dPss = 0.0; fs01_dPs0 = 0.0; //initialized for debug printing
Chi_1 = 0.0 ; Chi_A = 0.0 ; Chi_B = 0.0 ; //initialized for debug printing
flg_conv = -1 ; //initialized for debug printing
Ps0LD_ini = 0; //for fully iterative Ps0LD (COQOVSM=4)
fbsq = 0; //for fully iterative Ps0LD (COQOVSM=4)

//---------------------------------------------------*
//* Determine clamping limits for too large bulk bias for parasitic PMOS capacitor (-Vxbgmt).
//*-----------------//
Pb2over =  2.0e0 * beta_inv * ln (Nover_func / Nin) ;
`Fn_SU( Vbs_max_over , Pb2over , 0.8 , 0.1 , T0 )
if ( Vbs_bnd_over > Vbs_max_over * 0.5 ) begin
    Vbs_bnd_over = 0.5 * Vbs_max_over ;
end

//updates when VBFWDMX and VBFWDBND are given:
if ($param_given(VBFWDMX)) begin
    Vbs_max_over = VBFWDMX; //user-defined value
end
if ($param_given(VBFWDBND)) begin
    Vbs_bnd_over = VBFWDBND; //user-defined value
end else begin
    if ($param_given(VBFWDMX)) begin
        Vbs_bnd_over = 0.5 * Vbs_max_over; //based on the user-defined value
    end
end
if ( Vbs_bnd_over > Vbs_max_over * 0.5 ) begin
    Vbs_bnd_over = 0.5 * Vbs_max_over ;
end

//---------------------------------------------------*
//* Clamp -Vxbgmt.
//*-----------------//
if ( COQOVCL == 1) begin
    T0 = - Vxbgmt;
    if ( T0 > Vbs_bnd_over ) begin
        T1 =    T0   - Vbs_bnd_over;
        T2 =    Vbs_max_over    - Vbs_bnd_over;
        `Fn_SUPoly4m( TY, T1, T2, T11, T0 )
        T10 = Vbs_bnd_over + TY ;
    end  else begin
        T10 = T0 ;
    end
    Vxbgmtcl = - T10  ;
end // if ( COQOVCL == 1)
else begin
    Vxbgmtcl = Vxbgmt;  // no clamp
end // else: !if( COQOVCL == 1)

fac1 = cnst0over_func / Cox0_func ;
fac1p2 = fac1 * fac1 ;
VgpLD = - Vgbgmt + UC_VFBOVER;
Vgb_fb_LD =  - Vxbgmtcl + `epsm10 ;
Q_dep_LD  =  0.0 ;
q_NsubLD = `C_QE * Nover_func ;

T0 = Nin / Nover_func;
cnst1over = T0 * T0;                 //moved from the case ( COQOVSM > 0 ) below
//exp_bVbs = exp( beta * -Vxbgmtcl ) ; //moved from the case ( COQOVSM > 0 ) below
`Fn_DExp( exp_bVbs , ( beta * -Vxbgmtcl ) , T0)

if ( flg_never_reach_vfbover ) begin
    // ceiling (VgpLD + Vxbgmtcl) less than 0 and feed back to Vxbgmtcl:
    //--> never enters the depletion region.
    `Fn_SL(T1, (-VgpLD*`VXBGMTDLT)  , 0.5, 1 , T0 )
    `Fn_SU_CP(T1, (VgpLD + Vxbgmtcl), 0.0, T1, 1, T0)
    Vxbgmtcl = T1 - VgpLD;
    Vgb_fb_LD =  - Vxbgmtcl + `epsm10 ;
end

//-----------------------------------*
//* QsuLD: total charge = Accumulation | Depletion+inversion
//*-----------------//
if ( VgpLD  < Vgb_fb_LD ) begin
    //---------------------------*
    //* Accumulation
    //*-----------------//
    flg_ovzone = -1 ;
    Ps0_min = 2.0 * beta_inv * ln (-Vgs_min/fac1) ;
    TX = beta * ( VgpLD + Vxbgmtcl ) ;

    T1 = 1.0 / ( beta * cnst0over_func ) ;
    TY = T1 * Cox0_func ;
    Ac41 = 2.0 + 3.0 * `C_SQRT_2 * TY ;
    Ac4 = 8.0 * Ac41 * Ac41 * Ac41 ;
    Ac31 = 7.0 * `C_SQRT_2 - 9.0 * TY * ( TX - 2.0 ) ;
    Ac3 = Ac31 * Ac31 ;
    if ( Ac4 < Ac3*1.0e-8 ) begin
        flg_ovzone = -2 ;
        Ac1 = 0.5 * Ac4 / Ac31 ;
    end else begin
        Ac2 = sqrt( Ac4 + Ac3 ) ;
        Ac1 = -Ac31 + Ac2 ;
    end
    Acd = pow( Ac1 , `C_1o3 ) ;
    Acn = -4.0 * `C_SQRT_2 - 12.0 * TY + 2.0 * Acd + `C_SQRT_2 * Acd * Acd ;
    Chi = Acn / Acd ;

    T1 = Chi * beta_inv ;
    T2 = T1 / Ps0_min ;
    T3 = sqrt( 1.0 + ( T2 * T2 ) ) ;
    Ps0LD = T1 / T3 - Vxbgmtcl ;
    T2 = ( VgpLD - Ps0LD ) ;
    QsuLD = Cox0_func * T2 ;

    QbuLD = QsuLD ;

`ifdef _COFDISPLAY_
        QsuLD_ini = QsuLD ;
        QbuLD_ini = QbuLD ;
`endif
    Ps0LD_ini = Ps0LD ; //for fully iterative Ps0LD (COQOVSM=4)

end else begin

    //---------------------------*
    //* Depletion and inversion
    //*-----------------//

    // initial value for a few fixpoint iterations
    //to get Ps0_iniA from simplified Poisson equation: //
    if ( beta * ( VgpLD + Vxbgmtcl ) < 1.0e0 + ( `epsm10 - 1.0e0 ) * fac1p2 * beta2 / 4.0e0 ) begin //equivalent to (TX < `epsm10)
        Ps0_iniA = VgpLD + fac1p2 * beta / 2.0e0  ;
    end else begin
        TX = 1.0e0 + 4.0e0 * ( beta * ( VgpLD + Vxbgmtcl ) - 1.0e0 ) / ( fac1p2 * beta2 ) ;
        Ps0_iniA = VgpLD + fac1p2 * beta / 2.0e0 * ( 1.0e0 - sqrt( TX ) ) ;
    end
    Chi = beta * ( Ps0_iniA + Vxbgmtcl ) ;

    if ( Chi >= `znbd3 ) begin
        flg_ovzone = 2 ;
        // 1 .. 2 relaxation steps should be sufficient //
        for ( lp_ld = 1; lp_ld <= 2; lp_ld = lp_ld + 1 ) begin
            TY = exp(-Chi);
            TX = 1.0e0 + 4.0e0 * ( beta * ( VgpLD + Vxbgmtcl ) - 1.0e0 + TY ) / ( fac1p2 * beta2 ) ;
            Ps0_iniA = VgpLD + fac1p2 * beta / 2.0e0 * ( 1.0e0 - sqrt( TX ) ) ;
            Chi = beta * ( Ps0_iniA + Vxbgmtcl ) ;
        end // End of iteration //
    end else begin
        flg_ovzone = 1 ;

        //-----------------------------------*
        //* zone-D1
        //* - Ps0_iniA is the analytical solution of QovLD=Qb0 with
        //*   Qb0 being approximated by 3-degree polynomial.
        //*
        //*   new: Inclusion of exp(-Chi) term at right border
        //*-----------------//
        Ta =  1.0/(9.0*sqrt(2.0)) - (5.0+7.0*exp(-3.0)) / (54.0*sqrt(2.0+exp(-3.0)));
        Tb = (1.0+exp(-3.0)) / (2.0*sqrt(2.0+exp(-3.0))) - sqrt(2.0) / 3.0;
        Tc =  1.0/sqrt(2.0) + 1.0/(beta*fac1);
        Td = - (VgpLD + Vxbgmtcl) / fac1;
        Tq = Tb*Tb*Tb / (27.0*Ta*Ta*Ta) - Tb*Tc/(6.0*Ta*Ta) + Td/(2.0*Ta);
        Tp = (3.0*Ta*Tc-Tb*Tb)/(9.0*Ta*Ta);
        T5 = sqrt(Tq*Tq + Tp*Tp*Tp);
        Tu = pow(-Tq + T5,`C_1o3);
        Tv = -pow(Tq + T5,`C_1o3);
        Chi = Tu + Tv - Tb/(3.0*Ta);
        Ps0_iniA = Chi * beta_inv - Vxbgmtcl ;
    end

    if ( COQOVSM > 0 ) begin
        //-----------------------------------*
        //* - Ps0_iniB : upper bound.
        //*-----------------//
        VgpLD_shift = VgpLD + Vxbgmtcl + 0.1;
        //

        cfs1 = cnst1over * exp_bVbs ;
        gammaChi = cnst1over * exp_bVbs;
        T0  = beta2 * fac1p2;
        psi = beta*VgpLD_shift;
        Chi_1 = ln (gammaChi*T0 + psi*psi) - ln (cnst1over*T0) + beta*Vxbgmtcl;
        if ( COQOVSM == 2 ) begin
            `Fn_SU( Chi_1, Chi_1, psi, 1.0, T1 )
        end else begin
            Chi_1 = `Fn_Min( Chi_1, psi ); // clipping to keep the original curve (Initial guess doesn't need to be continuous.)
        end
        Chi_1 = `Fn_Max( Chi_1, 0.0 ); // protection for the unclamped beta*Vxbgmtcl when COQOVCL=0

        // 1 fixpoint step for getting more accurate Chi_B //
        psi = psi - Chi_1 ;
        psi = psi + beta*0.1 ;
        T1 = ln (gammaChi*T0 + psi*psi) - ln (cnst1over*T0) ;
        Chi_B = T1 + beta*Vxbgmtcl ;
        Chi_B = `Fn_Max( Chi_B, 0.0 ); // protection for the unclamped beta*Vxbgmtcl when COQOVCL=0

        // construction of Ps0LD by taking Ps0_iniB as an upper limit of Ps0_iniA
        //*
        //* Limiting is done for Chi rather than for Ps0LD, to avoid shifting
        //* for Fn_SU //
        Chi_A = Chi;
        if ( COQOVSM == 2 ) begin
            `Fn_SU_CP( Chi, Chi_A, Chi_B, 0.2*Chi_B, 2, T1 )
        end else begin
            Chi = `Fn_Min( Chi_A, Chi_B ); // clipping to keep the original curve (Initial guess doesn't need to be continuous.)
        end

    end

    // update_of_initial_guess_for_FD_mode
    if ( COQOVSM == 1 ) begin
        //----------------------------//
        // temporary_Chib_for_FD_mode //
        //----------------------------//

        Ps0LD = Chi* beta_inv - Vxbgmtcl ; // updating Ps0LD //

        // calc. effective DDRIFT with p-n junction
        if ( Wdep_func > 0.0 ) begin
            T2 = `DDRIFT - Wdep_func ;
        end else begin
            `Fn_SZ( T2 , (Vdsi + VBI) , 0.1 , T9 )
            Wjunc0 = sqrt ( kjunc * T2 ) * QOVJUNC ;
            T2 = `DDRIFT - Wjunc0 ;
        end
        `Fn_SZ( T2 , T2 , `DDRIFT * 0.01 , T9 )
        ddriftldc = T2 ;

        dphi_sb = q_NsubLD * ddriftldc * ddriftldc / 2.0 / `C_ESI ;
        T0 = sqrt(2.0 * beta * dphi_sb) ;
        T1 = (lexp(T0) + lexp(-T0)) / 2 ;
        c_sb = ln(T1) / dphi_sb ;

        Ps0LD_Vxb = Ps0LD + Vxbgmtcl ;
        TY = c_sb * ( Ps0LD_Vxb - dphi_sb ) ;
        if ( TY  < `large_arg ) begin
            T1 = exp(TY) ;
            T0 = exp(- c_sb * dphi_sb) ;
            T2 = T1 - T0 ;
            phi_b = ln(1 + T2) / c_sb ;
        end else begin
            phi_b = Ps0LD_Vxb - dphi_sb ;
        end
        Chib = beta * phi_b ;

        if ( Chib > Chi/100 && Chib > 0 ) begin //FD-mode correction for Vgs dependence:
            flg_FD_mode = flg_FD_mode + 1; // FD mode
            Chi = Chi_1;
        end
    end // if ( COQOVSM == 1 )

    // updating Ps0LD //
    Ps0LD = Chi* beta_inv - Vxbgmtcl ;

    if (abs(Chi)> 1e-6) begin   // 20161012
        T1 = Chi - 1.0 + exp(-Chi);
        T2 = sqrt(T1);
    end else begin
        flg_ovzone = flg_ovzone + 4; //very close to flatband
        // T2 = `C_1oSQRT2*Chi;
        // further alternative:
        //  // Chi - 1.0 + exp(-Chi) = (1/2)*Chi*Chi*(1- (1/3)*Chi)
        //  u = 1.0 - Chi * `C_1to3;
        //  T2 = `C_1oSQRT2* Chi* sqrt(u);
        T2 =`C_1oSQRT2* Chi* sqrt( 1.0 - Chi * `C_1o3); // 20200727
    end
    QbuLD = cnst0over_func * T2 ;

    //-----------------------------------------------------------*
    //* QsuLD : Qovs or Qovd in unit area.
    //* note: QsuLD = Qdep+Qinv.
    //*-----------------//
    QsuLD = Cox0_func * ( VgpLD - Ps0LD ) ;

    // 2nd_update_of_initial_guess_for_FD_mode
    begin : FD_mode
        real WdLD0, Ps0LD_bef1;

        WdLD0 = QbuLD / q_NsubLD ;
        if ( COQOVSM == 2 ) begin
            `Fn_SU_CP( T1 , WdLD0 , ddriftldc , ddriftldc*0.1 , 2 , T0 )
            if ( T0 < 1.0) begin
                flg_FD_mode = flg_FD_mode + 2; // FD mode
            end
        end else begin
            T1 = `Fn_Min( WdLD0, ddriftldc );
            if ( WdLD0 >= ddriftldc ) begin
                flg_FD_mode = flg_FD_mode + 2; // FD mode
            end
        end

        if ( flg_FD_mode >= 2 ) begin // FD-mode correction for large Vds:
            Ps0LD_bef1 = Ps0LD;
            QbuLD = T1 * q_NsubLD ;
            Ps0LD = VgpLD - QbuLD / Cox0_func ; // QsuLD = QbuLD w/o Qinv
            if ( COQOVSM == 2 ) begin
                `Fn_SU_CP( Ps0LD , Ps0LD, Ps0LD_bef1 , 0.1 , 2 , T0 )
            end else begin
                Ps0LD = `Fn_Min( Ps0LD, Ps0LD_bef1 );
            end
        end

    end // block: FD_mode

`ifdef _COFDISPLAY_
        QsuLD_ini = QsuLD ;
        QbuLD_ini = QbuLD ;
`endif
    Ps0LD_ini = Ps0LD ; //for fully iterative Ps0LD (COQOVSM=4)

    if ( COQOVSM == 1 ) begin // Dynamic Depletion Model //

        //---------------------------------------------------*
        //* Calculation of Ps0. (beginning of Newton loop)
        //* - Fs0 : Fs0 = 0 is the equation to be solved.
        //* - dPs0 : correction value.
        //*-----------------//
        flg_conv = 0 ;
        C_W_LD = sqrt(2.0 * (`C_ESI / q_NsubLD * beta_inv)) ;
        // calc. effective DDRIFT with p-n junction
        if ( Wdep_func > 0.0 ) begin
            T2 = `DDRIFT - Wdep_func ;
        end else begin
            `Fn_SZ( T2 , (Vdsi + VBI) , 0.1 , T9 )
            Wjunc0 = sqrt ( kjunc * T2 ) * QOVJUNC ;
            T2 = `DDRIFT - Wjunc0 ;
        end
        `Fn_SZ( T2 , T2 , `DDRIFT * 0.01 , T9 )
        ddriftldc = T2 ;

        dphi_sb = q_NsubLD * ddriftldc * ddriftldc / 2.0 / `C_ESI ;
        T0 = sqrt(2.0 * beta * dphi_sb) ;
        T1 = (lexp(T0) + lexp(-T0)) / 2 ;
        c_sb = ln(T1) / dphi_sb ;

        for ( lp_s0 = 1 ; lp_s0 <= lp_s0_max + 1 ; lp_s0 = lp_s0 + 1 ) begin
            if ( i_over == 3 ) begin
                OP_lp_ld = lp_s0 - 1 ;
            end
`ifdef _COFDISPLAY_
                probe_lp_s0 = lp_s0 - 1; // -1 is necessary to correct the counts
`endif
            flg_ovzone_intheloop = 0;

            Ps0LD_Vxb = Ps0LD + Vxbgmtcl ;
            Chi = beta * Ps0LD_Vxb ;

            TY = c_sb * ( Ps0LD_Vxb - dphi_sb ) ;
            if ( TY  < `large_arg ) begin
                T1 = exp(TY) ;
                T0 = exp(- c_sb * dphi_sb) ;
                T2 = T1 - T0 ;
                phi_b = ln(1 + T2) / c_sb ;
                phi_b_dPss = T1 / (1 + T2) ;
            end else begin
                flg_ovzone_intheloop = flg_ovzone_intheloop + 8 ; //possible case
                phi_b = Ps0LD_Vxb - dphi_sb ;
                phi_b_dPss = 1 ;
            end
            Chib = beta * phi_b ;

            if (Chi < 0) begin
                flg_ovzone_intheloop = flg_ovzone_intheloop + 64 ; //unexpected case
                T0 = - `C_1oSQRT2 ; //derived with 2nd-order Maclaurin series
                fb = Chi * T0 ;
                fb_dPss = beta * T0 ;
            end else if (Chi < 1E-6) begin
                flg_ovzone_intheloop = flg_ovzone_intheloop + 32 ; //rare case
                T0 = Chi * Chi / 2 * (1 - Chi / 3 * (1 - Chi / 4 * (1 - Chi / 5))) ;
                T1 = Chi * (1 - Chi / 2 * (1 - Chi / 3 * (1 - Chi / 4))) ;
                T2 = Chib * Chib / 2 * (1 - Chib / 3 * (1 - Chib / 4 * (1 - Chib / 5))) ;
                T3 = Chib * (1 - Chib / 2 * (1 - Chib / 3 * (1 - Chib / 4))) ;
                T4 = T0 - T2 ;
                if ( T4 > 0.0 ) begin
                    fb = sqrt(T4) ;
                    fb_dPss = beta * 0.5 * (T1 - phi_b_dPss * T3) / fb ;
                end else begin
                    flg_ovzone_intheloop = flg_ovzone_intheloop + 256 ; //FPE case
                    fb = 0.0 ;
                    fb_dPss = 0.0 ;
                end
            end else begin
                //-------------------------------------------*
                //* zone-D3.  (Ps0LD)
                //*-----------------//
                T0 = exp(-Chi) ;
                T1 = exp(-Chib) ;
                T4 = Chi - Chib + (T0 - T1) ;
                if ( T4 > 0.0 ) begin
                    fb = sqrt(T4) ;
                    fb_dPss = beta * 0.5 * (1 - T0 - phi_b_dPss * (1 - T1)) / fb ;
                end else begin
                    flg_ovzone_intheloop = flg_ovzone_intheloop + 512 ; //FPE case
                    fb = 0.0 ;
                    fb_dPss = 0.0 ;
                end
            end //

            if (Chi < 0) begin
                flg_ovzone_intheloop = flg_ovzone_intheloop + 128 ; //unexpected case
                fs01 = 0.0 ;
                fs01_dPs0 = 0.0 ;
                fs02 = -fb ;
                fs02_dPs0 = -fb_dPss ;
            end else begin
                if ( Chi < `large_arg ) begin // avoid exp_Chi to become extremely large
                    if ( Chi < 5.0e-5 ) begin
                        T0 = Chi * Chi / 2 * (1 + Chi / 3 * (1 + Chi / 4 * (1 + Chi / 5))) ;
                        T1 = Chi * (1 + Chi / 2 * (1 + Chi / 3 * (1 + Chi / 4))) ;
                        fs01 = cfs1 * T0 ;
                        fs01_dPs0 = cfs1 * T1 * beta ;
                    end else begin
                        exp_Chi = exp( Chi ) ;
                        T1 = exp_Chi - 1 ;
                        fs01 = cfs1 * ( T1 - Chi ) ;
                        fs01_dPs0 = cfs1 * beta * ( T1 ) ;
                    end
                end else begin
                    flg_ovzone_intheloop = flg_ovzone_intheloop + 16 ; //possible case
                    exp_bPs0 = exp( beta*Ps0LD ) ;
                    fs01 = cnst1over * ( exp_bPs0 - exp_bVbs * (Chi + 1) ) ;
                    fs01_dPs0 = cnst1over * beta * ( exp_bPs0 - exp_bVbs ) ;
                end
                if ( fs01 > 0.0 ) begin //original:
                    fs02 = sqrt(fb * fb + fs01) ;
                    fs02_dPs0 = 0.5 * (2 * fb_dPss * fb + fs01_dPs0) / fs02 ;
                end else begin //simplified to avoid division by zero:
                    flg_ovzone_intheloop = flg_ovzone_intheloop + 1024 ; //simplified case
                    fs02 = fb ;
                    fs02_dPs0 = fb_dPss ;
                end
            end

            // Revised Fs0 //
            Fs0 = - VgpLD + Ps0LD + fac1 * fs02 ;
            Fs0_dPs0 = 1.0 + fac1 * fs02_dPs0 ;
            //          lp_s0_LD = lp_s0 ;
            if ( flg_conv == 1 ) begin
                lp_s0 = lp_s0_max+1 ; // break
            end else begin
                dPs0 = - Fs0 / Fs0_dPs0 ;

                //-------------------------------------------*
                //* Update Ps0 .
                //* - clamped to Vbcs_cl if Ps0 < Vbcs_cl .
                //*-----------------//
                dPlim = 0.5*`dP_max*(1.0 + `Fn_Max(1.0e0,abs(Ps0LD))) ;
                if ( abs( dPs0 ) > dPlim ) dPs0 = dPlim * `Fn_Sgn( dPs0 ) ;
                Ps0LD = Ps0LD + dPs0 ;

                //-------------------------------------------*
                //* Check convergence.
                //* NOTE: This condition may be too rigid.
                //*-----------------//
                if ( abs( dPs0 ) <= `ps_conv && abs( Fs0 ) <= `gs_conv ) begin
                    flg_conv = 1 ;
                end

            end

        end // end of Ps0LD Newton loop //

        //-------------------------------------------*
        //* Procedure for diverged case.
        //*-----------------//
        if ( flg_conv == 0 ) begin
            $write( "*** warning(HiSIM_HV(%m)): Went Over Iteration Maximum(Ps0LD)\n" ) ;
            $write(" -Vxbgmtcl = %e   Vgbgmt = %e\n" , -Vxbgmtcl , Vgbgmt ) ;
        end

        //-----------------------------------*
        //* Xi0p12
        //*-----------------//
        WdLD = C_W_LD * fb ;
        Q_dep_LD = q_NsubLD * WdLD ;
        Xi0p12 = Q_dep_LD / cnst0over_func + `epsm10 ;

        //-----------------------------------------------------------*
        //* QbuLD and QiuLD
        //*-----------------//
        QbuLD = cnst0over_func * Xi0p12 ;
        T1 = 1.0 / ( fs02 + Xi0p12 ) ;
        QiuLD = cnst0over_func * fs01 * T1 ;

        //-----------------------------------------------------------*
        //* Total overlap charge
        //*-----------------//
        QsuLD = QbuLD + QiuLD;

    end // COQOVSM=1 //
end // end of Vgbgmt region blocks //

if ( COQOVSM == 4 ) begin : FULLY_ITERATIVE_PS0LD

    exp_bVbs = exp( beta * -Vxbgmtcl ) ;
    T0 = Nin / Nover_func;
    cnst1over = T0 * T0;
    cfs1 = cnst1over * exp_bVbs ;

    Ps0LD = Ps0LD_ini ;

    //---------------------------------------------------*
    //* Calculation of Ps0. (beginning of Newton loop)
    //* - Fs0 : Fs0 = 0 is the equation to be solved.
    //* - dPs0 : correction value.
    //*-----------------//
    flg_conv = 0 ;
    C_W_LD = sqrt(2.0 * (`C_ESI / q_NsubLD * beta_inv)) ;
    // calc. effective DDRIFT with p-n junction
    if ( Wdep_func > 0.0 ) begin
        T2 = `DDRIFT - Wdep_func ;
    end else begin
        `Fn_SZ( T2 , (Vdsi + VBI) , 0.1 , T9 )
        Wjunc0 = sqrt ( kjunc * T2 ) * QOVJUNC ;
        T2 = `DDRIFT - Wjunc0 ;
    end
    `Fn_SZ( T2 , T2 , `DDRIFT * 0.01 , T9 )
    ddriftldc = T2 ;

    dphi_sb = q_NsubLD * ddriftldc * ddriftldc / 2.0 / `C_ESI ;
    T0 = sqrt(2.0 * beta * dphi_sb) ;
    T1 = (lexp(T0) + lexp(-T0)) / 2 ;
    c_sb = ln(T1) / dphi_sb ;

    for ( lp_s0 = 1 ; lp_s0 <= lp_s0_max + 1 ; lp_s0 = lp_s0 + 1 ) begin
        if ( i_over == 3 ) begin
            OP_lp_ld = lp_s0 - 1 ;
        end
`ifdef _COFDISPLAY_
            probe_lp_s0 = lp_s0 - 1; // -1 is necessary to correct the counts
`endif
        flg_ovzone_intheloop = 0;

        Ps0LD_Vxb = Ps0LD + Vxbgmtcl ;
        Chi = beta * Ps0LD_Vxb ;

        TY = c_sb * ( Ps0LD_Vxb - dphi_sb ) ;
        if ( TY  < `large_arg ) begin
            T1 = exp(TY) ;
            T0 = exp(- c_sb * dphi_sb) ;
            T2 = T1 - T0 ;
            phi_b = ln(1 + T2) / c_sb ;
            phi_b_dPss = T1 / (1 + T2) ;
        end else begin
            phi_b = Ps0LD_Vxb - dphi_sb ;
            phi_b_dPss = 1 ;
        end
        Chib = beta * phi_b ;

        if ( abs(Chi) < 1.0e-6 ) begin
            flg_ovzone_intheloop = `Fn_Sgn(Chi)*1;
            T0 = Chi * Chi / 2 * (1 - Chi / 3 * (1 - Chi / 4 * (1 - Chi / 5))) ;
            T1 = Chi * (1 - Chi / 2 * (1 - Chi / 3 * (1 - Chi / 4))) ;
            T2 = Chib * Chib / 2 * (1 - Chib / 3 * (1 - Chib / 4 * (1 - Chib / 5))) ;
            T3 = Chib * (1 - Chib / 2 * (1 - Chib / 3 * (1 - Chib / 4))) ;
            fbsq = T0 - T2 ;
            fbsq_dPss = beta * (T1 - phi_b_dPss * T3) ;
        end else begin
            flg_ovzone_intheloop = `Fn_Sgn(Chi)*2;
            T0 = exp(-Chi) ;
            T1 = exp(-Chib) ;
            fbsq = (Chi - Chib + (T0 - T1)) ;  // main equation of fbsq
            fbsq_dPss = beta * (1 - T0 - phi_b_dPss * (1 - T1)) ;
        end

        if ( abs(Chi) < 5.0e-5 ) begin
            T0 = Chi * Chi / 2 * (1 + Chi / 3 * (1 + Chi / 4 * (1 + Chi / 5))) ;
            T1 = Chi * (1 + Chi / 2 * (1 + Chi / 3 * (1 + Chi / 4))) ;
            fs01 = cfs1 * T0 ;
            fs01_dPs0 = cfs1 * T1 * beta ;
        end else begin // if ( abs(Chi) < 5.0e-5 )

            if ( abs(Chi) < `large_arg ) begin
                flg_ovzone_intheloop = `Fn_Sgn(Chi)*3;
                exp_Chi = exp( Chi ) ;
                T1 = exp_Chi - 1 ;
                fs01 = cfs1 * ( T1 - Chi ) ;  // main equation of fs01
                fs01_dPs0 = cfs1 * beta * ( T1 ) ;
            end else begin
                flg_ovzone_intheloop = `Fn_Sgn(Chi)*4;
                exp_bPs0 = exp( beta*Ps0LD ) ;
                fs01 = cnst1over * ( exp_bPs0 - exp_bVbs * (Chi + 1) ) ;
                fs01_dPs0 = cnst1over * beta * ( exp_bPs0 - exp_bVbs ) ;
            end

        end // else: !if( abs(Chi) < 5.0e-5 )

        if (fs01 > 0.0) begin
            fs02 = sqrt(fbsq + fs01) ;  // main equation of fs02
            fs02_dPs0 = 0.5 * (fbsq_dPss + fs01_dPs0) / fs02 ;
        end else begin
            if (fbsq > 0.0) begin
                fs02 = sqrt(fbsq) ;
                fs02_dPs0 = 0.5 * (fbsq_dPss) / fs02 ;
            end else begin
                fs02 = 0.0 ;
                fs02_dPs0 = 0.0 ;
            end
        end

        fs02 =      `Fn_Sgn(Chi) * fs02 ;
        fs02_dPs0 = `Fn_Sgn(Chi) * fs02_dPs0 ;

        // Revised Fs0 //
        Fs0 = - VgpLD + Ps0LD + fac1 * fs02 ;
        Fs0_dPs0 = 1.0 + fac1 * fs02_dPs0 ;
        if ( flg_conv > 0 ) begin
            lp_s0 = lp_s0_max+1 ; // break
        end else begin
            dPs0 = - Fs0 / Fs0_dPs0 ;

            //-------------------------------------------*
            //* Update Ps0 .
            //* - clamped to Vbcs_cl if Ps0 < Vbcs_cl .
            //*-----------------//
            dPlim = 0.5*`dP_max*(1.0 + `Fn_Max(1.0e0,abs(Ps0LD))) ;
            if ( abs( dPs0 ) > dPlim ) dPs0 = dPlim * `Fn_Sgn( dPs0 ) ;
            Ps0LD = Ps0LD + dPs0 ;

            //-------------------------------------------*
            //* Check convergence.
            //* NOTE: This condition may be too rigid.
            //*-----------------//
            if ( abs( dPs0 ) <= `ps_conv && abs( Fs0 ) <= `gs_conv ) begin
                flg_conv = flg_conv + 2 ; //conventional criterion
            end

        end

    end // end of Ps0LD Newton loop //

    //-------------------------------------------*
    //* Procedure for diverged case.
    //*-----------------//
    if ( flg_conv == 0 ) begin
        $write( "*** warning(HiSIM_HV(%m)): Went Over Iteration Maximum(Ps0LD fully iterative)\n" ) ;
        $write(" -Vxbgmtcl = %e   Vgbgmt = %e\n" , -Vxbgmtcl , Vgbgmt ) ;
    end

    //-----------------------------------*
    //* Xi0p12
    //*-----------------//
    fb = (fbsq>=0)? `Fn_Sgn(Chi)*sqrt(fbsq) : 0 ;
    WdLD = C_W_LD * fb ;
    Q_dep_LD = q_NsubLD * WdLD ;
    Xi0p12 = Q_dep_LD / cnst0over_func + `epsm10 ;

    //-----------------------------------------------------------*
    //* QbuLD and QiuLD
    //*-----------------//
    QbuLD = cnst0over_func * Xi0p12 ;
    T1 = 1.0 / ( fs02 + Xi0p12 ) ;
    QiuLD = cnst0over_func * fs01 * T1 ;

    //-----------------------------------------------------------*
    //* Total overlap charge
    //*-----------------//
    QsuLD = QbuLD + QiuLD;

end // block: FULLY_ITERATIVE_PS0LD

// inversion charge = total - depletion //
QiuLD = QsuLD - QbuLD  ;

// calc. bias dependent Lover
// 2.4.0's codes reside in HSMHV_LoverLim.inc 20170825
if ( Lover_func < 0.0 ) begin
    Lover_func = - Lover_func ; // now, Lover_func positive
    if (COTRENCH == 0) begin  // COTRENCH=0 only
        if ( COOVJUNC == 0 ) begin
            Vx = -Ps0LD; // original implementation
        end else begin
            Vx = Vxbgmt; // more correct implementation (2.4.0)
        end
        `Fn_SZ( T2 , ( Vx + VBI) , 0.1 , T9 )
        Wjunc0 = sqrt ( kjunc * T2 ) * QOVJUNC ;
        `Fn_SU( Wjuncld, Wjunc0, Lover_func, 0.1 * Lover_func, T0 )
        Lover_func = Lover_func - Wjuncld ;
    end
end
// end of HSMHVevalQover //
// ---- end `include "HSMHV_eval_qover.inc" ----
        end  // HSMHVevalQover_qov

        case (i_over)  // calc. the total overlap charges
            1: begin
                if ( COTRENCH == 1) begin
                    T4 = weffcv_nf * Lover_func;
                end else begin
                    T4 = weffcv_nf * Lover_func * ( 1 - UC_CVDSOVER ) ;
                end
                Qovs  = T4 * QsuLD ;
                QbsLD = T4 * QbuLD ;
                RS_Ps0LD = Ps0LD;
                RS_QbuLD = QbuLD; // OPP and actual uses
            end // COOVLPS != 0 end //
            2: begin
                T4 = weffcv_nf * Lover_func * UC_CVDSOVER ;
                Qovsext =  T4 * QsuLD ;
                QbsLDext = T4 * QbuLD ;
            end
            3: begin
                if ( COTRENCH == 1 ) begin
                    T4 = weffcv_nf * Lover_func ;
                end else begin
                    T4 = weffcv_nf * Lover_func * ( 1 - UC_CVDSOVER ) ;
                end
                RD_Ps0LD = Ps0LD ;
                if ( RDRQOVER == 0 ) begin //original:
                    RD_QbuLD = QbuLD ;
                end
                // saves for the trench part
                Qovd  = T4 * ( QsuLD ) ;
                QbdLD = T4 * ( QbuLD ) ;
                Qbd_qs = QbdLD ; //for CONQSOV=1
            end //
            4: begin
                T4 = weffcv_nf * Lover_func * UC_CVDSOVER ;
                Qovdext =  T4 * QsuLD ;
                QbdLDext = T4 * QbuLD ;
            end

        endcase // end of case
    end // flg_calcqover == 1
end // enf of loop for overlap charges

//
// Additional calculation for the another version of RD_QbuLD:
//
if ( RDRQOVER > 0 ) begin //trial 1
    flg_never_reach_vfbover = 1;
    if ( COOVLP == 1 && LOVERLD > 0.0 && UC_NOVER > 0.0 ) begin
        Vgbgmt = Vgsi - Vbsi ;
        Vxbgmt = Vdsi - Vbsi ;
        Nover_func = UC_NOVER ;
        Lover_func = 0.0 ; //not used in this additional calculation
        Wdep_func  = Wdep ;
        cnst0over_func = cnst0over ;
        Cox0_func = Coxb0; //added
        begin : HSMHVevalQover_qov_rdr
// ---- begin `include "HSMHV_eval_qover.inc" ----
/***********************************************************************

 HiSIM (Hiroshima University STARC IGFET Model)
 Copyright (C) 2000-2016 Hiroshima University and STARC
 Copyright (C) 2016-2023 Hiroshima University
 HiSIM_HV (High-Voltage Model)
 Copyright (C) 2007-2016 Hiroshima University and STARC
 Copyright (C) 2016-2023 Hiroshima University

 MODEL NAME : HiSIM_HV
 ( VERSION : 2  SUBVERSION : 5  REVISION : 1 )
 Model Parameter 'VERSION' : 2.51
 FILE : HSMHV_eval_qover.inc

 Date : 2023.02.09

 released by Hiroshima University

***********************************************************************/
//
////////////////////////////////////////////////////////////////
//
//
//
//
//Licensed under the Educational Community License, Version 2.0
//(the "License"); you may not use this file except in
//compliance with the License.
//
//You may obtain a copy of the License at:
//
//      http://opensource.org/licenses/ECL-2.0
//
//Unless required by applicable law or agreed to in writing,
//software distributed under the License is distributed on an
//"AS IS" BASIS, WITHOUT WARRANTIES OR CONDITIONS OF ANY KIND,
//either express or implied. See the License for the specific
//language governing permissions and limitations under the
//License.
//
//
//The HiSIM_HV standard has been supported by the members of
//Silicon Integration Initiative's Compact Model Coalition. A
//link to the most recent version of this standard can be found
//at:
//
//http://www.si2.org/cmc
//
////////////////////////////////////////////////////////////////
//

// begin : HSMHVevalQover //
real WdLD , Q_dep_LD , q_NsubLD ;
real Vx; // auxiliary
integer flg_ovzone_intheloop;
real Pb2over, Vbs_max_over, Vbs_bnd_over;
`ifdef _COFDISPLAY_
    real QsuLD_ini , QbuLD_ini ;
    integer probe_lp_s0;
`endif
integer flg_FD_mode;
real Ps0LD_ini; //for fully iterative Ps0LD (COQOVSM=4)
real fbsq, fbsq_dPss; //for fully iterative Ps0LD (COQOVSM=4)
Vbs_bnd_over = 0.4; //necessary initial value
flg_ovzone_intheloop = 0;
`ifdef _COFDISPLAY_
    probe_lp_s0 = 0; //initialized for debug printing
`endif
flg_FD_mode = 0; //necessary initial value
fb = 0.0 ; fs01 = 0.0 ; fs02 = 0.0 ; //initialized for debug printing
Fs0 =0.0; dPs0=0.0; //initialized for debug printing
Fs0_dPs0 = 0.0; fs02_dPs0 = 0.0; fb_dPss = 0.0; fs01_dPs0 = 0.0; //initialized for debug printing
Chi_1 = 0.0 ; Chi_A = 0.0 ; Chi_B = 0.0 ; //initialized for debug printing
flg_conv = -1 ; //initialized for debug printing
Ps0LD_ini = 0; //for fully iterative Ps0LD (COQOVSM=4)
fbsq = 0; //for fully iterative Ps0LD (COQOVSM=4)

//---------------------------------------------------*
//* Determine clamping limits for too large bulk bias for parasitic PMOS capacitor (-Vxbgmt).
//*-----------------//
Pb2over =  2.0e0 * beta_inv * ln (Nover_func / Nin) ;
`Fn_SU( Vbs_max_over , Pb2over , 0.8 , 0.1 , T0 )
if ( Vbs_bnd_over > Vbs_max_over * 0.5 ) begin
    Vbs_bnd_over = 0.5 * Vbs_max_over ;
end

//updates when VBFWDMX and VBFWDBND are given:
if ($param_given(VBFWDMX)) begin
    Vbs_max_over = VBFWDMX; //user-defined value
end
if ($param_given(VBFWDBND)) begin
    Vbs_bnd_over = VBFWDBND; //user-defined value
end else begin
    if ($param_given(VBFWDMX)) begin
        Vbs_bnd_over = 0.5 * Vbs_max_over; //based on the user-defined value
    end
end
if ( Vbs_bnd_over > Vbs_max_over * 0.5 ) begin
    Vbs_bnd_over = 0.5 * Vbs_max_over ;
end

//---------------------------------------------------*
//* Clamp -Vxbgmt.
//*-----------------//
if ( COQOVCL == 1) begin
    T0 = - Vxbgmt;
    if ( T0 > Vbs_bnd_over ) begin
        T1 =    T0   - Vbs_bnd_over;
        T2 =    Vbs_max_over    - Vbs_bnd_over;
        `Fn_SUPoly4m( TY, T1, T2, T11, T0 )
        T10 = Vbs_bnd_over + TY ;
    end  else begin
        T10 = T0 ;
    end
    Vxbgmtcl = - T10  ;
end // if ( COQOVCL == 1)
else begin
    Vxbgmtcl = Vxbgmt;  // no clamp
end // else: !if( COQOVCL == 1)

fac1 = cnst0over_func / Cox0_func ;
fac1p2 = fac1 * fac1 ;
VgpLD = - Vgbgmt + UC_VFBOVER;
Vgb_fb_LD =  - Vxbgmtcl + `epsm10 ;
Q_dep_LD  =  0.0 ;
q_NsubLD = `C_QE * Nover_func ;

T0 = Nin / Nover_func;
cnst1over = T0 * T0;                 //moved from the case ( COQOVSM > 0 ) below
//exp_bVbs = exp( beta * -Vxbgmtcl ) ; //moved from the case ( COQOVSM > 0 ) below
`Fn_DExp( exp_bVbs , ( beta * -Vxbgmtcl ) , T0)

if ( flg_never_reach_vfbover ) begin
    // ceiling (VgpLD + Vxbgmtcl) less than 0 and feed back to Vxbgmtcl:
    //--> never enters the depletion region.
    `Fn_SL(T1, (-VgpLD*`VXBGMTDLT)  , 0.5, 1 , T0 )
    `Fn_SU_CP(T1, (VgpLD + Vxbgmtcl), 0.0, T1, 1, T0)
    Vxbgmtcl = T1 - VgpLD;
    Vgb_fb_LD =  - Vxbgmtcl + `epsm10 ;
end

//-----------------------------------*
//* QsuLD: total charge = Accumulation | Depletion+inversion
//*-----------------//
if ( VgpLD  < Vgb_fb_LD ) begin
    //---------------------------*
    //* Accumulation
    //*-----------------//
    flg_ovzone = -1 ;
    Ps0_min = 2.0 * beta_inv * ln (-Vgs_min/fac1) ;
    TX = beta * ( VgpLD + Vxbgmtcl ) ;

    T1 = 1.0 / ( beta * cnst0over_func ) ;
    TY = T1 * Cox0_func ;
    Ac41 = 2.0 + 3.0 * `C_SQRT_2 * TY ;
    Ac4 = 8.0 * Ac41 * Ac41 * Ac41 ;
    Ac31 = 7.0 * `C_SQRT_2 - 9.0 * TY * ( TX - 2.0 ) ;
    Ac3 = Ac31 * Ac31 ;
    if ( Ac4 < Ac3*1.0e-8 ) begin
        flg_ovzone = -2 ;
        Ac1 = 0.5 * Ac4 / Ac31 ;
    end else begin
        Ac2 = sqrt( Ac4 + Ac3 ) ;
        Ac1 = -Ac31 + Ac2 ;
    end
    Acd = pow( Ac1 , `C_1o3 ) ;
    Acn = -4.0 * `C_SQRT_2 - 12.0 * TY + 2.0 * Acd + `C_SQRT_2 * Acd * Acd ;
    Chi = Acn / Acd ;

    T1 = Chi * beta_inv ;
    T2 = T1 / Ps0_min ;
    T3 = sqrt( 1.0 + ( T2 * T2 ) ) ;
    Ps0LD = T1 / T3 - Vxbgmtcl ;
    T2 = ( VgpLD - Ps0LD ) ;
    QsuLD = Cox0_func * T2 ;

    QbuLD = QsuLD ;

`ifdef _COFDISPLAY_
        QsuLD_ini = QsuLD ;
        QbuLD_ini = QbuLD ;
`endif
    Ps0LD_ini = Ps0LD ; //for fully iterative Ps0LD (COQOVSM=4)

end else begin

    //---------------------------*
    //* Depletion and inversion
    //*-----------------//

    // initial value for a few fixpoint iterations
    //to get Ps0_iniA from simplified Poisson equation: //
    if ( beta * ( VgpLD + Vxbgmtcl ) < 1.0e0 + ( `epsm10 - 1.0e0 ) * fac1p2 * beta2 / 4.0e0 ) begin //equivalent to (TX < `epsm10)
        Ps0_iniA = VgpLD + fac1p2 * beta / 2.0e0  ;
    end else begin
        TX = 1.0e0 + 4.0e0 * ( beta * ( VgpLD + Vxbgmtcl ) - 1.0e0 ) / ( fac1p2 * beta2 ) ;
        Ps0_iniA = VgpLD + fac1p2 * beta / 2.0e0 * ( 1.0e0 - sqrt( TX ) ) ;
    end
    Chi = beta * ( Ps0_iniA + Vxbgmtcl ) ;

    if ( Chi >= `znbd3 ) begin
        flg_ovzone = 2 ;
        // 1 .. 2 relaxation steps should be sufficient //
        for ( lp_ld = 1; lp_ld <= 2; lp_ld = lp_ld + 1 ) begin
            TY = exp(-Chi);
            TX = 1.0e0 + 4.0e0 * ( beta * ( VgpLD + Vxbgmtcl ) - 1.0e0 + TY ) / ( fac1p2 * beta2 ) ;
            Ps0_iniA = VgpLD + fac1p2 * beta / 2.0e0 * ( 1.0e0 - sqrt( TX ) ) ;
            Chi = beta * ( Ps0_iniA + Vxbgmtcl ) ;
        end // End of iteration //
    end else begin
        flg_ovzone = 1 ;

        //-----------------------------------*
        //* zone-D1
        //* - Ps0_iniA is the analytical solution of QovLD=Qb0 with
        //*   Qb0 being approximated by 3-degree polynomial.
        //*
        //*   new: Inclusion of exp(-Chi) term at right border
        //*-----------------//
        Ta =  1.0/(9.0*sqrt(2.0)) - (5.0+7.0*exp(-3.0)) / (54.0*sqrt(2.0+exp(-3.0)));
        Tb = (1.0+exp(-3.0)) / (2.0*sqrt(2.0+exp(-3.0))) - sqrt(2.0) / 3.0;
        Tc =  1.0/sqrt(2.0) + 1.0/(beta*fac1);
        Td = - (VgpLD + Vxbgmtcl) / fac1;
        Tq = Tb*Tb*Tb / (27.0*Ta*Ta*Ta) - Tb*Tc/(6.0*Ta*Ta) + Td/(2.0*Ta);
        Tp = (3.0*Ta*Tc-Tb*Tb)/(9.0*Ta*Ta);
        T5 = sqrt(Tq*Tq + Tp*Tp*Tp);
        Tu = pow(-Tq + T5,`C_1o3);
        Tv = -pow(Tq + T5,`C_1o3);
        Chi = Tu + Tv - Tb/(3.0*Ta);
        Ps0_iniA = Chi * beta_inv - Vxbgmtcl ;
    end

    if ( COQOVSM > 0 ) begin
        //-----------------------------------*
        //* - Ps0_iniB : upper bound.
        //*-----------------//
        VgpLD_shift = VgpLD + Vxbgmtcl + 0.1;
        //

        cfs1 = cnst1over * exp_bVbs ;
        gammaChi = cnst1over * exp_bVbs;
        T0  = beta2 * fac1p2;
        psi = beta*VgpLD_shift;
        Chi_1 = ln (gammaChi*T0 + psi*psi) - ln (cnst1over*T0) + beta*Vxbgmtcl;
        if ( COQOVSM == 2 ) begin
            `Fn_SU( Chi_1, Chi_1, psi, 1.0, T1 )
        end else begin
            Chi_1 = `Fn_Min( Chi_1, psi ); // clipping to keep the original curve (Initial guess doesn't need to be continuous.)
        end
        Chi_1 = `Fn_Max( Chi_1, 0.0 ); // protection for the unclamped beta*Vxbgmtcl when COQOVCL=0

        // 1 fixpoint step for getting more accurate Chi_B //
        psi = psi - Chi_1 ;
        psi = psi + beta*0.1 ;
        T1 = ln (gammaChi*T0 + psi*psi) - ln (cnst1over*T0) ;
        Chi_B = T1 + beta*Vxbgmtcl ;
        Chi_B = `Fn_Max( Chi_B, 0.0 ); // protection for the unclamped beta*Vxbgmtcl when COQOVCL=0

        // construction of Ps0LD by taking Ps0_iniB as an upper limit of Ps0_iniA
        //*
        //* Limiting is done for Chi rather than for Ps0LD, to avoid shifting
        //* for Fn_SU //
        Chi_A = Chi;
        if ( COQOVSM == 2 ) begin
            `Fn_SU_CP( Chi, Chi_A, Chi_B, 0.2*Chi_B, 2, T1 )
        end else begin
            Chi = `Fn_Min( Chi_A, Chi_B ); // clipping to keep the original curve (Initial guess doesn't need to be continuous.)
        end

    end

    // update_of_initial_guess_for_FD_mode
    if ( COQOVSM == 1 ) begin
        //----------------------------//
        // temporary_Chib_for_FD_mode //
        //----------------------------//

        Ps0LD = Chi* beta_inv - Vxbgmtcl ; // updating Ps0LD //

        // calc. effective DDRIFT with p-n junction
        if ( Wdep_func > 0.0 ) begin
            T2 = `DDRIFT - Wdep_func ;
        end else begin
            `Fn_SZ( T2 , (Vdsi + VBI) , 0.1 , T9 )
            Wjunc0 = sqrt ( kjunc * T2 ) * QOVJUNC ;
            T2 = `DDRIFT - Wjunc0 ;
        end
        `Fn_SZ( T2 , T2 , `DDRIFT * 0.01 , T9 )
        ddriftldc = T2 ;

        dphi_sb = q_NsubLD * ddriftldc * ddriftldc / 2.0 / `C_ESI ;
        T0 = sqrt(2.0 * beta * dphi_sb) ;
        T1 = (lexp(T0) + lexp(-T0)) / 2 ;
        c_sb = ln(T1) / dphi_sb ;

        Ps0LD_Vxb = Ps0LD + Vxbgmtcl ;
        TY = c_sb * ( Ps0LD_Vxb - dphi_sb ) ;
        if ( TY  < `large_arg ) begin
            T1 = exp(TY) ;
            T0 = exp(- c_sb * dphi_sb) ;
            T2 = T1 - T0 ;
            phi_b = ln(1 + T2) / c_sb ;
        end else begin
            phi_b = Ps0LD_Vxb - dphi_sb ;
        end
        Chib = beta * phi_b ;

        if ( Chib > Chi/100 && Chib > 0 ) begin //FD-mode correction for Vgs dependence:
            flg_FD_mode = flg_FD_mode + 1; // FD mode
            Chi = Chi_1;
        end
    end // if ( COQOVSM == 1 )

    // updating Ps0LD //
    Ps0LD = Chi* beta_inv - Vxbgmtcl ;

    if (abs(Chi)> 1e-6) begin   // 20161012
        T1 = Chi - 1.0 + exp(-Chi);
        T2 = sqrt(T1);
    end else begin
        flg_ovzone = flg_ovzone + 4; //very close to flatband
        // T2 = `C_1oSQRT2*Chi;
        // further alternative:
        //  // Chi - 1.0 + exp(-Chi) = (1/2)*Chi*Chi*(1- (1/3)*Chi)
        //  u = 1.0 - Chi * `C_1to3;
        //  T2 = `C_1oSQRT2* Chi* sqrt(u);
        T2 =`C_1oSQRT2* Chi* sqrt( 1.0 - Chi * `C_1o3); // 20200727
    end
    QbuLD = cnst0over_func * T2 ;

    //-----------------------------------------------------------*
    //* QsuLD : Qovs or Qovd in unit area.
    //* note: QsuLD = Qdep+Qinv.
    //*-----------------//
    QsuLD = Cox0_func * ( VgpLD - Ps0LD ) ;

    // 2nd_update_of_initial_guess_for_FD_mode
    begin : FD_mode
        real WdLD0, Ps0LD_bef1;

        WdLD0 = QbuLD / q_NsubLD ;
        if ( COQOVSM == 2 ) begin
            `Fn_SU_CP( T1 , WdLD0 , ddriftldc , ddriftldc*0.1 , 2 , T0 )
            if ( T0 < 1.0) begin
                flg_FD_mode = flg_FD_mode + 2; // FD mode
            end
        end else begin
            T1 = `Fn_Min( WdLD0, ddriftldc );
            if ( WdLD0 >= ddriftldc ) begin
                flg_FD_mode = flg_FD_mode + 2; // FD mode
            end
        end

        if ( flg_FD_mode >= 2 ) begin // FD-mode correction for large Vds:
            Ps0LD_bef1 = Ps0LD;
            QbuLD = T1 * q_NsubLD ;
            Ps0LD = VgpLD - QbuLD / Cox0_func ; // QsuLD = QbuLD w/o Qinv
            if ( COQOVSM == 2 ) begin
                `Fn_SU_CP( Ps0LD , Ps0LD, Ps0LD_bef1 , 0.1 , 2 , T0 )
            end else begin
                Ps0LD = `Fn_Min( Ps0LD, Ps0LD_bef1 );
            end
        end

    end // block: FD_mode

`ifdef _COFDISPLAY_
        QsuLD_ini = QsuLD ;
        QbuLD_ini = QbuLD ;
`endif
    Ps0LD_ini = Ps0LD ; //for fully iterative Ps0LD (COQOVSM=4)

    if ( COQOVSM == 1 ) begin // Dynamic Depletion Model //

        //---------------------------------------------------*
        //* Calculation of Ps0. (beginning of Newton loop)
        //* - Fs0 : Fs0 = 0 is the equation to be solved.
        //* - dPs0 : correction value.
        //*-----------------//
        flg_conv = 0 ;
        C_W_LD = sqrt(2.0 * (`C_ESI / q_NsubLD * beta_inv)) ;
        // calc. effective DDRIFT with p-n junction
        if ( Wdep_func > 0.0 ) begin
            T2 = `DDRIFT - Wdep_func ;
        end else begin
            `Fn_SZ( T2 , (Vdsi + VBI) , 0.1 , T9 )
            Wjunc0 = sqrt ( kjunc * T2 ) * QOVJUNC ;
            T2 = `DDRIFT - Wjunc0 ;
        end
        `Fn_SZ( T2 , T2 , `DDRIFT * 0.01 , T9 )
        ddriftldc = T2 ;

        dphi_sb = q_NsubLD * ddriftldc * ddriftldc / 2.0 / `C_ESI ;
        T0 = sqrt(2.0 * beta * dphi_sb) ;
        T1 = (lexp(T0) + lexp(-T0)) / 2 ;
        c_sb = ln(T1) / dphi_sb ;

        for ( lp_s0 = 1 ; lp_s0 <= lp_s0_max + 1 ; lp_s0 = lp_s0 + 1 ) begin
            if ( i_over == 3 ) begin
                OP_lp_ld = lp_s0 - 1 ;
            end
`ifdef _COFDISPLAY_
                probe_lp_s0 = lp_s0 - 1; // -1 is necessary to correct the counts
`endif
            flg_ovzone_intheloop = 0;

            Ps0LD_Vxb = Ps0LD + Vxbgmtcl ;
            Chi = beta * Ps0LD_Vxb ;

            TY = c_sb * ( Ps0LD_Vxb - dphi_sb ) ;
            if ( TY  < `large_arg ) begin
                T1 = exp(TY) ;
                T0 = exp(- c_sb * dphi_sb) ;
                T2 = T1 - T0 ;
                phi_b = ln(1 + T2) / c_sb ;
                phi_b_dPss = T1 / (1 + T2) ;
            end else begin
                flg_ovzone_intheloop = flg_ovzone_intheloop + 8 ; //possible case
                phi_b = Ps0LD_Vxb - dphi_sb ;
                phi_b_dPss = 1 ;
            end
            Chib = beta * phi_b ;

            if (Chi < 0) begin
                flg_ovzone_intheloop = flg_ovzone_intheloop + 64 ; //unexpected case
                T0 = - `C_1oSQRT2 ; //derived with 2nd-order Maclaurin series
                fb = Chi * T0 ;
                fb_dPss = beta * T0 ;
            end else if (Chi < 1E-6) begin
                flg_ovzone_intheloop = flg_ovzone_intheloop + 32 ; //rare case
                T0 = Chi * Chi / 2 * (1 - Chi / 3 * (1 - Chi / 4 * (1 - Chi / 5))) ;
                T1 = Chi * (1 - Chi / 2 * (1 - Chi / 3 * (1 - Chi / 4))) ;
                T2 = Chib * Chib / 2 * (1 - Chib / 3 * (1 - Chib / 4 * (1 - Chib / 5))) ;
                T3 = Chib * (1 - Chib / 2 * (1 - Chib / 3 * (1 - Chib / 4))) ;
                T4 = T0 - T2 ;
                if ( T4 > 0.0 ) begin
                    fb = sqrt(T4) ;
                    fb_dPss = beta * 0.5 * (T1 - phi_b_dPss * T3) / fb ;
                end else begin
                    flg_ovzone_intheloop = flg_ovzone_intheloop + 256 ; //FPE case
                    fb = 0.0 ;
                    fb_dPss = 0.0 ;
                end
            end else begin
                //-------------------------------------------*
                //* zone-D3.  (Ps0LD)
                //*-----------------//
                T0 = exp(-Chi) ;
                T1 = exp(-Chib) ;
                T4 = Chi - Chib + (T0 - T1) ;
                if ( T4 > 0.0 ) begin
                    fb = sqrt(T4) ;
                    fb_dPss = beta * 0.5 * (1 - T0 - phi_b_dPss * (1 - T1)) / fb ;
                end else begin
                    flg_ovzone_intheloop = flg_ovzone_intheloop + 512 ; //FPE case
                    fb = 0.0 ;
                    fb_dPss = 0.0 ;
                end
            end //

            if (Chi < 0) begin
                flg_ovzone_intheloop = flg_ovzone_intheloop + 128 ; //unexpected case
                fs01 = 0.0 ;
                fs01_dPs0 = 0.0 ;
                fs02 = -fb ;
                fs02_dPs0 = -fb_dPss ;
            end else begin
                if ( Chi < `large_arg ) begin // avoid exp_Chi to become extremely large
                    if ( Chi < 5.0e-5 ) begin
                        T0 = Chi * Chi / 2 * (1 + Chi / 3 * (1 + Chi / 4 * (1 + Chi / 5))) ;
                        T1 = Chi * (1 + Chi / 2 * (1 + Chi / 3 * (1 + Chi / 4))) ;
                        fs01 = cfs1 * T0 ;
                        fs01_dPs0 = cfs1 * T1 * beta ;
                    end else begin
                        exp_Chi = exp( Chi ) ;
                        T1 = exp_Chi - 1 ;
                        fs01 = cfs1 * ( T1 - Chi ) ;
                        fs01_dPs0 = cfs1 * beta * ( T1 ) ;
                    end
                end else begin
                    flg_ovzone_intheloop = flg_ovzone_intheloop + 16 ; //possible case
                    exp_bPs0 = exp( beta*Ps0LD ) ;
                    fs01 = cnst1over * ( exp_bPs0 - exp_bVbs * (Chi + 1) ) ;
                    fs01_dPs0 = cnst1over * beta * ( exp_bPs0 - exp_bVbs ) ;
                end
                if ( fs01 > 0.0 ) begin //original:
                    fs02 = sqrt(fb * fb + fs01) ;
                    fs02_dPs0 = 0.5 * (2 * fb_dPss * fb + fs01_dPs0) / fs02 ;
                end else begin //simplified to avoid division by zero:
                    flg_ovzone_intheloop = flg_ovzone_intheloop + 1024 ; //simplified case
                    fs02 = fb ;
                    fs02_dPs0 = fb_dPss ;
                end
            end

            // Revised Fs0 //
            Fs0 = - VgpLD + Ps0LD + fac1 * fs02 ;
            Fs0_dPs0 = 1.0 + fac1 * fs02_dPs0 ;
            //          lp_s0_LD = lp_s0 ;
            if ( flg_conv == 1 ) begin
                lp_s0 = lp_s0_max+1 ; // break
            end else begin
                dPs0 = - Fs0 / Fs0_dPs0 ;

                //-------------------------------------------*
                //* Update Ps0 .
                //* - clamped to Vbcs_cl if Ps0 < Vbcs_cl .
                //*-----------------//
                dPlim = 0.5*`dP_max*(1.0 + `Fn_Max(1.0e0,abs(Ps0LD))) ;
                if ( abs( dPs0 ) > dPlim ) dPs0 = dPlim * `Fn_Sgn( dPs0 ) ;
                Ps0LD = Ps0LD + dPs0 ;

                //-------------------------------------------*
                //* Check convergence.
                //* NOTE: This condition may be too rigid.
                //*-----------------//
                if ( abs( dPs0 ) <= `ps_conv && abs( Fs0 ) <= `gs_conv ) begin
                    flg_conv = 1 ;
                end

            end

        end // end of Ps0LD Newton loop //

        //-------------------------------------------*
        //* Procedure for diverged case.
        //*-----------------//
        if ( flg_conv == 0 ) begin
            $write( "*** warning(HiSIM_HV(%m)): Went Over Iteration Maximum(Ps0LD)\n" ) ;
            $write(" -Vxbgmtcl = %e   Vgbgmt = %e\n" , -Vxbgmtcl , Vgbgmt ) ;
        end

        //-----------------------------------*
        //* Xi0p12
        //*-----------------//
        WdLD = C_W_LD * fb ;
        Q_dep_LD = q_NsubLD * WdLD ;
        Xi0p12 = Q_dep_LD / cnst0over_func + `epsm10 ;

        //-----------------------------------------------------------*
        //* QbuLD and QiuLD
        //*-----------------//
        QbuLD = cnst0over_func * Xi0p12 ;
        T1 = 1.0 / ( fs02 + Xi0p12 ) ;
        QiuLD = cnst0over_func * fs01 * T1 ;

        //-----------------------------------------------------------*
        //* Total overlap charge
        //*-----------------//
        QsuLD = QbuLD + QiuLD;

    end // COQOVSM=1 //
end // end of Vgbgmt region blocks //

if ( COQOVSM == 4 ) begin : FULLY_ITERATIVE_PS0LD

    exp_bVbs = exp( beta * -Vxbgmtcl ) ;
    T0 = Nin / Nover_func;
    cnst1over = T0 * T0;
    cfs1 = cnst1over * exp_bVbs ;

    Ps0LD = Ps0LD_ini ;

    //---------------------------------------------------*
    //* Calculation of Ps0. (beginning of Newton loop)
    //* - Fs0 : Fs0 = 0 is the equation to be solved.
    //* - dPs0 : correction value.
    //*-----------------//
    flg_conv = 0 ;
    C_W_LD = sqrt(2.0 * (`C_ESI / q_NsubLD * beta_inv)) ;
    // calc. effective DDRIFT with p-n junction
    if ( Wdep_func > 0.0 ) begin
        T2 = `DDRIFT - Wdep_func ;
    end else begin
        `Fn_SZ( T2 , (Vdsi + VBI) , 0.1 , T9 )
        Wjunc0 = sqrt ( kjunc * T2 ) * QOVJUNC ;
        T2 = `DDRIFT - Wjunc0 ;
    end
    `Fn_SZ( T2 , T2 , `DDRIFT * 0.01 , T9 )
    ddriftldc = T2 ;

    dphi_sb = q_NsubLD * ddriftldc * ddriftldc / 2.0 / `C_ESI ;
    T0 = sqrt(2.0 * beta * dphi_sb) ;
    T1 = (lexp(T0) + lexp(-T0)) / 2 ;
    c_sb = ln(T1) / dphi_sb ;

    for ( lp_s0 = 1 ; lp_s0 <= lp_s0_max + 1 ; lp_s0 = lp_s0 + 1 ) begin
        if ( i_over == 3 ) begin
            OP_lp_ld = lp_s0 - 1 ;
        end
`ifdef _COFDISPLAY_
            probe_lp_s0 = lp_s0 - 1; // -1 is necessary to correct the counts
`endif
        flg_ovzone_intheloop = 0;

        Ps0LD_Vxb = Ps0LD + Vxbgmtcl ;
        Chi = beta * Ps0LD_Vxb ;

        TY = c_sb * ( Ps0LD_Vxb - dphi_sb ) ;
        if ( TY  < `large_arg ) begin
            T1 = exp(TY) ;
            T0 = exp(- c_sb * dphi_sb) ;
            T2 = T1 - T0 ;
            phi_b = ln(1 + T2) / c_sb ;
            phi_b_dPss = T1 / (1 + T2) ;
        end else begin
            phi_b = Ps0LD_Vxb - dphi_sb ;
            phi_b_dPss = 1 ;
        end
        Chib = beta * phi_b ;

        if ( abs(Chi) < 1.0e-6 ) begin
            flg_ovzone_intheloop = `Fn_Sgn(Chi)*1;
            T0 = Chi * Chi / 2 * (1 - Chi / 3 * (1 - Chi / 4 * (1 - Chi / 5))) ;
            T1 = Chi * (1 - Chi / 2 * (1 - Chi / 3 * (1 - Chi / 4))) ;
            T2 = Chib * Chib / 2 * (1 - Chib / 3 * (1 - Chib / 4 * (1 - Chib / 5))) ;
            T3 = Chib * (1 - Chib / 2 * (1 - Chib / 3 * (1 - Chib / 4))) ;
            fbsq = T0 - T2 ;
            fbsq_dPss = beta * (T1 - phi_b_dPss * T3) ;
        end else begin
            flg_ovzone_intheloop = `Fn_Sgn(Chi)*2;
            T0 = exp(-Chi) ;
            T1 = exp(-Chib) ;
            fbsq = (Chi - Chib + (T0 - T1)) ;  // main equation of fbsq
            fbsq_dPss = beta * (1 - T0 - phi_b_dPss * (1 - T1)) ;
        end

        if ( abs(Chi) < 5.0e-5 ) begin
            T0 = Chi * Chi / 2 * (1 + Chi / 3 * (1 + Chi / 4 * (1 + Chi / 5))) ;
            T1 = Chi * (1 + Chi / 2 * (1 + Chi / 3 * (1 + Chi / 4))) ;
            fs01 = cfs1 * T0 ;
            fs01_dPs0 = cfs1 * T1 * beta ;
        end else begin // if ( abs(Chi) < 5.0e-5 )

            if ( abs(Chi) < `large_arg ) begin
                flg_ovzone_intheloop = `Fn_Sgn(Chi)*3;
                exp_Chi = exp( Chi ) ;
                T1 = exp_Chi - 1 ;
                fs01 = cfs1 * ( T1 - Chi ) ;  // main equation of fs01
                fs01_dPs0 = cfs1 * beta * ( T1 ) ;
            end else begin
                flg_ovzone_intheloop = `Fn_Sgn(Chi)*4;
                exp_bPs0 = exp( beta*Ps0LD ) ;
                fs01 = cnst1over * ( exp_bPs0 - exp_bVbs * (Chi + 1) ) ;
                fs01_dPs0 = cnst1over * beta * ( exp_bPs0 - exp_bVbs ) ;
            end

        end // else: !if( abs(Chi) < 5.0e-5 )

        if (fs01 > 0.0) begin
            fs02 = sqrt(fbsq + fs01) ;  // main equation of fs02
            fs02_dPs0 = 0.5 * (fbsq_dPss + fs01_dPs0) / fs02 ;
        end else begin
            if (fbsq > 0.0) begin
                fs02 = sqrt(fbsq) ;
                fs02_dPs0 = 0.5 * (fbsq_dPss) / fs02 ;
            end else begin
                fs02 = 0.0 ;
                fs02_dPs0 = 0.0 ;
            end
        end

        fs02 =      `Fn_Sgn(Chi) * fs02 ;
        fs02_dPs0 = `Fn_Sgn(Chi) * fs02_dPs0 ;

        // Revised Fs0 //
        Fs0 = - VgpLD + Ps0LD + fac1 * fs02 ;
        Fs0_dPs0 = 1.0 + fac1 * fs02_dPs0 ;
        if ( flg_conv > 0 ) begin
            lp_s0 = lp_s0_max+1 ; // break
        end else begin
            dPs0 = - Fs0 / Fs0_dPs0 ;

            //-------------------------------------------*
            //* Update Ps0 .
            //* - clamped to Vbcs_cl if Ps0 < Vbcs_cl .
            //*-----------------//
            dPlim = 0.5*`dP_max*(1.0 + `Fn_Max(1.0e0,abs(Ps0LD))) ;
            if ( abs( dPs0 ) > dPlim ) dPs0 = dPlim * `Fn_Sgn( dPs0 ) ;
            Ps0LD = Ps0LD + dPs0 ;

            //-------------------------------------------*
            //* Check convergence.
            //* NOTE: This condition may be too rigid.
            //*-----------------//
            if ( abs( dPs0 ) <= `ps_conv && abs( Fs0 ) <= `gs_conv ) begin
                flg_conv = flg_conv + 2 ; //conventional criterion
            end

        end

    end // end of Ps0LD Newton loop //

    //-------------------------------------------*
    //* Procedure for diverged case.
    //*-----------------//
    if ( flg_conv == 0 ) begin
        $write( "*** warning(HiSIM_HV(%m)): Went Over Iteration Maximum(Ps0LD fully iterative)\n" ) ;
        $write(" -Vxbgmtcl = %e   Vgbgmt = %e\n" , -Vxbgmtcl , Vgbgmt ) ;
    end

    //-----------------------------------*
    //* Xi0p12
    //*-----------------//
    fb = (fbsq>=0)? `Fn_Sgn(Chi)*sqrt(fbsq) : 0 ;
    WdLD = C_W_LD * fb ;
    Q_dep_LD = q_NsubLD * WdLD ;
    Xi0p12 = Q_dep_LD / cnst0over_func + `epsm10 ;

    //-----------------------------------------------------------*
    //* QbuLD and QiuLD
    //*-----------------//
    QbuLD = cnst0over_func * Xi0p12 ;
    T1 = 1.0 / ( fs02 + Xi0p12 ) ;
    QiuLD = cnst0over_func * fs01 * T1 ;

    //-----------------------------------------------------------*
    //* Total overlap charge
    //*-----------------//
    QsuLD = QbuLD + QiuLD;

end // block: FULLY_ITERATIVE_PS0LD

// inversion charge = total - depletion //
QiuLD = QsuLD - QbuLD  ;

// calc. bias dependent Lover
// 2.4.0's codes reside in HSMHV_LoverLim.inc 20170825
if ( Lover_func < 0.0 ) begin
    Lover_func = - Lover_func ; // now, Lover_func positive
    if (COTRENCH == 0) begin  // COTRENCH=0 only
        if ( COOVJUNC == 0 ) begin
            Vx = -Ps0LD; // original implementation
        end else begin
            Vx = Vxbgmt; // more correct implementation (2.4.0)
        end
        `Fn_SZ( T2 , ( Vx + VBI) , 0.1 , T9 )
        Wjunc0 = sqrt ( kjunc * T2 ) * QOVJUNC ;
        `Fn_SU( Wjuncld, Wjunc0, Lover_func, 0.1 * Lover_func, T0 )
        Lover_func = Lover_func - Wjuncld ;
    end
end
// end of HSMHVevalQover //
// ---- end `include "HSMHV_eval_qover.inc" ----
        end
        RD_QbuLD = QbuLD ;
    end // flg_COOVLP = 1;
end //

//-----------------------------------*
//* Simplified model
//* Source side [S'] not (s'); whereas (s') can be either of [S'] or [D'] within the intrinsic MOSFET part
//*-----------------//
if ( COOVLPS == 1 && LOVERS > 0.0 && UC_NOVERS == 0.0 ) begin
    flg_COOVLPS = 1 ;
    cov_slp = MKS_OVSLP ;
    cov_mag = OVMAG ;
    T1 = Cox0 * weffcv_nf ;
    if (mode == `HiSIM_NORMAL_MODE) begin
        T4 = cov_slp * T1 * ( cov_mag + Vgs ) ;   //  V(g)(s) == V[G][S]
        T5 = LOVERS * T1 ;
        T9 = 1.2e0 - Ps0 ; // [S]
        Qgos = Vgs * T5 - T4 * T9; // 20200712
    end else begin
        T4 = cov_slp * T1 * ( cov_mag + Vgs - Vds ) ; //  V(g)(d) = V[G][S]
        //T5 = LOVERLD * T1 ;
        T5 = LOVERS * T1; // 20200712
        T9 = 1.2e0 + Vds - Psl ; // as is
        Qgos = (Vgs - Vds) * T5 - T4 * T9; // 20200712
    end
    //Qgos = Vgs * T5 - T4 * T9 ;  commented
end
//-----------------------------------*
//* Simplified model
//* Drain side [D'] not (d'); whereas (d') can be either of [D'] or [S'] within the intrinsic MOSFET part
//*-----------------//
if ( COOVLP == 1 && LOVERLD > 0.0 && UC_NOVER == 0.0 ) begin
    flg_COOVLP = 1 ;
    cov_slp = MKS_OVSLP ;
    cov_mag = OVMAG ;
    T1 = Coxb0 * weffcv_nf ;
    if (mode == `HiSIM_NORMAL_MODE) begin
        T4 = cov_slp * T1 * ( cov_mag + Vgs - Vds ) ; // V(g)(d) = V[G][D]
        T5 = LOVERLD * T1 ;
        T9 = 1.2e0 + Vds - Psl ;
        Qgod = ( Vgs - Vds ) * T5 - T4 * T9 ; // 20200712   V(g)(d) = V[G][D]
    end else begin
        T4 = cov_slp * T1 * ( cov_mag + Vgs ) ; // V(g)(s) = V[G][D]
        //T5 = LOVERS * T1 ; 20200712
        T5 = LOVERLD * T1; // 20200712
        T9 = 1.2e0 - Ps0 ;
        Qgod = Vgs * T5 - T4 * T9; // 20200712 V(g)(s) = V[G][D]
    end
    // Qgod = ( Vgs - Vds ) * T5 - T4 * T9 ; commented 20200712
end
// Thus, Qgos and Qgod are final; independent of Vds-mode in the intrinsic part.

//--------------------------------------*
//* Additional constant capacitance model
//* Source side
//*-----------------//
//     Cgos = - Cox0 * LOVERS * weffcv_nf ;
//     Qgos = - Cgos * Vgsi ;
if ( CGSO_GIVEN ) begin
    Cgsoe = UC_CGSO * ( - weffcv_nf ) ;
end else begin
    if ( flg_COOVLPS == 0 ) begin
        Cgsoe = - Cox0 * LOVERS * weffcv_nf ;
    end
end
Qgso  = - Cgsoe * Vgsei ;

//--------------------------------------*
//* Additional constant capacitance model
//* Drain side
//*-----------------//
//     Cgod = - Cox0 * LOVERLD  * weffcv_nf ;
//     Cgod = Cgod - Coxb0 * UC_WTRENCH * weffcv_nf ;
//     Qgod = - Cgod * (Vgsi - Vdsi) ;
if ( CGDO_GIVEN ) begin
    Cgdoe = UC_CGDO * ( - weffcv_nf ) ;
end else begin
    if ( flg_COOVLP == 0 ) begin
        Cgdoe = - Coxb0 * LOVERLD * weffcv_nf ;
    end
end
Qgdo  = - Cgdoe * (Vgsei - Vdsei) ;

//------------------------------------------------*
//* Additional Vds and Pds depend capacitance model
//*-----------------//
if (mode == `HiSIM_NORMAL_MODE) begin
    QodAD =   QOVADD * ( Vds - Pds ) ;
    Qovd_ADD  = T4 * ( QodAD ) ; // T4?
    QbdLD_ADD = T4 * ( QodAD ) ; // T4?
end else begin
    QodAD = - QOVADD * ( Vds - Pds ) ;
    Qovs_ADD  = T4 * ( QodAD ) ; // T4?
    QbsLD_ADD = T4 * ( QodAD ) ; // T4?
end

//-------------------------------------------*
//* Gate/Bulk overlap charge: Qgbo
//*-----------------//
Cgbo_loc = - UC_CGBO * Lgate ;
Qgbo = - Cgbo_loc * (Vgsi -Vbsi) ;
// ---- end `include "HSMHV_eval_Overlap.inc" ----
        end

        //---------------------------------------------------*
        //* Lateral-field-induced capacitance (depends on the Vds mode).
        //*-----------------//
        Aclm = UC_CLM1 ;
        if ( flg_noqi != 0 ) begin
            //-------------------------------------------*
            //* Calculation of Psdl for cases of flg_noqi==1.
            //*-----------------//
            Psdl = Aclm * (Vds + Ps0) + (1.0e0 - Aclm) * Psl ;
`ifdef REPLACE_CLIPPING_WITH_SMOOTHING //revised for continuity (Psdl for Nthrml)
                `Fn_SU_CP(Psdl, Psdl, (Ps0 + Vds - `epsm10), `epsm10, 2, T0)
`else
                if ( Psdl > Ps0 + Vds - `epsm10 ) begin
                    Psdl = Ps0 + Vds - `epsm10 ;
                end
`endif
            if (flg_qy) begin
                Ec = 0.0e0 ;
            end
        end else begin
            // Ec is removed from Lred calc. part //
            if (flg_qy) begin
                if ( Idd < `C_IDD_MIN || Vdseff < `C_VDS_MIN ) begin
                    Ec = 0.0e0 ;
                end else begin
                    Ec = Idd / Qn0 * beta_inv / Leff ;
                end
            end
        end

        if ( flg_qy == 0 ) begin
            Qy = 0.0e0 ;
        end else begin
            T2 = `C_ESI * weffcv_nf * wdpl * 1.3 ;
            if ( XQY != 0.0 ) begin
                Pslk = Ec * Leff + Ps0 ;
                T1 = Aclm * ( Vdsz + Ps0 ) + ( 1.0e0 - Aclm ) * Pslk ;  // 20160525 Vds->Vdsz
                Qy = - ( ( Ps0 + Vdsz  - T1 ) / XQY ) * T2 ; // 20160525 Vds->Vdsz
            end
            if ( XQY1 != 0.0 ) begin
                Qy = Qy + cqyb0 * Vbs ;
            end
        end

        //---------------------------------------------------*
        //* Fringing capacitance.
        //*-----------------//
        Cfd = cfrng ;
        Cfs = cfrng ;
        Qfd = Cfd * ( Vgsei - Vdsei ) ;
        Qfs = Cfs * Vgsei ;

        //-----------------------------------------------------------*
        //* End of PART-3. (label)
        //*-----------------//

        // end_of_part_3:

        //++++++++++++++++++++++++++++++++++++++++++++++++++++++++++++
        //* PART-4: Substrate-source/drain junction diode.
        //*++++++++++++++++++++++++++++++++++++++++++++++++++++++++++++//

`ifdef COEXTDIO
            /* for Junction Diode Model */
`else
// ---- begin `include "HSMHV_eval_dio.inc" ----
/***********************************************************************

 HiSIM (Hiroshima University STARC IGFET Model)
 Copyright (C) 2000-2016 Hiroshima University and STARC
 Copyright (C) 2016-2023 Hiroshima University
 HiSIM_HV (High-Voltage Model)
 Copyright (C) 2007-2016 Hiroshima University and STARC
 Copyright (C) 2016-2023 Hiroshima University

 MODEL NAME : HiSIM_HV
 ( VERSION : 2  SUBVERSION : 5  REVISION : 1 )
 Model Parameter 'VERSION' : 2.51
 FILE : vaFiles/HSMHV_eval_dio.inc

 Date : 2023.02.09

 released by Hiroshima University

***********************************************************************/
//
////////////////////////////////////////////////////////////////
//
//
//
//
//Licensed under the Educational Community License, Version 2.0
//(the "License"); you may not use this file except in
//compliance with the License.
//
//You may obtain a copy of the License at:
//
//      http://opensource.org/licenses/ECL-2.0
//
//Unless required by applicable law or agreed to in writing,
//software distributed under the License is distributed on an
//"AS IS" BASIS, WITHOUT WARRANTIES OR CONDITIONS OF ANY KIND,
//either express or implied. See the License for the specific
//language governing permissions and limitations under the
//License.
//
//
//The HiSIM_HV standard has been supported by the members of
//Silicon Integration Initiative's Compact Model Coalition. A
//link to the most recent version of this standard can be found
//at:
//
//http://www.si2.org/cmc
//
////////////////////////////////////////////////////////////////
//

//-----------------------------------------------------------*
//* Temperature dependent constants.
//*-----------------//
if ( COSELFHEAT > 0 && UC_RTH0 != 0.0 ) begin

// ---- begin `include "HSMHV_temp_eval_dio.inc" ----
/***********************************************************************

 HiSIM (Hiroshima University STARC IGFET Model)
 Copyright (C) 2000-2016 Hiroshima University and STARC
 Copyright (C) 2016-2023 Hiroshima University
 HiSIM_HV (High-Voltage Model)
 Copyright (C) 2007-2016 Hiroshima University and STARC
 Copyright (C) 2016-2023 Hiroshima University

 MODEL NAME : HiSIM_HV
 ( VERSION : 2  SUBVERSION : 5  REVISION : 1 )
 Model Parameter 'VERSION' : 2.51
 FILE : HSMHV_temp_eval_dio.inc

 Date : 2023.02.09

 released by Hiroshima University

***********************************************************************/
//
////////////////////////////////////////////////////////////////
//
//
//
//
//Licensed under the Educational Community License, Version 2.0
//(the "License"); you may not use this file except in
//compliance with the License.
//
//You may obtain a copy of the License at:
//
//      http://opensource.org/licenses/ECL-2.0
//
//Unless required by applicable law or agreed to in writing,
//software distributed under the License is distributed on an
//"AS IS" BASIS, WITHOUT WARRANTIES OR CONDITIONS OF ANY KIND,
//either express or implied. See the License for the specific
//language governing permissions and limitations under the
//License.
//
//
//The HiSIM_HV standard has been supported by the members of
//Silicon Integration Initiative's Compact Model Coalition. A
//link to the most recent version of this standard can be found
//at:
//
//http://www.si2.org/cmc
//
////////////////////////////////////////////////////////////////
//

T0 = Tratio * Tratio ;

// for substrate-drain junction diode. //
`HSMHV_Idio_args1(js,     UC_JS0D,    XTID,  UC_NJD)
`HSMHV_Idio_args1(jssw,   UC_JS0SWD,  XTID,  NJSWD)
`HSMHV_Idio_args1(jsswg,  JS0SWGD,    XTID,  NJSWGD)
`HSMHV_Idio_args1(js2,    UC_JS0D,    XTI2D, UC_NJD)
`HSMHV_Idio_args1(jssw2,  UC_JS0SWD,  XTI2D, NJSWD)
`HSMHV_Idio_args1(jsswg2, JS0SWGD,    XTI2D, NJSWGD)

if ( CODIO > 0 ) begin //new model:
    `HSMHV_Idio_args2(isbd_btm, isbd2_btm, isbd_sws, isbd2_sws, isbd_swg, isbd2_swg, PD, AD)
end else begin //backward compatible:
    `HSMHV_Idio_args2_compat(isbd_btm, isbd2_btm, isbd_sws, isbd2_sws, isbd_swg, isbd2_swg, PD, AD)
end
isbd = isbd_btm + isbd_sws + isbd_swg ;

if ( isbd > 0 ) begin
    T2 = isbd + `Small ; //once removed in Geoffrey01_Small_20160309, but necessary for backward compatibility
    vbdt = UC_NJD / beta * ln( UC_VDIFFJD * T0 / T2 + 1.0 ) ;
    exptempd = exp (( Tratio - 1.0 ) * CTEMPD ) ;
    jd_nvtm_invd = 1.0 / ( UC_NJD / beta ) ;
    jd_expcd = exp (vbdt * jd_nvtm_invd ) ;
end

// for substrate-source junction diode. //
`HSMHV_Idio_args1(js,     UC_JS0S,    XTIS,  UC_NJS)
`HSMHV_Idio_args1(jssw,   UC_JS0SWS,  XTIS,  NJSWS)
`HSMHV_Idio_args1(jsswg,  JS0SWGS,    XTIS,  NJSWGS)
`HSMHV_Idio_args1(js2,    UC_JS0S,    XTI2S, UC_NJS)
`HSMHV_Idio_args1(jssw2,  UC_JS0SWS,  XTI2S, NJSWS)
`HSMHV_Idio_args1(jsswg2, JS0SWGS,    XTI2S, NJSWGS)

if ( CODIO > 0 ) begin //new model:
    `HSMHV_Idio_args2(isbs_btm, isbs2_btm, isbs_sws, isbs2_sws, isbs_swg, isbs2_swg, PS, AS)
end else begin //backward compatible:
    `HSMHV_Idio_args2_compat(isbs_btm, isbs2_btm, isbs_sws, isbs2_sws, isbs_swg, isbs2_swg, PS, AS)
end
isbs = isbs_btm + isbs_sws + isbs_swg ;

if ( isbs > 0 ) begin
    T3 = isbs + `Small ; //once removed in Geoffrey01_Small_20160309, but necessary for backward compatibility
    vbst = UC_NJS / beta * ln( UC_VDIFFJS * T0 / T3 + 1.0 ) ;
    exptemps = exp (( Tratio - 1.0 ) * CTEMPS ) ;
    jd_nvtm_invs = 1.0 / ( UC_NJS / beta ) ;
    jd_expcs = exp (vbst * jd_nvtm_invs ) ;
end

//-----------------------------------------------------------*
//* Charges and Capacitances.
//*-----------------//

// Drain Bulk Junction //
`HSMHV_Qdio_args1(czbd, czbdsw, czbdswg, PD, AD, CJD, TCJBD, CJSWD, TCJBDSW, CJSWGD, TCJBDSWG, "D")
`HSMHV_Qdio_args2(pzbd, pzbdsw, pzbdswg, PD, AD, PBD, TPBBD, PBSWD, TPBBDSW, PBSWGD, TPBBDSWG, "D")

// Source Bulk Junction //
`HSMHV_Qdio_args1(czbs, czbssw, czbsswg, PS, AS, CJS, TCJBS, CJSWS, TCJBSSW, CJSWGS, TCJBSSWG, "S")
`HSMHV_Qdio_args2(pzbs, pzbssw, pzbsswg, PS, AS, PBS, TPBBS, PBSWS, TPBBSSW, PBSWGS, TPBBSSWG, "S")

// end of HSMHVtemp_eval_dio.h //
// ---- end `include "HSMHV_temp_eval_dio.inc" ----
end else begin
    TTEMP = $temperature + DTEMP;
end

//-----------------------------------------------------------*
//* Cbsj, Cbdj: node-base S/D biases.
//*-----------------//

// ibd //
T10 = CVBD * jd_nvtm_invd ;
T9 = CISBD * exptempd ;
`HSMHV_Idio(Ibd_btm, vbd_jct,  isbd_btm, isbd2_btm,  vbdt, jd_expcd,  T10, T9, jd_nvtm_invd, UC_CISBKD, DIVXD)
`HSMHV_Idio(Ibd_sws, vbd_jct,  isbd_sws, isbd2_sws,  vbdt, jd_expcd,  T10, T9, jd_nvtm_invd, UC_CISBKD, DIVXD)
if ( CODIO > 0 ) begin //new model:
    `HSMHV_Idio(Ibd_swg, vbdi_jct, isbd_swg, isbd2_swg,  vbdt, jd_expcd,  T10, T9, jd_nvtm_invd, UC_CISBKD, DIVXD)
end else begin //backward compatible:
    Ibd_swg = 0.0 ;
end

// ibs //
T10 = CVBS * jd_nvtm_invs ;
T9 = CISBS * exptemps ;
`HSMHV_Idio(Ibs_btm, vbs_jct,  isbs_btm, isbs2_btm,  vbst, jd_expcs,  T10, T9, jd_nvtm_invs, UC_CISBKS, DIVXS)
`HSMHV_Idio(Ibs_sws, vbs_jct,  isbs_sws, isbs2_sws,  vbst, jd_expcs,  T10, T9, jd_nvtm_invs, UC_CISBKS, DIVXS)
if ( CODIO > 0 ) begin //new model:
    `HSMHV_Idio(Ibs_swg, vbsi_jct, isbs_swg, isbs2_swg,  vbst, jd_expcs,  T10, T9, jd_nvtm_invs, UC_CISBKS, DIVXS)
end else begin //backward compatible:
    Ibs_swg = 0.0 ;
end

//-----------------------------------------------------------*
//* Charges and Capacitances.
//*-----------------//
//  charge storage elements
//*  bulk-drain and bulk-source depletion capacitances
//*  czbd : zero bias drain junction capacitance
//*  czbs : zero bias source junction capacitance
//*  czbdsw:zero bias drain junction sidewall capacitance
//*  czbssw:zero bias source junction sidewall capacitance
////

// Drain Bulk Junction //
`HSMHV_Qdio(Qbd_btm, Capbd_btm, vbd_jct,  czbd,    pzbd,    MJD)
`HSMHV_Qdio(Qbd_sws, Capbd_sws, vbd_jct,  czbdsw,  pzbdsw,  MJSWD)
if ( CODIO > 0 ) begin //new model:
    `HSMHV_Qdio(Qbd_swg, Capbd_swg, vbdi_jct, czbdswg, pzbdswg, MJSWGD)
end else begin //backward compatible:
    `HSMHV_Qdio(Qbd_swg, Capbd_swg, vbd_jct,  czbdswg, pzbdswg, MJSWGD)
end

// Source Bulk Junction //
`HSMHV_Qdio(Qbs_btm, Capbs_btm, vbs_jct,  czbs,    pzbs,    MJS)
`HSMHV_Qdio(Qbs_sws, Capbs_sws, vbs_jct,  czbssw,  pzbssw,  MJSWS)
if ( CODIO > 0 ) begin //new model:
    `HSMHV_Qdio(Qbs_swg, Capbs_swg, vbsi_jct, czbsswg, pzbsswg, MJSWGS)
end else begin //backward compatible:
    `HSMHV_Qdio(Qbs_swg, Capbs_swg, vbs_jct,  czbsswg, pzbsswg, MJSWGS)
end

//---------------------------------------------------*
//* Junction diode.
//*-----------------//
Ibs = Mfactor * (Ibs_btm + Ibs_sws) ;
Ibd = Mfactor * (Ibd_btm + Ibd_sws) ;
if ( CODIO > 0 ) begin //new model:
    Ibsi = Mfactor * Ibs_swg ;
    Ibdi = Mfactor * Ibd_swg ;
    Qbs = Mfactor * (Qbs_btm + Qbs_sws) ;
    Qbd = Mfactor * (Qbd_btm + Qbd_sws) ;
    Qbsi = Mfactor * Qbs_swg ;
    Qbdi = Mfactor * Qbd_swg ;
    Capbs = Mfactor * (Capbs_btm + Capbs_sws) ;
    Capbd = Mfactor * (Capbd_btm + Capbd_sws) ;
    Capbsi = Mfactor * Capbs_swg ;
    Capbdi = Mfactor * Capbd_swg ;
end else begin //backward compatible:
    Ibsi = 0.0 ;
    Ibdi = 0.0 ;
    Qbs = Mfactor * (Qbs_btm + Qbs_sws + Qbs_swg) ;
    Qbd = Mfactor * (Qbd_btm + Qbd_sws + Qbd_swg) ;
    Capbs = Mfactor * (Capbs_btm + Capbs_sws + Capbs_swg) ;
    Capbd = Mfactor * (Capbd_btm + Capbd_sws + Capbd_swg) ;
    Qbsi = 0.0 ;
    Qbdi = 0.0 ;
    Capbsi = 0.0 ;
    Capbdi = 0.0 ;
end

//---------------------------------------------------*
//* Reverse recovery model imported from Diode_CMC 2.0.0 (23/Aug/2016).
//*-----------------//

//imported from DIODE_CMC_InitModel.include:
//diode reverse recovery model
NDI_i    = NDIBOT / `C_cm2m_p3;  //UC_NOVER
NJL      = UC_NJD;
MUEN_i   = `C_MUEN / `C_m2cm_p2;  // [cm2/V/sec] -> [m2/V/sec]
MUEP_i   = `C_MUEP / `C_m2cm_p2;  // [cm2/V/sec] -> [m2/V/sec]
JUNCDLT  = 1e-3; //Smoothness of depletion width around zero bias (minor) [V]
//// Temperature-dependent variables
// Intrinsic Carrier Density:
`HSMHV_Idio_args1(Nin_dio,     `C_Nin0_dio,    XTID,  UC_NJD)  //diverted from js to Nin_dio
// Minority Carrier Density:
Pn0 = Nin_dio * Nin_dio / NDI_i;
// Ambipolar Diffusion Length:
T1 = pow(Tratio, -`C_MUETMP); // temperature dependence of phonon scattering
Dn = (MUEN_i * T1) * beta_inv;
Dp = (MUEP_i * T1) * beta_inv;
Da = 2*Dn*Dp/(Dn+Dp);
T2 = pow(Tratio, TAUT); // temperature dependence of tau
tau_HL = TAU * T2;
La = sqrt(tau_HL * Da);
// High-Injection Threshold Voltages:
V_HA = (NJL * beta_inv) * ln( NDI_i / Pn0 );
V_HK = (NJL * beta_inv) * ( ln( NDI_i / Pn0 ) + WI/La );
//End of diode reverse recovery model

//imported from diode_cmc.va:
/////////////////////////////////////////////////////////////////////////////
//
//  Recovery charge (calculations for ddt() contribs)
//
/////////////////////////////////////////////////////////////////////////////

// diode reverse recovery model
begin : evaluateRecoveryCharge

    if ( CORECOVERY > 0 ) begin

        //// High-Injection part //////////////////////////////////////////////////////

        // High-Injection Coefficient for the N+/N- Junction:
        nj_K = UC_NJD;

        // Hole Density at the P+/N- Junction:
        exp_A = exp( vbd_jct * jd_nvtm_invd );

        // Hole Density at the N+/N- Junction:
        if ( vbd_jct - ( V_HK - V_HA ) > 0 ) begin
            exp_K = exp( beta * ( vbd_jct / nj_K - (V_HK-V_HA) / nj_K ) );
        end else begin
            exp_K = 1;
        end

        //// Carrier-distribution-based recovery model ////////////////////////////////

        /////////////////////////////////////////////////////////
        //// Injected Charge from the P+/N- Junction (Anode Side)
        /////////////////////////////////////////////////////////

        // Modification of exp_A (especially for the high-injection condition):
        if (INJ2 == 0 || vbd_jct < V_HA) begin
            exp_A2 = exp_A * INJ1;
        end else begin
            exp_A2 = exp_A * INJ1 * exp( - INJ2*(vbd_jct-V_HA)*(vbd_jct-V_HA) * exp(INJT*ln(1/Tratio)) );
        end
        exp_A2 = ( exp_A2 > `C_EXPCEIL ?  `C_EXPCEIL : exp_A2); // safety valve

        // Hole Density at the P+/N- Junction:
        p_nA = Pn0 * exp_A2;

        // Excess Charge Density (Quasi-Static):
        q_pexA = `C_QE * AD * ( p_nA - Pn0 );

        //// Nonquasi-Static (NQS) Effect Model Formulation
        if ( NQS > 0.0 ) begin
            Q_qs_A = q_pexA * `QN_INJ_SCALING;        //input: QS charge density (scaled)
            Q_nqs_A = `NQS_CAPACITOR * V(charge_A);   //output: NQS charge dens. (scaled)
            Inqs0_A = (Q_nqs_A - Q_qs_A ) / NQS;      //DC current to the charge node
            // Injected Charge Density (Nonquasi-Static):
            q_pexA_nqs = Q_nqs_A / `QN_INJ_SCALING;   //(rescaled)
        end else begin
            Q_qs_A = q_pexA;     //input: QS charge density (unscaled)
            q_pexA_nqs = Q_qs_A; //(unscaled)
        end

        /////////////////////////////////////////////////////////
        //// Injected Charge from the N+/N- Junction (Cathode Side)
        /////////////////////////////////////////////////////////

        // Modification of exp_A (especially for the high-injection condition):
        if (INJ2 == 0 || vbd_jct < V_HK) begin
            exp_K2 = exp_K * INJ1;
        end else begin
            exp_K2 = exp_K * INJ1 * exp( - INJ2*(vbd_jct-V_HK)*(vbd_jct-V_HK) * exp(INJT*ln(1/Tratio)) );
        end
        exp_K2 = ( exp_K2 > `C_EXPCEIL ?  `C_EXPCEIL : exp_K2); // safety valve

        // Hole Density at the N+/N- Junction:
        p_nK = Pn0 * exp_K2;

        // Excess Charge Density (Quasi-Static):
        q_pexK = `C_QE * AD * (p_nK - Pn0);

        //// Nonquasi-Static (NQS) Effect Model Formulation
        if ( NQS > 0.0 ) begin
            Q_qs_K = q_pexK * `QN_INJ_SCALING;        //input: QS charge density (scaled)
            Q_nqs_K = `NQS_CAPACITOR * V(charge_K);   //output: NQS charge dens. (scaled)
            Inqs0_K = (Q_nqs_K - Q_qs_K ) / NQS;      //DC current to the charge node
            // Injected Charge Density (Nonquasi-Static):
            q_pexK_nqs = Q_nqs_K / `QN_INJ_SCALING;   //(rescaled)
        end else begin
            Q_qs_K = q_pexK;     //input: QS charge density (unscaled)
            q_pexK_nqs = Q_qs_K; //(unscaled)
        end

        /////////////////////////////////////////////////////////
        //// Depletion part
        /////////////////////////////////////////////////////////

        //// At the P+/N- Junction:
        Vjunc_A = PBD - vbd_jct ;
        //Vjunc_A = VBIRBOT_i - vbd_jct ; //to use the existing parameter in diode_cmc but results will change
        `Fn_SZ( Vjunc_A, Vjunc_A, JUNCDLT, T0 )
        W_depA = sqrt (2 * `C_ESI * Vjunc_A / (`C_QE * NDI_i));
        //W_depA = sqrt (2 * EPSSI * Vjunc_A / (`C_QE * NDI_i)); //to use the existing parameter in diode_cmc but results will change

        // Punch through effect:
        `Fn_SU( W_depA, W_depA, WI, `C_PUNCH, T0 )

        // NQS Effect on W_depA (temporary model):
        if ( DEPNQS > 0.0 ) begin
            W_qs_A = W_depA * `DEP_SCALING;            //input: QS value (scaled)
            W_nqs_A = `DEPNQS_CAPACITOR * V(depl_A);   //output: NQS value (scaled)
            IWnqs0_A = (W_nqs_A - W_qs_A ) / DEPNQS;   //DC current to the NQS node
            // Depletion Width (Nonquasi-Static):
            W_depA_nqs = W_nqs_A / `DEP_SCALING;       //(rescaled)
        end else begin
            W_qs_A = W_depA;     //input: QS value (unscaled)
            W_depA_nqs = W_qs_A; //(unscaled)
        end

        /////////////////////////////////////////////////////////
        //// Final Equations
        /////////////////////////////////////////////////////////
        //----- Analytical Integration Based on the Carrier Distribution:
        // basic majority-carrier charge:
        Q_n0 = - (NDI_i * AD * `C_QE) * WI;
        // excess charge (Anode side):
        Q_nexA_nqs = La * q_pexA_nqs * ( exp( - WI/La ) - exp( - W_depA_nqs/La ) );
        // excess charge (Cathode side):
        Q_nexK_nqs = La * q_pexK_nqs * ( exp( - (WI - W_depA_nqs)/La ) - 1.0 );
        // depletion charge:
        //              Q_depA = + (NDI_i * AD * `C_QE) * W_depA_nqs;

        //// Final total electron charge:
        Qrr = - ( Q_n0 + Q_nexA_nqs + Q_nexK_nqs );

        /////////////////////////////////////
        //connection with original Diode_cmc:
        /////////////////////////////////////
        Qbd = Qbd + Mfactor * Qrr;

    end //End of if ( CORECOVERY > 0 )

end // evaluateRecoveryCharge
// End of diode reverse recovery model

/////////////////////////////////////////////////////////////////////////////
//
//  NQS nodes contribs for the recovery model
//
/////////////////////////////////////////////////////////////////////////////

// diode reverse recovery model
begin : loadRecovery
    if ( CORECOVERY > 0 && NQS > 0.0 ) begin
        I(charge_A) <+ Inqs0_A + ddt(Q_nqs_A);
        I(charge_K) <+ Inqs0_K + ddt(Q_nqs_K);
    end else begin
        V(charge_A) <+ 0.0;
        V(charge_K) <+ 0.0;
    end
    if ( CORECOVERY > 0 && DEPNQS > 0.0 ) begin
        I(depl_A) <+ IWnqs0_A + ddt(W_nqs_A);
    end else begin
        V(depl_A) <+ 0.0;
    end
end // loadRecovery
// End of diode reverse recovery model

//  End of HSMHVevalDio //
// ---- end `include "HSMHV_eval_dio.inc" ----
`endif /* End of COEXTDIO */

        // snapback //
        //     wIbjt = 0.0;  iiFac = 0.0;  wk_iiFac = 0.0;  // probing 20180410
        if ( COSNP == 1 ) begin //{
            // This part comes from PART-2.
            //-------------------------------------------*
            //* Conductive case.
            //*-----------------//
            if ( UC_SUB1SNP > 0.0e0 && UC_VMAX > 0.0e0 ) begin //{
                T1 = vg2const_ * Vgp ;
                T3 = qnsub_esi / (Cox0 * Cox0) ;
                T4 = 2.0 / qnsub_esi * (Cox0 * Cox0) ;
                T5 = T1 - beta_inv - xvbs_ * Vbsz ;
                T6 = 1.0 + T4 * T5 ;
                T7 = 2.0 * ( 1.0 + T4 ) ;
                `Fn_SL_CP( T6 , T6 , 0, T7 , 4 , T0 )
                T6 = sqrt( T6 ) ;
                Psislsat = T1 + T3 * ( 1.0 - T6 ) ;
                T2 = Lgate / (xgate_ + Lgate) ;
                Psisubsat = UC_SVDSSNP * Vdsz + Ps0z - T2 * Psislsat ;
                `Fn_SZ( Psisubsat , Psisubsat, 1.0e-3, T9 )
                Psisubsat = Psisubsat + `Small ;
                xsubtmp = 1.0 + UC_SUBTMP * (TTEMP-KTNOM) ;
                xsubtmp = ( xsubtmp <= 1.0e-3 ) ? 1.0e-3  : xsubtmp ;
                T5 = xsub1_ / xsubtmp ;
                T6 = xsub2_ * xsubtmp ;
                T2 = exp( - T6 / Psisubsat ) ;
                iiFac = T5 * Psisubsat * T2 ;

                // Ibs (CODIbdO = 0)or Ibsi (CODIO > 0 ) From 20160610 on
                if ( CODIO > 0) begin //new model
                    wIbjt = ( 1.0 + iiFac) * Ibsi; // Ibs:  weff_nf, M factor incl.
                end else begin
                    wIbjt = ( 1.0 + iiFac) * Ibs; // Ibs:  weff_nf, M factor incl.
                end
            end // } if( UC_SUB1SNP > 0.0e0 && UC_VMAX > 0.0e0 )
        end //}  if ( COSNP == 1 )
        //        wk_iiFac = iiFac; wk_Ibjt = wIbjt; wk_Ibsi = Ibsi; wk_Ibs = Ibs; // 20180410 probing
        //-----------------------------------------------------------*
        //* End of PART-4. (label)
        //*-----------------//

        // end_of_part_4:

        //-----------------------------------------------------------*
        //* PART-5: NQS. (label)
        //*-----------------//

        if ( flg_nqs ) begin
            if (flg_noqi == 0) begin
                T12 = DLY1 ;
                T10 = DLY2 ;
                T3 = Lch ;
                T1 = T12 * T10 * T3 * T3 ;
                T2 = Mu * VgVt * T12 + T10 * T3 * T3 + `Small ;
                tau = T1 / T2 ;
            end else begin
                tau = DLY1 ;
            end
            T2 = MKS_DLY3 ;
            taub = T2 * Cox;
        end

        //-----------------------------------------------------------*
        //* End of PART-5. (label)
        //*-----------------//
        // end_of_part_5:

        //++++++++++++++++++++++++++++++++++++++++++++++++++++++++++++
        //* PART-6: Noise Calculation.
        //*++++++++++++++++++++++++++++++++++++++++++++++++++++++++++++//

        //-----------------------------------------------------------*
        //* 1/f noise.
        //*-----------------//
        if ( COFLICK != 0 && !flg_noqi ) begin
            NFalpe = UC_NFALP ;
            NFtrpe = UC_NFTRP ;
            Cite = MKS_CIT ;
            T1 = Qn0 / `C_QE ;
            `Fn_SZ( T5 , (Ps0 - Vbscl) , 1e-3 , T0 )
            T2 = ( Cox + Qn0 / ( T5 ) + Cite ) * beta_inv / `C_QE ;
            T3 = -2.0E0 * Qi_noi / `C_QE / Lch / weffcv_nf - T1 ;
            if ( abs(T3 - T1) > `epsm10 ) begin
                T4 = 1.0E0 / ( T1 + T2 ) / ( T3 + T2 ) + 2.0E0 * NFalpe * Ey * Mu / ( T3 - T1 )
                * ln(( T3 + T2 ) /( T1 + T2 ) ) + NFalpe * Ey * Mu * NFalpe * Ey * Mu ;
            end  else begin
                //series expansion for ln(1+(T3-T1)/(T1+T2)) about the point T3=T1:
                T4 = 1.0 / ( T1 + T2 ) / ( T3 + T2 ) + 2.0 * NFalpe * Ey * Mu / ( T1 + T2 )
                + NFalpe * Ey * Mu * NFalpe * Ey * Mu;
            end
            Nflic = Ids * Ids * NFtrpe / ( Lch * beta * weff_nf ) * T4 ;
        end else begin
            Nflic = 0.0 ;
        end

        //-----------------------------------------------------------*
        //* thermal noise.
        //*-----------------//
        if ( COTHRML != 0 && !flg_noqi && UC_CODEP == 0) begin
            Eyd = ( Psdl - Ps0 + `epsm10 ) / Lch ;
            Eyd = `Fn_Max( Eyd , 0.0 ) ; // bugfix to avoid FPE in `Fn_Pow below
            T12 = Muun * Eyd / 1.0e7 ;
            // note: bb = 2 (electron) ;1 (hole) //
            if ( 1.0e0 - `epsm10 <= BB && BB <= 1.0e0 + `epsm10 ) begin
                T7  = 1.0e0 ;
            end else if ( 2.0e0 - `epsm10 <= BB && BB <= 2.0e0 + `epsm10 ) begin
                T7  = T12 ;
            end else begin
                T7  = `Fn_Pow( Eyd, BB - 1.0e0 ) ;
            end
            T8 = T12 * T7 ;
            T9 = 1.0e0 + T8 ;
            T10 = `Fn_Pow( T9, ( - 1.0e0 / BB - 1.0e0 ) ) ;
            T11 = T9 * T10 ;
            Mud_hoso = Muun * T11 ;
            Mu_Ave = ( Mu + Mud_hoso ) / 2.0 ;
            // Sid_h = GAMMA * 4.0 * C_KB * temp * gds0_h2; //
            T0 = Alpha * Alpha ;
            Nthrml  = weff_nf * Cox * VgVt * Mu
               * ( ( 1e0 + 3e0 * Alpha + 6e0 * T0 ) * Mud_hoso * Mud_hoso
               + ( 3e0 + 4e0 * Alpha + 3e0 * T0 ) * Mud_hoso * Mu
               + ( 6e0 + 3e0 * Alpha + T0 ) * Mu * Mu )
               / ( 15e0 * Lch * ( 1e0 + Alpha ) * Mu_Ave * Mu_Ave ) ;
        end else begin
            Nthrml = 0e0 ;
        end

        //----------------------------------------------------------*
        //* induced gate noise. ( Part 2/3 )
        //*----------------------//
        if ( COIGN != 0 && COTHRML != 0 && flg_ign == 1 && !flg_noqi && UC_CODEP == 0) begin
            sqrtkusaiL = sqrt( kusaiL ) ;
            T2 = VgVt + sqrtkusaiL ;
            T3 = kusai00 * kusai00 ;
            T4 = kusaiL * kusaiL ;
            T5 = 42.0e0 * kusai00 * kusaiL ;
            T5 = T5 + 4.0e0 * ( T3 + T4 ) ;
            T5 = T5 + 20.0e0 * sqrtkusaiL * VgVt * ( kusai00 + kusaiL ) ;
            T10 = T2 * T2 ;
            T10 = T10 * T10 ;
            kusai_ig = T5 / ( T10 * T2 ) ; // Induced Gate Noise parameter //
            gds0_ign = weff_nf / Lch * Mu * Cox ;
            gds0_h2 = gds0_ign * VgVt ;
            GAMMA = Nthrml / gds0_h2 ;
            T7 = kusai00 + 4.0e0 * VgVt * sqrtkusaiL + kusaiL ;
            // cross-correlation coefficient(= Sigid/sqrt(Sig*Sid) ) //
            crl_f = `c_sqrt_15 * kusai00L * T7
             / ( 6.0e0 * T2 * sqrt( GAMMA * T2 * VgVt * T5 ) ) ;
        end

        //-----------------------------------------------------------*
        //* End of PART-6. (label)
        //*-----------------//
        // end_of_part_6:

    end // Vbscl_local   // *******************************
    //++++++++++++++++++++++++++++++++++++++++++++++++++++++++++++
    //* PART-7: Evaluation of outputs.
    //*++++++++++++++++++++++++++++++++++++++++++++++++++++++++++++//

    //-----------------------------------------------------------*
    //* Assign outputs.
    //*-----------------//

    //---------------------------------------------------*
    //* Channel current and conductances.
    //*-----------------//
    idse  = Mfactor * Ids ;
    IdsAcc = Mfactor * Ids_acc ;
    IdsRes = Mfactor * Ids_res ;
    IresLeak = Mfactor * Ires_leak ;
    IdsIBPCe  = Mfactor * IdsIBPC ;

    Ibjte = wIbjt; // 20160414  Mfactor incl. ibs (diode)

    // -------------------------------------*
    //* Intrinsic charges / capacitances.
    //*-----------------//
    qgexte = 0.0 ;
    qdexte = 0.0 ;
    qsexte = 0.0 ;
    qgov = 0.0 ;
    qdov = 0.0 ;
    qsov = 0.0 ;
    qdp = 0.0 ;
    qsp = 0.0 ;
    if (flg_nqs || COADOV==2) begin // for flat handling of NQS: the NQS charges are added in hsmhvld // (COADOV=2 for debugging; intrinsic charge zero;)
        qge = 0.0 ;
        qde = 0.0 ;
        qse = 0.0 ;

        Xd       = Qdrat;
        Qbulk    = Mfactor * Qb ;
        Qi       = Mfactor * Qi ;

    end else  begin // QS //
        qge = Mfactor * - (Qb + Qi) ;
        qde = Mfactor * Qd ;
        qse = Mfactor * ( Qi - Qd ) ;
    end

    //---------------------------------------------------*
    //* Add S/D overlap charges/capacitances to intrinsic ones.
    //* - NOTE: This function depends on coadov, a control option.
    //*-----------------//
    if ( CONQSOV ) begin
        MKS_DLYOV = MKS_DLYOV * Psl ; //Psl depends on the Vds mode!
        `Fn_SZ(MKS_DLYOV, MKS_DLYOV, 1e-12 , T0)
        tauov = MKS_DLYOV * Cox0 ;
        Qbd_nqs = V(qbd) ;
        Ibd_nqs = (Qbd_nqs - Qbd_qs) / tauov ;
        Qovd  = Qovd - (Qbd_qs - Qbd_nqs) ;
        QbdLD = Qbd_nqs ;
    end else begin
        Qbd_nqs = Qbd_qs ;
    end
    if ( COADOV > 0 ) begin
        // note: independent of Vds mode:
        qgov = Mfactor * ( Qgbo - Qovd - Qovs    + Qgos + Qgod) ; // 20200712
        qdov = Mfactor * ( + QbdLD                      - Qgod) ; // 20200712
        qsov = Mfactor * ( + QbsLD               - Qgos       ) ; // 20200712

        // note: dependent on Vds mode:
        //qge = qge + Mfactor * ( + Qgod + Qgos + Qy - Qovd_ADD - Qovs_ADD  ) ;
        //qde = qde + Mfactor * ( - Qgod        - Qy + QbdLD_ADD ) ;
        //qse = qse + Mfactor * ( - Qgos             + QbsLD_ADD ) ;
        qge = qge + Mfactor * (               + Qy - Qovd_ADD - Qovs_ADD  ) ; // 20200712
        qde = qde + Mfactor * (               - Qy + QbdLD_ADD ) ;            // 20200712
        qse = qse + Mfactor * (                    + QbsLD_ADD ) ;            // 20200712

        // note: independent of Vds mode:
        qgexte = Mfactor * ( - Qovdext - Qovsext ) ;
        qdexte = Mfactor * QbdLDext ;
        qsexte = Mfactor * QbsLDext ;

        // for fringing capacitances (independent of Vds mode) //
        qdp = qdp + Mfactor * ( - Qfd - Qgdo ) ;
        qsp = qsp + Mfactor * ( - Qfs - Qgso ) ;

    end

    //---------------------------------------------------*
    //* Substrate/gate/leak currents.
    //*-----------------//
    isube  = Mfactor * (Isub+IsubIBPC) ; // 20180413
    IsubLDe = Mfactor * IsubLD ;
    igbe   = Mfactor * -Igb ;
    if (mode == `HiSIM_NORMAL_MODE) begin
        igde = Mfactor * ( GLPART1 * Igate - Igd ) ;
    end else begin
        igde = Mfactor * ( (1.0e0 - GLPART1 ) * Igate - Igs ) ;
    end
    if (mode == `HiSIM_NORMAL_MODE) begin
        igse = Mfactor * ( (1.0e0  - GLPART1) * Igate - Igs ) ;
    end else begin
        igse = Mfactor * ( GLPART1 * Igate - Igd ) ;
    end

    // note: igd and igs are already subjected to mode handling,
    igidle    = Mfactor * Igidl ;
    igisle    = Mfactor * Igisl ;

    //---------------------------------------------------*
    //* Von, Vdsat.
    //*-----------------//
    Von = Vth ;
    Vdsat = Vdsat ;

    //-----------------------------------------------------------*
    //* Noise.
    //*-----------------//
    // Noise coeff. calculation
`define C_QE2    2.0 * `C_QE
    whi_noise = 4.0 * `C_KB* TTEMP * `Kwhite ;
    noiflick = Mfactor * Nflic ;
    noithrml = Mfactor * Nthrml ;

    cgdbd = ddx(qge,V(dp)) ;
    cgdbd = TYPE * cgdbd ;  // VAMPyRE ERROR
    cgsbd = ddx(qge,V(sp)) ;
    cgsbd = TYPE * cgsbd ;  // VAMPyRE ERROR
    cgsb  = (mode > 0) ? cgsbd : cgdbd ;

    noiigate = 0.0e0 ;
    noicross = 0.0e0 ;
    //----------------------------------------------------------*
    //* induced gate noise. ( Part 3/3 )
    //*----------------------//
    if ( COIGN != 0 && COTHRML != 0 && flg_ign == 1 && !flg_noqi && UC_CODEP == 0 ) begin
        T0 = `Cox_Small * Cox * weffcv_nf * Leff ;
        T10 = cgsb / Mfactor ;
        //       T10 = - Cox * weffcv_nf * Leff ; //constant capacitance to solve VAMPyRE ERROR
        Nign0 = `c_16o135 * `C_QE * beta_inv * T10 * T10 / gds0_ign ;
        if ( kusai00L > `epsm10 && Vds > `epsm10 ) begin
            MuModA = Muun / Mu ;
            MuModB = ( Muun / Mud_hoso - MuModA ) / Vds ;
            correct_w1 = MuModA + `C_2o3 * MuModB
                      * ( kusai00 + VgVt * sqrtkusaiL + kusaiL )
                      / ( VgVt + sqrtkusaiL ) ;
        end else begin
            correct_w1 = Muun / Mud_hoso ;
        end
        noiigate = Mfactor * Nign0 * kusai_ig * correct_w1 ;
        noicross = crl_f ;
        noiigate = ( noiigate < 0.0 ) ? 0.0e0 : noiigate ;
        noiigate = ( - T10 > T0 ) ? noiigate : 0.0 ;
        noicross = ( - T10 > T0 ) ? noicross : 0.0 ;
    end
    // Thermal noise and induced gate noise:
    sid    = whi_noise * noithrml;
    ci     = noicross;
    sigrat = (sid > 0.0 && noiigate > 0.0) ? sqrt(noiigate/sid) : 0.0 ;
    sigrat_s  = (mode > 0) ? sigrat*(1-Qdrat) : sigrat*   Qdrat ;
    sigrat_d  = (mode > 0) ? sigrat*   Qdrat  : sigrat*(1-Qdrat) ;

    //-----------------------------------------------------------*
    //* End of PART-7. (label)
    //*-----------------//

    //++++++++++++++++++++++++++++++++++++++++++++++++++++++++++++++++++++
    //* PART of New Drift Resistance Model.
    //*+++++++++++++++++++++++++++++++++++++++++++++++++++++++++++++++++++//
    Rsde=0.0;
    Rdde=0.0;
    if ( UC_CORDRIFT == 1 ) begin
// ---- begin `include "HSMHV_eval_rdrifts.inc" ----
/***********************************************************************

 HiSIM (Hiroshima University STARC IGFET Model)
 Copyright (C) 2000-2016 Hiroshima University and STARC
 Copyright (C) 2016-2023 Hiroshima University
 HiSIM_HV (High-Voltage Model)
 Copyright (C) 2007-2016 Hiroshima University and STARC
 Copyright (C) 2016-2023 Hiroshima University

 MODEL NAME : HiSIM_HV
 ( VERSION : 2  SUBVERSION : 5  REVISION : 1 )
 Model Parameter 'VERSION' : 2.51
 FILE : HSMHV_eval_rdrifts.inc

 Date : 2023.02.09

 released by Hiroshima University

***********************************************************************/
//
////////////////////////////////////////////////////////////////
//
//
//
//
//Licensed under the Educational Community License, Version 2.0
//(the "License"); you may not use this file except in
//compliance with the License.
//
//You may obtain a copy of the License at:
//
//      http://opensource.org/licenses/ECL-2.0
//
//Unless required by applicable law or agreed to in writing,
//software distributed under the License is distributed on an
//"AS IS" BASIS, WITHOUT WARRANTIES OR CONDITIONS OF ANY KIND,
//either express or implied. See the License for the specific
//language governing permissions and limitations under the
//License.
//
//
//The HiSIM_HV standard has been supported by the members of
//Silicon Integration Initiative's Compact Model Coalition. A
//link to the most recent version of this standard can be found
//at:
//
//http://www.si2.org/cmc
//
////////////////////////////////////////////////////////////////
//

begin : HSMHV_eval_rdrifts
    if ( flg_rs == 0 ) begin
        // does nothing; no resistance on source side;  node sp shall be collapsed.
    end
    else begin //  CORS == 1; source side resistance in consideration

        //-----------------------------------------------------------*
        //* Temperature dependent constants.
        //*-----------------//
        if ( COSELFHEAT > 0 && UC_RTH0 != 0.0 ) begin

// ---- begin `include "HSMHV_temp_eval_rdris.inc" ----
/***********************************************************************

 HiSIM (Hiroshima University STARC IGFET Model)
 Copyright (C) 2000-2016 Hiroshima University and STARC
 Copyright (C) 2016-2023 Hiroshima University
 HiSIM_HV (High-Voltage Model)
 Copyright (C) 2007-2016 Hiroshima University and STARC
 Copyright (C) 2016-2023 Hiroshima University

 MODEL NAME : HiSIM_HV
 ( VERSION : 2  SUBVERSION : 5  REVISION : 1 )
 Model Parameter 'VERSION' : 2.51
 FILE : HSMHV_temp_eval_rdris.inc

 Date : 2023.02.09

 released by Hiroshima University

***********************************************************************/
//
////////////////////////////////////////////////////////////////
//
//
//
//
//Licensed under the Educational Community License, Version 2.0
//(the "License"); you may not use this file except in
//compliance with the License.
//
//You may obtain a copy of the License at:
//
//      http://opensource.org/licenses/ECL-2.0
//
//Unless required by applicable law or agreed to in writing,
//software distributed under the License is distributed on an
//"AS IS" BASIS, WITHOUT WARRANTIES OR CONDITIONS OF ANY KIND,
//either express or implied. See the License for the specific
//language governing permissions and limitations under the
//License.
//
//
//The HiSIM_HV standard has been supported by the members of
//Silicon Integration Initiative's Compact Model Coalition. A
//link to the most recent version of this standard can be found
//at:
//
//http://www.si2.org/cmc
//
////////////////////////////////////////////////////////////////
//

// Phonon Scattering(temperature-dependent part) //
T1 =  `Fn_Pow( Tratio, RDRMUETMPS ) ;
RRDRMUES = MKS_RDRMUES / T1 ;

// Velocity Temperature Dependence //
T0 = 1.8 + 0.4 * Tratio + 0.1 * Tratio * Tratio - RDRVTMPS * ( 1.0 - Tratio ) ;
RRDRVMAXS = MKS_RDRVMAXS / T0 ;

//Toshiba model //
UC_RDRBB_s = UC_RDRBB_s+RDRBBTMPS*(TTEMP-KTNOM) ;

// end of HSMHVtemp_eval_rdri.h //
// ---- end `include "HSMHV_temp_eval_rdris.inc" ----
        end else begin
            TTEMP = $temperature + DTEMP ;
        end

        WeffLD_nf = weff_ld * NF ;  // Used for Rsd = Rsd / WeffLD_nf ;
        //Ldrifte_s = LDRIFT1S + LDRIFT2S ; // compatibility btw rdrift and rdrifts
        Ldrifte_s = LDRIFTS; // (new feature)
        Novers = UC_NOVERS ;

        Mu0_s   = RRDRMUES * Rdrmuele;
        Vmaxe_s = RRDRVMAXS * Rdrvmaxwe * Rdrvmaxle + `Small;
`ifdef __DEBUG_RDRIFTS__
            $write("debug_eval_rdrifts_0[ %g %g %g %g ]\n",Vmaxe_s, RRDRVMAXS, MKS_RDRVMAXS,RRDRMUES); /
`endif

            Edri_s     = Vsps  / Ldrifte_s ;
        Vdri_s     = Mu0_s  * Edri_s ;
        //-----------------------------------------------------------*
        //* Mu : mobility
        //*-----------------//
        if ( Vsps >= 0 ) begin
            T1       = Vdri_s / Vmaxe_s ;
        end else  begin
            T1       = - Vdri_s / Vmaxe_s ;
        end
`ifdef __DEBUG_RDRIFTS__
            $write("debug_eval_rdrifts_a[ %g %g %g  %g %g ]\n", Vsps, Vdri_s, Vmaxe_s, Edri_s, Mu0_s);
`endif
        if ( 1.0e0 - `epsm10 <= UC_RDRBB_s && UC_RDRBB_s <= 1.0e0 + `epsm10 ) begin
            T3 = 1.0e0 ;
        end else if ( 2.0e0 - `epsm10 <= UC_RDRBB_s && UC_RDRBB_s <= 2.0e0 + `epsm10 ) begin
            T3 = T1 ;
        end else  begin
            T3 = pow( T1 , UC_RDRBB_s - 1.0e0 ) ;  // if( T1 == 0.0 ) is removed because of VAMPyRE ERROR
        end
        T2 = T1 * T3 ;
        T4 = 1.0e0 + T2 ;
        if ( 1.0e0 - `epsm10 <= UC_RDRBB_s && UC_RDRBB_s <= 1.0e0 + `epsm10 ) begin
            T5 = 1.0 / T4 ;
        end else if ( 2.0e0 - `epsm10 <= UC_RDRBB_s && UC_RDRBB_s <= 2.0e0 + `epsm10 ) begin
            T5 = 1.0 / sqrt( T4 ) ;
        end else  begin
            T6 = `Fn_Pow( T4 , ( - 1.0e0 / UC_RDRBB_s - 1.0e0 ) ) ;
            T5 = T4 * T6 ;
        end
        Mu_s   = Mu0_s * T5 ;  // velocity saturation accounted
`ifdef __DEBUG_RDRIFTS__
            $write("debug_eval_rdrifts_b[ %g %g %g ]\n", Mu_s, Mu0_s, T5);
`endif
        //-----------------------------------------------------------*
        //* Carr : carrier density
        //*-----------------//
        Carr_s = Novers;
        Xov_s = Xmax_s;
        //-----------------------------------------------------------*
        //* Rd : drift resistance
        //*-----------------//
        //drain:    T1 = `C_QE / ( Ldrifte + RDRDL1 );
        T1 = `C_QE / ( Ldrifte_s );
        GD_s = T1 * Xov_s * Mu_s * Carr_s ;
`ifdef __DEBUG_RDRIFTS__
            $write("debug_eval_rdrifts_c[ %g %g %g %g %g  %g %g %g  %g ]\n", GD_s, T1, Xov_s, Mu_s, Carr_s, Mu0_s, Vdri_s, Vmaxe_s, Edri_s);
`endif

`ifdef REPLACE_CLIPPING_WITH_SMOOTHING //revised for continuity (Rsd)
            `Fn_SL_CP(GD_s, GD_s, 0, `Small, 2, T0)
`else
            if ( GD_s <= 0 ) begin
                GD_s = `Small ;
            end
`endif

        Rsd = 1 / GD_s ;
        // Weff dependence of the resistances //
        Rsd = Rsd  /  WeffLD_nf ;

        // Sheet resistances are added. //
        //drain: Rdd = Rdd + Rd0 ;
        Rsd = Rsd + Rs0 ;

        // Re-stamps for hsmhvnoi.c //
        //drain: if ( Rdd  > `Res_min && COTHRML != 0 ) drainConductance = Mfactor / Rdd ;
        //drain: else drainConductance = 0.0 ;
        if ( Rsd  > `Res_min && COTHRML != 0 ) sourceConductance = Mfactor / Rsd ;
        else sourceConductance = 0.0 ;

        // Clamping to Res_min //
        if (Rsd < `Res_min) begin
            Rsd = `Res_min ;
        end
        Rsde = Rsd / Mfactor ;   // Rsd to have been evaluated in HSMHV_eval_rdrifts.inc beforehand.
        //drain: if(Rdd < `Res_min) begin Rdd = `Res_min ; end
        //drain: Rdde = Rdd / Mfactor ;

    end //  if ( flg_rs == 0)
end //  HSMHV_eval_rdrifts

// ---- end `include "HSMHV_eval_rdrifts.inc" ----
// ---- begin `include "HSMHV_eval_rdrift.inc" ----
/***********************************************************************

 HiSIM (Hiroshima University STARC IGFET Model)
 Copyright (C) 2000-2016 Hiroshima University and STARC
 Copyright (C) 2016-2023 Hiroshima University
 HiSIM_HV (High-Voltage Model)
 Copyright (C) 2007-2016 Hiroshima University and STARC
 Copyright (C) 2016-2023 Hiroshima University

 MODEL NAME : HiSIM_HV
 ( VERSION : 2  SUBVERSION : 5  REVISION : 1 )
 Model Parameter 'VERSION' : 2.51
 FILE : HSMHV_eval_rdrift.inc

 Date : 2023.02.09

 released by Hiroshima University

***********************************************************************/
//
////////////////////////////////////////////////////////////////
//
//
//
//
//Licensed under the Educational Community License, Version 2.0
//(the "License"); you may not use this file except in
//compliance with the License.
//
//You may obtain a copy of the License at:
//
//      http://opensource.org/licenses/ECL-2.0
//
//Unless required by applicable law or agreed to in writing,
//software distributed under the License is distributed on an
//"AS IS" BASIS, WITHOUT WARRANTIES OR CONDITIONS OF ANY KIND,
//either express or implied. See the License for the specific
//language governing permissions and limitations under the
//License.
//
//
//The HiSIM_HV standard has been supported by the members of
//Silicon Integration Initiative's Compact Model Coalition. A
//link to the most recent version of this standard can be found
//at:
//
//http://www.si2.org/cmc
//
////////////////////////////////////////////////////////////////
//

begin : HSMHV_eval_rdrift
    real Vds, Vbs , Mu , Vmaxe ;
    //  real Carr1 , Carr2 ;

    if ( flg_rd == 0 ) begin
        // does nothing; drain side resistance zero; node dp shall be collapsed beforehand.
    end
    else begin
        //  getting biases
        Vds = Vdsi ;
        Vbs = Vbsi ;

        //-----------------------------------------------------------*
        //* Temperature dependent constants.
        //*-----------------//
        if ( COSELFHEAT > 0 && UC_RTH0 != 0.0 ) begin

// ---- begin `include "HSMHV_temp_eval_rdri.inc" ----
/***********************************************************************

 HiSIM (Hiroshima University STARC IGFET Model)
 Copyright (C) 2000-2016 Hiroshima University and STARC
 Copyright (C) 2016-2023 Hiroshima University
 HiSIM_HV (High-Voltage Model)
 Copyright (C) 2007-2016 Hiroshima University and STARC
 Copyright (C) 2016-2023 Hiroshima University

 MODEL NAME : HiSIM_HV
 ( VERSION : 2  SUBVERSION : 5  REVISION : 1 )
 Model Parameter 'VERSION' : 2.51
 FILE : HSMHV_temp_eval_rdri.inc

 Date : 2023.02.09

 released by Hiroshima University

***********************************************************************/
//
////////////////////////////////////////////////////////////////
//
//
//
//
//Licensed under the Educational Community License, Version 2.0
//(the "License"); you may not use this file except in
//compliance with the License.
//
//You may obtain a copy of the License at:
//
//      http://opensource.org/licenses/ECL-2.0
//
//Unless required by applicable law or agreed to in writing,
//software distributed under the License is distributed on an
//"AS IS" BASIS, WITHOUT WARRANTIES OR CONDITIONS OF ANY KIND,
//either express or implied. See the License for the specific
//language governing permissions and limitations under the
//License.
//
//
//The HiSIM_HV standard has been supported by the members of
//Silicon Integration Initiative's Compact Model Coalition. A
//link to the most recent version of this standard can be found
//at:
//
//http://www.si2.org/cmc
//
////////////////////////////////////////////////////////////////
//

// Phonon Scattering(temperature-dependent part) //
T1 =  `Fn_Pow( Tratio, RDRMUETMP ) ;
RRDRMUE = MKS_RDRMUE / T1 ;

// Velocity Temperature Dependence //
T0 = 1.8 + 0.4 * Tratio + 0.1 * Tratio * Tratio - RDRVTMP * ( 1.0 - Tratio ) ;
RRDRVMAX = MKS_RDRVMAX / T0 ;

//Toshiba model //
UC_RDRBB = UC_RDRBB + RDRBBTMP * (TTEMP-KTNOM) ;

// Check the value after temperature dependence
`MINRESET(UC_RDRBB, 0.1 , "RDRBB@T dependence")

// end of HSMHVtemp_eval_rdri.h //
// ---- end `include "HSMHV_temp_eval_rdri.inc" ----
        end else begin
            TTEMP = $temperature + DTEMP ;
        end

        WeffLD_nf = weff_ld * NF ;
        Ldrifte   = LDRIFT1 + LDRIFT2;
        //Ldrifte = LDRIFT; // in future
        Rd_Xldld  = UC_XLDLD + `Small2 ;
        Noverd    = UC_NOVER ;
        T1 = 1.0e0 + Vbs*(RDRMUEBS1 - RDRMUEBS2 * Vbs); // 20181017
        `Fn_SZ( RdrmueVbs,  T1, 0.1, T2)                // 20181017
        Mu0 = RRDRMUE  * Rdrmuele  * RdrmueVbs ;        // 20181017

        Vmaxe = RRDRVMAX * Rdrvmaxwe * Rdrvmaxle + `Small ;
        Cx    = UC_RDRCX ;
        Car   = RDRCAR ;

        // Check the value after L , W and T dependence
        T1 = Mu0 * `C_m2cm_p2 ;
        T2 = Vmaxe * `C_m2cm ;
        `RANGECHECK(T1, 1e2 , 3e3 , "RDRMUE@L,T dependence")
        `RANGECHECK(T2, 1e6 , 100e6  , "RDRVMAX@L,W,T dependence ")

        //-----------------------------------------------------------*
        // Modified bias introduced to realize symmetry at Vddp=0.
        //-----------------//
        if (Vddp < 0) begin
            `Fn_SymAdd( Vzadd , -Vddp / 2 , VZADD0 , T2 )
            if ( Vzadd < `ps_conv ) begin
                Vzadd = `ps_conv ;
            end
            Vddpz = Vddp - 2 * Vzadd ;
        end else begin
            `Fn_SymAdd( Vzadd ,  Vddp / 2 , VZADD0 , T2 )
            if ( Vzadd < `ps_conv ) begin
                Vzadd = `ps_conv ;
            end
            Vddpz = Vddp + 2 * Vzadd ;
        end

        Edri = Vddpz / Ldrifte ;
        Vdri = Mu0   * Edri ;

        //-----------------------------------------------------------*
        //* Mu : mobility
        //*-----------------//
        if ( Vddp >= 0 ) begin
            T1 = Vdri / Vmaxe ;
        end else  begin
            T1 = - Vdri / Vmaxe ;
        end
        if ( 1.0e0 - `epsm10 <= UC_RDRBB && UC_RDRBB <= 1.0e0 + `epsm10 ) begin
            T3 = 1.0e0 ;
        end else if ( 2.0e0 - `epsm10 <= UC_RDRBB && UC_RDRBB <= 2.0e0 + `epsm10 ) begin
            T3 = T1 ;
        end else  begin
            T3 = pow( T1 , UC_RDRBB - 1.0e0 ) ;  // if( T1 == 0.0 ) is removed because of VAMPyRE ERROR
        end
        T2 = T1 * T3 ;
        T4 = 1.0e0 + T2 ;
        if ( 1.0e0 - `epsm10 <= UC_RDRBB && UC_RDRBB <= 1.0e0 + `epsm10 ) begin
            T5 = 1.0 / T4 ;
        end else if ( 2.0e0 - `epsm10 <= UC_RDRBB && UC_RDRBB <= 2.0e0 + `epsm10 ) begin
            T5 = 1.0 / sqrt( T4 ) ;
        end else  begin
            T6 = `Fn_Pow( T4 , ( - 1.0e0 / UC_RDRBB - 1.0e0 ) ) ;
            T5 = T4 * T6 ;
        end
        Mu = Mu0 * T5 ;
        //-----------------------------------------------------------*
        //* Carr : carrier density
        //*-----------------//
        T4 = 1.0e0 + T1 ;
        T5 = 1.0 / T4 ;
        T4 = 1.0 + Car * ( 1.0 - T5 ) * Vddpz /  ( Ldrifte - RDRDL2 ) ;
        `Fn_SL( T5, T4, 0.0, 1e-3, T0 )
        Carr1 = Noverd * T5 ;
        Carr2 = RD_QbuLD / `C_QE * RDRQOVER ;
        `Fn_SU( Carr2, Carr2, Carr1, Carr1*1e-3, T0)
        Carr = Carr1 - Carr2 ;
        if ( NDRIDLT > 0 && NDRILIM > 1.0 ) begin
            `Fn_SU_CP( T2 , Carr , Noverd*NDRILIM , Noverd*NDRIDLT , NDRIPW , T0 )
            Carr = T2 ;
        end
`ifdef _AGING_
        //        COFIXAG  =1(new)  =0(old)
        Vdseeff = COFIXAG ? AVddp : Vtraplx_prv ;
        DVddp = TRAPDVDDP + DVddp * lexp( - Vdseeff / TRAPDLX ) ;
`ifdef _DEBUG_
        $write("DVddp= %g Vddpz = %g Vdseeff = %g TRAPDLX=%g \n",DVddp, Vddpz, Vdseeff, TRAPDLX);
`endif
        Carr = Carr + Noverd * DVddp ;
`endif

        //-----------------------------------------------------------*
        //* Xov : depth of the current flow
        //*-----------------//
        T0 = -RD_Ps0LD ;
        `Fn_SZ( T0 , T0 , 1.0e-2 , T9 )
        T0 = T0 + `epsm10 ;
        Wdepl  = sqrt ( kdep * T0 ) ;
        T2 = Vds - Vbs + VBI ;
        `Fn_SZ( T2 , T2 , 1.0e-2 , T9 )
        T2 = T2 + `epsm10 ;
        Wjunc0 = sqrt ( kjunc * T2 ) ;
        `Fn_SU( Wjunc, Wjunc0, Rd_Xldld, 10e-3*Rd_Xldld, T0 )
        Wrdrdjunc = RDRDJUNC + `Small ;
        Xov = Xmax * ( 1.0 - Cx * ( Wdepl / Wrdrdjunc + Wjunc / Rd_Xldld ));
        `Fn_SZ( Xov , Xov , (1.0 - UC_RDRCX) * Xmax / 100 , T9 )
        //-----------------------------------------------------------*
        //* Rd : drift resistance
        //*-----------------//
        T1 = `C_QE / ( Ldrifte + RDRDL1 );
        GD = T1 * Xov * Mu * Carr ;

`ifdef REPLACE_CLIPPING_WITH_SMOOTHING //revised for continuity (Rdd)
        `Fn_SL_CP(GD, GD, 0, `Small, 2, T0)
`else
        if ( GD <= 0 ) begin
            GD = `Small ;
        end
`endif

        Rdd  = 1 / GD ;

        // Weff dependence of the resistances //
        Rdd = Rdd / WeffLD_nf ;

        `Fn_SU_CP( Rdd, Rdd, 1e6, 1e3, 2, T0 )

        /* subnode modeling */
        if ( COSUBNODE == 1 &&
            ( UC_NOVER * ( `NSUBSUB + UC_NOVER ) ) > 0 ) begin
            ddriftld = `DDRIFT - Wdep ;
            Rdd = Rdd * Ldrift0 / ddriftld ;
        end

        // Sheet resistances are added. //
        Rdd = Rdd + Rd0 ;

        // Re-stamps for hsmhvnoi.c //
        if ( Rdd > `Res_min && COTHRML != 0 ) drainConductance = Mfactor / Rdd ;
        else drainConductance = 0.0 ;

        if (Rdd < `Res_min) begin
            Rdd = `Res_min ;
        end
        // Clamping to Res_min //
        Rdde = Rdd / Mfactor ;

    end //  if ( flg_rd == 0)
end //  HSMHV_eval_rdrift

// ---- end `include "HSMHV_eval_rdrift.inc" ----
    end else begin // UC_CORDRIFT == 0
        // Clamping to Res_min //
        // 20161025 Might need use flooring function to avoid zero and not to hinder VA`s autogeneration of derivative codes.
        if (Rdd < `Res_min) begin
            Rdd = `Res_min ;
        end
        if (Rsd < `Res_min) begin
            Rsd = `Res_min ;
        end
        if ( VdseModeNML > 0.0 ) begin
            Rdde = Rdd / Mfactor ;
            Rsde = Rsd / Mfactor ;
        end else begin
            Rdde = Rsd / Mfactor ;
            Rsde = Rdd / Mfactor ;
        end
    end // if( UC_CORDRIFT == 1 ) else block
    //-----------------------------------------------------------*
    //* End of New Drift Resistance Model.
    //*-----------------//

    // *-------------------------------------------------------------
    // * Actually load the device currents                 hsmhvld.c
    // *

    // note: Rdde and Rsde are already subjected to mode handling,
    Rdd       = Rdde ;
    Rsd       = Rsde ;
    // note: igd and igs are already subjected to mode handling,
    Igd       =   igde ;
    Igs       =   igse ;
    Igb       =   igbe ;
    if ( mode > 0 ) begin // forward mode //
        Ids       = idse ;
        Qd        = qde ;
        Qg        = qge ;
        Qs        = qse ;
        Qb        = - (qge + qde + qse) ;
        Isub      = isube ;
        Isubs     = 0.0 ;
        IsubLD    = IsubLDe ;
        IsubLDs   = 0.0 ;
        IdsIBPC   = IdsIBPCe ;
        IdsIBPCs  = 0.0 ;
        Ibjt  = Ibjte; // 20160414
        Ibjts = 0.0;   // 20160414
        Ibreak    = Ibreake ;
        Ibreaks   = 0.0 ;
        Igidl     = igidle ;
        Igisl     = igisle ;

        //---------------------------------------------------*
        if (flg_nqs) begin
            Qdrat   = Xd         ;
        end

    end else begin // reverse mode //
        Ids       = - idse ;
        Qd        =   qse ;
        Qg        =   qge ;
        Qs        =   qde ;
        Qb        = - (qge + qde + qse) ;
        Isub      = 0.0 ;
        Isubs     =   isube ;
        IsubLD    = 0.0 ;
        IsubLDs   =   IsubLDe ;
        IdsIBPC   = 0.0 ;
        IdsIBPCs  =   IdsIBPCe ;
        Ibjt     = 0.0;    // 20160414
        Ibjts    = Ibjte;  // 20160414
        Ibreak    = 0.0 ;
        Ibreaks   = Ibreake ;
        Igidl     =   igisle ;
        Igisl     =   igidle ;

        //---------------------------------------------------*
        if (flg_nqs) begin
            Qdrat   =   1.0 - Xd         ;
        end
    end // end of reverse mode //
    // note: independent of Vds mode:
    Qg = Qg + qgov ;
    Qd = Qd + qdov ;
    Qs = Qs + qsov ;
    Qb = - (Qg + Qd + Qs) ;
    // note: independent of Vdse mode:
    Qfd       = qdp ;
    Qfs       = qsp ;
    Qdext     = qdexte ;
    Qgext     = qgexte ;
    Qbext     = - (qgexte + qdexte + qsexte) ;

    if (COSELFHEAT > 0) begin
        if (RTH > `C_RTH_MIN) begin
            Gth = 1.0/RTH ;
        end else begin
            Gth = 1.0/`C_RTH_MIN ;
        end
        //     P = Ids * (Vdsi + param * ( Vdse - Vdsi)) //
        //       = Ids * Veffpower                       //
        if ( Vdsi *(Vdsei - Vdsi) >= 0.0) begin
            if ( UC_POWRAT == 1.0 ) begin
                Veffpower = Vdsei ;
            end else begin
                Veffpower = Vdsi + powratio * (Vdsei - Vdsi) ;
            end
        end else begin
            Veffpower   = Vdsi ;
        end
        P  = Ids  * Veffpower ;

        if ( COSELFHEAT == 1 ) begin
            // Clamping the maximum temperature rise (SHEMAX) //
            T1 = SHEMAX * Gth ;
            `Fn_SU( T2 , P , T1 , SHEMAXDLT * Gth , T0 )
            P = T2 ;
        end

    end else begin
        Gth = 0.0 ;
        P   = 0.0 ;
    end

    // in case of nqs: construct static contributions to the nqs equations(Iqi_nqs, Iqb_nqs)       //
    //   and nqs charge contributions to inner drain, gate and source node(Qd_nqs, Qg_nqs, Qs_nqs) //
    if (flg_nqs) begin
        // .. tau, taub must be > 0 //
        if (tau < `tau_min) begin
            tau = `tau_min ;
        end
        if (taub < `tau_min) begin
            taub = `tau_min ;
        end
        Iqi_nqs          = (Qi_nqs - Qi) / tau ;
        Iqb_nqs          = (Qb_nqs - Qbulk) / taub ;
        Qd_nqs           = Qi_nqs * Qdrat ;
        Qg_nqs           = - Qi_nqs - Qb_nqs ;
        Qs_nqs           =   Qi_nqs * (1.0 - Qdrat) ;
    end else begin
        Iqi_nqs = 0.0 ; Iqb_nqs = 0.0 ; Qd_nqs = 0.0 ; Qg_nqs = 0.0 ; Qs_nqs = 0.0 ;
    end

    //---------------------------------------------------*
    //*
    //--print Op points--------*/
    idse    =  TYPE * mode * Ids ;
    Isuba   =  TYPE * (Isub + Isubs) ;

    ggds    =  ddx(idse,V(dp)) ;
    gdse = ggds ;
    ggdss   =  ddx(idse,V(sp)) ;
    gme     =  ddx(idse,V(gp)) ;
    gmbse   =  ddx(idse,V(bp)) ;
    gmte    =  ddx(idse,V(temp));
    gmte    =  ddx(idse,V(temp));

    gbgs    =  ddx(Isuba,V(gp));
    gbdsd   =  ddx(Isuba,V(dp));
    gbdss   =  ddx(Isuba,V(sp));
    gbds    =  gbdsd + gbdss ;
    gbbs    =  ddx(Isuba,V(bp));

    cggbd   =  ddx(Qg,V(gp)) ;
    cggbd = TYPE * cggbd ;
    cgdbd   =  ddx(Qg,V(dp)) ;
    cgdbd = TYPE * cgdbd ;
    cgsbd   =  ddx(Qg,V(sp)) ;
    cgsbd = TYPE * cgsbd ;
    cgbbd   =  ddx(Qg,V(bp)) ;
    cgbbd = TYPE * cgbbd ;

    cdgbd   =  ddx(Qd,V(gp)) ;
    cdgbd = TYPE * cdgbd ;
    cddbd   =  ddx(Qd,V(dp)) ;
    cddbd = TYPE * cddbd ;
    cdsbd   =  ddx(Qd,V(sp)) ;
    cdsbd = TYPE * cdsbd ;
    cdbbd   =  ddx(Qd,V(bp)) ;
    cdbbd = TYPE * cdbbd ;

    cbgbd   =  ddx(Qb,V(gp)) ;
    cbgbd = TYPE * cbgbd ;
    cbdbd   =  ddx(Qb,V(dp)) ;
    cbdbd = TYPE * cbdbd ;
    cbsbd   =  ddx(Qb,V(sp)) ;
    cbsbd = TYPE * cbsbd ;
    cbbbd   =  ddx(Qb,V(bp)) ;
    cbbbd = TYPE * cbbbd ;

    csgbd   =  ddx(Qs,V(gp)) ;
    csgbd = TYPE * csgbd ;
    csdbd   =  ddx(Qs,V(dp)) ;
    csdbd = TYPE * csdbd ;
    cssbd   =  ddx(Qs,V(sp)) ;
    cssbd = TYPE * cssbd ;
    csbbd   =  ddx(Qs,V(bp)) ;
    csbbd = TYPE * csbbd ;

    cgdobe  =  ddx(qgov,V(d))  ;
    cgdobe = TYPE * cgdobe ;
    cgsobe  =  ddx(qgov,V(s))  ;
    cgsobe = TYPE * cgsobe ;
    cgdobd  =  ddx(qgov,V(dp)) ;
    cgdobd = TYPE * cgdobd + cgdobe ;
    cgsobd  =  ddx(qgov,V(sp)) ;
    cgsobd = TYPE * cgsobd + cgsobe ;
    cgbobd  =  ddx(qgov,V(bp)) ;
    cgbobd = TYPE * cgbobd ;

    if (mode == `HiSIM_NORMAL_MODE) begin

        cggb  = cggbd ;
        cgdb  = cgdbd ;
        cgsb  = cgsbd ;

        cdgb  = cdgbd ;
        cddb  = cddbd ;
        cdsb  = cdsbd ;

        cbgb  = cbgbd ;
        cbdb  = cbdbd ;
        cbsb  = cbsbd ;

    end else begin
        ggds  = ggdss ;
        cggb  = cggbd ;
        cgdb  = cgsbd ;
        cgsb  = cgdbd ;

        cdgb  = csgbd ;
        cddb  = cssbd ;
        cdsb  = csdbd ;

        cbgb  = cbgbd ;
        cbdb  = cbsbd ;
        cbsb  = cbdbd ;

    end

    /* Temperatures */
    TK = TTEMP ;
    DTSH = deltemp ;

`ifdef COEXTDIO
        /* for Junction Diode Model */
`else
        ibdb    =  TYPE * Ibd  ;
        ibsb    =  TYPE * Ibs  ;
        ibdbi   =  TYPE * Ibdi ;
        ibsbi   =  TYPE * Ibsi ;
        Gbd     =  ddx(ibdb,V(db));
        Gbs     =  ddx(ibsb,V(sb));
        capbdb  =  Capbd  ;
        capbsb  =  Capbs  ;
        capbdbi =  Capbdi ;
        capbsbi =  Capbsi ;
`endif /* End of COEXTDIO */

`ifdef _AGING_
        DVTBTI = dVth_bti ;
        NTRAP0 = nt0s ;
        NTRAPL = ntls ;
`endif

    OP_mode  = mode  ;
    OP_Vdsi  = Vdsi  ;
    OP_Vbscl = Vbscl ;

    // print all outputs ------------VV //
    if ( INFO >= 8 ) begin
        $write( "von,vdsat = %18.10e %18.10e \n" , Von, Vdsat ) ;
        $write( "Ids       = %18.10e \n" , idse ) ;
        $write( "Rdd,Rdd   = %18.10e %18.10e \n" , Rdd , Rsd ) ;
        $write( "gds       = %18.10e \n" , gdse ) ;
        $write( "gm        = %18.10e \n" , gme  ) ;
        $write( "gmbs      = %18.10e \n" , gmbse) ;
        $write( "gmt       = %18.10e \n" , gmte ) ;
        $write( "Qg        = %18.10e \n" , Qg ) ;
        $write( "Qd        = %18.10e \n" , Qd ) ;
        $write( "Qs        = %18.10e \n" , Qs  ) ;
        $write( "cggb      = %18.10e \n" , cggb  ) ;
        $write( "cgsb      = %18.10e \n" , cgsb  ) ;
        $write( "cgdb      = %18.10e \n" , cgdb  ) ;
        $write( "cbgb      = %18.10e \n" , cbgb  ) ;
        $write( "cbsb      = %18.10e \n" , cbsb  ) ;
        $write( "cbdb      = %18.10e \n" , cbdb  ) ;
        $write( "cdgb      = %18.10e \n" , cdgb  ) ;
        $write( "cdsb      = %18.10e \n" , cdsb  ) ;
        $write( "cddb      = %18.10e \n" , cddb  ) ;
        $write( "Isub      = %18.10e \n" , Isuba ) ;
        $write( "gbgs      = %18.10e \n" , gbgs ) ;
        $write( "gbds      = %18.10e \n" , gbds ) ;
        $write( "gbbs      = %18.10e \n" , gbbs ) ;
        $write( "tau,taub  = %18.10e %18.10e\n" , tau, taub ) ;
        $write( "Qi   ,Qi_nqs,Iqi_nqs = %18.10e %18.10e %18.10e\n" , Qi   , Qi_nqs, Iqi_nqs ) ;
        $write( "Qbulk,Qb_nqs,Iqb_nqs = %18.10e %18.10e %18.10e\n" , Qbulk, Qb_nqs, Iqb_nqs ) ;

`ifdef _AGING_
            $write( "DVTBTI    = %18.10e \n" , DVTBTI) ;
            $write( "NTRAP0    = %18.10e \n" , NTRAP0) ;
            $write( "NTRAPL    = %18.10e \n" , NTRAPL) ;
`endif

`ifdef COEXTDIO
            /* for Junction Diode Model */
`else
            $write( "Ibd,Ibs     = %18.10e %18.10e\n" , ibdb , ibsb ) ;
            $write( "Ibdi,Ibsi   = %18.10e %18.10e\n" , ibdbi, ibsbi ) ;
            $write( "Gbd,Gbs     = %18.10e %18.10e\n" , Gbd  , Gbs ) ;
            $write( "Capbd,Capbs = %18.10e %18.10e\n" , capbdb , capbsb ) ;
            $write( "Capbdi,Capbsi = %18.10e %18.10e\n" , capbdbi, capbsbi ) ;
            $write( "Qbd,Qbs     = %18.10e %18.10e\n" , Qbd , Qbs ) ;
            $write( "Qbdi,Qbsi   = %18.10e %18.10e\n" , Qbdi , Qbsi ) ;
`endif /* End of COEXTDIO */

    end
    // print all outputs ------------AA //

    //`include "dbgprn5.cnt"

    // Drain , Substrate ,  GIDL and GISL Currents
    I(BRdpsp) <+  TYPE * (Ids  + IdsIBPC - IdsIBPCs ) ;
    I(BRds  ) <+  TYPE * ( Ibreak - Ibreaks ); // Ibreak, -Ibreaks revived 20161016.
    I(BRdpbp) <+  TYPE * (Igidl + Isub  + Ibjt  ); // Ibreak added 20160204; Ibreak removed; Ibjt entered 20160414; Ibreak revived 20161012; removed 20161016
    I(BRspbp) <+  TYPE * (Igisl + Isubs + Ibjts );  // Ibreaks added 20160204; Ibreaks removed; Ibjts entered    20160414; Ibreaks revived 20161012; removed 20161016
    I(BRdbp ) <+  TYPE * IsubLD ;
    I(BRsbp ) <+  TYPE * IsubLDs ;

`ifdef COEXTDIO
        /* for Junction Diode Model */
`else
        // Junction Diode Currents
        I(BRsbs ) <+  TYPE * Ibs ;
        I(BRdbd ) <+  TYPE * Ibd ;
        I(BRsbs ) <+  TYPE * ddt(Qbs) ;
        I(BRdbd ) <+  TYPE * ddt(Qbd) ;
        if ( CODIO > 0 ) begin //new model:
            I(BRbpsp) <+  TYPE * Ibsi ;
            I(BRbpdp) <+  TYPE * Ibdi ;
            I(BRbpsp) <+  TYPE * ddt(Qbsi) ;
            I(BRbpdp) <+  TYPE * ddt(Qbdi) ;
        end
        //     wk_loadIbs=Ibs; wk_loadIbsi=Ibsi; wk_idsibpce = IdsIBPCe;  // probing only

`endif /* End of COEXTDIO */

    // Gate Leakage Currents
    if (COIIGS == 1) begin
        I(BRgpsp) <+  TYPE * Igs;
        I(BRgpdp) <+  TYPE * Igd;
        I(BRgpbp) <+  TYPE * Igb;
    end

    // Source & Drain Resistance Currents
    //flg_rd = (CORD > 0) ? 1:0; // moved upfront
    //flg_rs = (CORS > 0) ? 1:0; // moved upfront
    if (flg_rd) I(BRddp ) <+ V(BRddp ) / Rdd; else V(BRddp ) <+ 0.0 ;
    if (flg_rs) I(BRsps ) <+ V(BRsps ) / Rsd; else V(BRsps ) <+ 0.0 ;

    //
    // Inner Capacitance Currents
    I(BRgpsp) <+  TYPE * ddt(Qg + Qg_nqs);
    I(BRdpsp) <+  TYPE * ddt(Qd + Qd_nqs);
    I(BRbpsp) <+  TYPE * ddt(Qb - (Qg_nqs + Qd_nqs + Qs_nqs));
    I(BRgps)  <+  TYPE * ddt(Qgext);
    I(BRds)   <+  TYPE * ddt(Qdext);
    I(BRbps)  <+  TYPE * ddt(Qbext);

    // Outer Fringe Capacitance Currents
    I(BRgpd ) <+ -TYPE * ddt(Qfd);
    I(BRgps ) <+ -TYPE * ddt(Qfs);
    //
    // Noise Currents
    if ( flg_rsrd != 1 && flg_rsrd != 3 && UC_CORDRIFT != 1 ) begin
        drainConductance = 0.0 ; sourceConductance = 0.0 ;
    end
    // 1/F Noise
    I(BRdpsp) <+ flicker_noise(mode * noiflick * `Kflic , UC_FALPH  , "iflick"); //updated for Pnoise
    // Thermal Noise & IG Noise
    I(n)      <+ 1*V(n) ;
    I(n)      <+ white_noise(sid , "internal") ;  // modified because of VAMPyRE ERROR
    I(BRdpsp) <+ white_noise((1.0-ci*ci)*sid , "ids") ;  // modified because of VAMPyRE ERROR
    I(BRdpsp) <+ ci*V(n) ;
    I(BRgpsp) <+ ddt(V(n)*sigrat_s) ;
    I(BRgpdp) <+ ddt(V(n)*sigrat_d) ;

    if (flg_rs) I(BRsps ) <+ white_noise(whi_noise * sourceConductance , "isource");
    if (flg_rd) I(BRddp ) <+ white_noise(whi_noise * drainConductance  , "idrain");
    // Shot Noise
    I(BRgpdp) <+ white_noise(`C_QE2 * abs(Igd) , "iigd");
    I(BRgpsp) <+ white_noise(`C_QE2 * abs(Igs) , "iigs");
    I(BRgpbp) <+ white_noise(`C_QE2 * abs(Igb) , "iigb");
    //
    // Gate Resistance Currents
    if (CORG ==1 && RSHG > 0.0) I(BRggp) <+ grg * V(BRggp);
    else V(BRggp) <+ 0.0 ;
    //
    // Substrate Resistance Network
    if (CORBNET) begin
        I(BRsbbp) <+  grbps * V(BRsbbp) ;
        I(BRdbbp) <+  grbpd * V(BRdbbp) ;
        I(BRbbp ) <+  grbpb * V(BRbbp ) ;
    end else begin
        V(BRbbp ) <+  0.0 ;
        V(BRsbbp) <+  0.0 ;
        V(BRdbbp) <+  0.0 ;
    end
    //     wk_vbrbbp = V(BRbbp); wk_ibrbbp = grbpb * V(BRbbp);  // probing 20180410
    //
    // Thermal Node Currents with thermal dissipation
    if (COSELFHEAT > 0) begin
        Itemp = P ;
        I(temp) <+ V(temp) * Gth ;
        I(temp) <+ - Itemp;
    end else begin
        CTH = 0.0;
        I(temp) <+ V(temp)*1e4;
    end
    I(temp) <+ ddt(CTH*V(temp));
    //
    // NQS Node Currents
    if (CONQS) begin
        I(qi) <+ Iqi_nqs;
        I(qb) <+ Iqb_nqs;
        Cqi = 1.0;
        Cqb = 1.0;
        I(qi) <+ ddt(Cqi*V(qi));
        I(qb) <+ ddt(Cqb*V(qb));
    end else begin
        V(qi) <+ 0.0;
        V(qb) <+ 0.0;
    end
    // NQS Node Currents for Qover
    if (CONQSOV) begin
        I(qbd) <+ Ibd_nqs;
        I(qbd) <+ ddt(V(qbd));
    end else begin
        V(qbd) <+ 0;
    end

`ifdef _AGING_
        // **************************************** //
        // integration Isub & Ontime
        // **************************************** //
        T0 =  TYPE * Isuba ;
        T0 = ( T0 < 0 || `pretime > $abstime ) ? 0.0 : T0 ;
        T1 =  TYPE * idse ;
        T1 = ( T1 < 0 || `pretime > $abstime ) ? 0.0 : T1 ;
        V(idtag1) <+ idt( T0 , 0 );
        V(idtag2) <+ idt( T1 , 0 );
        T2 = ( Vgs > Vth  && TRAPA > 0 && `pretime < $abstime ) ? 1.0 : 0.0 ;
        T3 = ( Vgs > Vth  && TRAPA > 0 && `pretime < $abstime ) ? Vgs : 0.0 ;
        if ( TRAPA > 0 && CODEGSTEP == 1 ) begin      // for BTI model
            V(idtag3) <+ idt( T2 , 0 ); // On time
            V(idtag4) <+ idt( T3 , 0 ); // Vgp
        end else begin
            V(idtag3) <+ 0 ;
            V(idtag4) <+ 0 ;
        end
        if ( CODEG == 1 && TRAPA > 0 ) begin          // for BTI model
            V(dVfb)   <+ dVth_bti ;
        end else begin
            V(dVfb)   <+ 0 ;
        end
        if ( CODEG == 1 && TRAPGC1MAX > 0 ) begin      // for HC model
            V(vgc1)    <+ gc1/1e24;
            V(ve1)     <+ e1;
        end else begin
            V(vgc1)    <+ 0 ;
            V(ve1)     <+ 0 ;
        end
        if ( TRAPGC1MAX > 0 && CODEGSTEP == 0 ) begin  // for HC model
            V(ps0)     <+ Ps0_prv ;
            V(vtraplx) <+ Vtraplx_prv ;
        end else begin
            V(ps0)     <+ 0 ;
            V(vtraplx) <+ 0 ;
        end
        // ************************************************ //
        // output the degradation file for aging simulation
        // ************************************************ //
        if ( CODEG == 1 && CODEGSTEP == 0 ) begin
            fno=$fopen("degradation.out") ;
            ivgs = V(g,s) ;
            ivds = V(d,s) ;
            ivbs = V(b,s) ;
            $fdisplay(fno,".param %M_DEGTIME=%g %M_gc1deg=%.5e %M_es1deg=%.5g %M_dVthbti=%.5g %M_Dvddpdeg=%.5g %M_TRAPGC1=%g %M_TRAPGC2=%g %M_TRAPGC1MAX=%g %M_TRAPGCTIME1=%g %M_TRAPGCTIME2=%g %M_TRAPES1=%g %M_TRAPES2=%g %M_TRAPES1MAX=%g %M_TRAPLX=%g \n*     Isub_trap=%g Ids=%g VGDEG:%g VDDEG:%g VBDEG:%g",
            DEGTIME,gc1*`C_cm2m_p3,e1,dVth_bti,DVddp,
            TRAPGC1,TRAPGC2,TRAPGC1MAX,TRAPGCTIME1,TRAPGCTIME2,TRAPES1,TRAPES2,TRAPES1MAX,TRAPLX,
            Isub_trap,Ids,ivgs,ivds,ivbs) ;
        end
        if ( CODEG == 1 && CODEGSTEP == 1 ) begin
            @(final_step("tran")) begin
                fno=$fopen("degtran.out") ;
                $fdisplay(fno,".param %M_DEGTIME=%g %M_gc1deg=%.5e %M_es1deg=%.5g %M_dVthbti=%.5g %M_Dvddpdeg=%.5g \n*     Isub_trap=%g Ids=%g tcycle=%g Vgsonave=%g time:%g ",
                DEGTIME,gc1*`C_cm2m_p3,e1,dVth_bti,DVddp, Isub_trap,Ids, tcycle,Vgsonave, $abstime) ;
            end
        end

`endif

    //`include "dbgprn5.cnt"

end
//================ End of executable code.=================//
// ---- end `include "HSMHV_module.inc" ----

endmodule
