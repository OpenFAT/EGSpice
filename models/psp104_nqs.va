//======================================================================================
//======================================================================================
// Filename: psp104_nqs.va
//======================================================================================
//======================================================================================
//
//  (c) Copyright notice
//
//  Since 2015 until today, PSP has been co-developed by NXP Semiconductors and
//  CEA-Leti. For this part of the model, each claim undivided ownership and copyrights
//  Since 2012 until 2015, PSP has been co-developed by NXP Semiconductors and
//  Delft University of Technology. For this part of the model, each claim undivided
//  ownership and copyrights
//  Until and including 2011, PSP has been co-developed by NXP Semiconductors and
//  Arizona State University. For this part of the model, NXP Semiconductors claims
//  undivided ownership and copyrights.
//
//
//  Version: 104.1.0 (PSP), 200.7.0 (JUNCAP), March 2026
//
//======================================================================================
//======================================================================================
//
// Further information can be found in the file releasenotesPSP104.txt
//

`include "constants.vams"
`include "disciplines.vams"

`include "discipline.h"

`define NQSmodel true

// ---- begin `include "Common104_macrodefs.include" ----
//======================================================================================
//======================================================================================
// Filename: Common104_macrodefs.include
//======================================================================================
//======================================================================================
//
//  (c) Copyright notice
//
//  Since 2015 until today, PSP has been co-developed by NXP Semiconductors and
//  CEA-Leti. For this part of the model, each claim undivided ownership and copyrights
//  Since 2012 until 2015, PSP has been co-developed by NXP Semiconductors and
//  Delft University of Technology. For this part of the model, each claim undivided
//  ownership and copyrights
//  Until and including 2011, PSP has been co-developed by NXP Semiconductors and
//  Arizona State University. For this part of the model, NXP Semiconductors claims
//  undivided ownership and copyrights.
//
//
//  Version: 104.1.0 (PSP), 200.7.0 (JUNCAP), March 2026
//
//======================================================================================
//======================================================================================
//
// Further information can be found in the file releasenotesPSP104.txt
//

//////////////////////////////////////////////////////////////
//
//  General macros and constants for compact va-models
//
//////////////////////////////////////////////////////////////

// Clipping functions
`define CLIP_LOW(val,min)      ((val)>(min)?(val):(min))
`define CLIP_HIGH(val,max)     ((val)<(max)?(val):(max))
`define CLIP_BOTH(val,min,max) ((val)>(min)?((val)<(max)?(val):(max)):(min))

// Min/Max functions
`define MAX(x,y)              ((x)>(y)?(x):(y))
// `define MIN(x,y)              ((x)<(y)?(x):(y))

// Mathematical constants
`define PI                    3.1415926535897931
`define SQRTPI                1.77245385090551603

// Physical constants
`define KELVINCONVERSION      273.15
`define KBOL                  1.3806505E-23
`define QELE                  1.6021918E-19
`define HBAR                  1.05457168E-34
`define MELE                  9.1093826E-31
`define EPSO                  8.8541878176E-12
`define EPSRSI                11.8

// Other constants
`define oneThird              3.3333333333333333e-01
`define twoThirds             6.6666666666666667e-01

// Constants needed in safe exponential function (called "expl")
`define se                    4.6051701859880916e+02
`define se05                  2.3025850929940458e+02
`define ke                    1.0e-200
`define ke05                  1.0e-100
// `define keinv                 1.0e200
`define ke05inv               1.0e100

//  P3       3rd order polynomial expansion of exp()
`define P3(u) (1.0 + (u) * (1.0 + 0.5 * ((u) * (1.0 + (u) * `oneThird))))

//  expl     exp() with 3rd order polynomial extrapolation for very low values (exp_low),
//           very high values (exp_high), or both (expl)
`define expl(x, res) \
    if (abs(x) < `se05) begin \
        res       = exp(x); \
    end else begin \
        if ((x) < 0.0) begin \
            res       = `ke05 / `P3(-`se05 - (x)); \
        end else begin \
            res       =  `ke05inv * `P3((x) - `se05); \
        end \
    end

`define expl_low(x, res) \
    if ((x) > -`se05) begin \
        res       =  exp(x); \
    end else begin \
        res       = `ke05 / `P3(-`se05 - (x)); \
    end

`define expl_high(x, res) \
    if ((x) < `se05) begin \
        res       = exp(x); \
    end else begin \
        res       =  `ke05inv * `P3((x) - `se05); \
    end

//  Exchange function
`define swap(a, b) \
    temp = a; \
    a    = b; \
    b    = temp;

// Log-Exp form of smoothed min/max functions
`define ELIM               37.0 // exp(-ELIM) is approximately machine epsilon, from PSPHV
// `define MINE(x, y, a)         ((x)<(y) ? (((x)-(y))/(a)<-`ELIM ? (x) : (x)-ln(1.0+exp(((x)-(y))/(a)))*(a)) : (((x)-(y))/(a)>`ELIM ? (y) : (y)-ln(1.0+exp(((y)-(x))/(a)))*(a))) // adapted from PSPHV : a -> 1/a
`define MAXE(x, y, a)         ((x)<(y) ? (((x)-(y))/(a)<-`ELIM ? (y) : (y)+ln(1.0+exp(((x)-(y))/(a)))*(a)) : (((x)-(y))/(a)>`ELIM ? (x) : (x)+ln(1.0+exp(((y)-(x))/(a)))*(a))) // adapted from PSPHV : a -> 1/a

//  Parameter definition macros: "des" description argument is intended to
//  be a short description, the "inf" information argument is intended to be
//  a detailed description (e.g. for display as part of on-line help).
//
//  MPR      model    parameter real
//  MPI      model    parameter integer
//  IPR      instance parameter real
//  IPI      instance parameter integer
//  OPP      operating point parameter, includes units and description for printing
//  OPM      operating point parameter, scales with $mfactor
//  OPD      operating point parameter, scales with 1/$mfactor
//
//  Instance parameters have the attribute *type="instance"* and note that
//  compilers treat these as both instance and model parameters, with a
//  specified instance value taking precedence over a specified model card value.
//
//  There are some issues with passing range directives with some compilers,
//  so for each parameter declaration there are multiple versions:
//  cc       closed lower bound, closed upper bound
//  co       closed lower bound, open   upper bound
//  cz       closed lower bound of zero (no upper bound)
//  oc       open   lower bound, closed upper bound
//  oo       open   lower bound, open   upper bound
//  oz       open   lower bound of zero (no upper bound)
//  nb       no bounds
//  sw       switch (integer only, values  0=false  and >0=true)
//  ty       switch (integer only, values -1=n-type and +1=p-type)
//

// `define ALIAS(alias,paramName) aliasparam alias = paramName;
`define OPP(nam,uni,des)               (*units=uni,                             desc=des*)           real    nam;
`define OPM(nam,uni,des)               (*units=uni, multiplicity="multiply",    desc=des*)           real    nam;
`define OPD(nam,uni,des)               (*units=uni, multiplicity="divide",      desc=des*)           real    nam;
`define MPRcc(nam,def,uni,lwr,upr,des) (*units=uni                            , desc=des*) parameter real    nam=def from[lwr:upr];
`define MPRco(nam,def,uni,lwr,upr,des) (*units=uni                            , desc=des*) parameter real    nam=def from[lwr:upr);
`define MPRcz(nam,def,uni,        des) (*units=uni                            , desc=des*) parameter real    nam=def from[  0:inf);
// `define MPRoc(nam,def,uni,lwr,upr,des) (*units=uni                            , desc=des*) parameter real    nam=def from(lwr:upr];
// `define MPRoo(nam,def,uni,lwr,upr,des) (*units=uni                            , desc=des*) parameter real    nam=def from(lwr:upr);
`define MPRoz(nam,def,uni,        des) (*units=uni                            , desc=des*) parameter real    nam=def from(  0:inf);
`define MPRnb(nam,def,uni,        des) (*units=uni                            , desc=des*) parameter real    nam=def;
`define MPIcc(nam,def,uni,lwr,upr,des) (*units=uni                            , desc=des*) parameter integer nam=def from[lwr:upr];
// `define MPIco(nam,def,uni,lwr,upr,des) (*units=uni                            , desc=des*) parameter integer nam=def from[lwr:upr);
// `define MPIcz(nam,def,uni,        des) (*units=uni                            , desc=des*) parameter integer nam=def from[  0:inf);
// `define MPIoc(nam,def,uni,lwr,upr,des) (*units=uni                            , desc=des*) parameter integer nam=def from(lwr:upr];
// `define MPIoo(nam,def,uni,lwr,upr,des) (*units=uni                            , desc=des*) parameter integer nam=def from(lwr:upr);
// `define MPIoz(nam,def,uni,        des) (*units=uni                            , desc=des*) parameter integer nam=def from(  0:inf);
`define MPInb(nam,def,uni,        des) (*units=uni                            , desc=des*) parameter integer nam=def;
// `define MPIsw(nam,def,uni,        des) (*units=uni                            , desc=des*) parameter integer nam=def from[  0:inf);
`define MPIty(nam,def,uni,        des) (*units=uni                            , desc=des*) parameter integer nam=def from[ -1:  1] exclude 0;
`define IPRcc(nam,def,uni,lwr,upr,des) (*units=uni, type="instance",            desc=des*) parameter real    nam=def from[lwr:upr];
`define IPRco(nam,def,uni,lwr,upr,des) (*units=uni, type="instance",            desc=des*) parameter real    nam=def from[lwr:upr);
`define IPRcz(nam,def,uni,        des) (*units=uni, type="instance",            desc=des*) parameter real    nam=def from[  0:inf);
// `define IPRoc(nam,def,uni,lwr,upr,des) (*units=uni, type="instance",            desc=des*) parameter real    nam=def from(lwr:upr];
// `define IPRoo(nam,def,uni,lwr,upr,des) (*units=uni, type="instance",            desc=des*) parameter real    nam=def from(lwr:upr);
// `define IPRoz(nam,def,uni,        des) (*units=uni, type="instance",            desc=des*) parameter real    nam=def from(  0:inf);
`define IPRnb(nam,def,uni,        des) (*units=uni, type="instance",            desc=des*) parameter real    nam=def;
// `define IPIcc(nam,def,uni,lwr,upr,des) (*units=uni, type="instance",            desc=des*) parameter integer nam=def from[lwr:upr];
// `define IPIco(nam,def,uni,lwr,upr,des) (*units=uni, type="instance",            desc=des*) parameter integer nam=def from[lwr:upr);
// `define IPIcz(nam,def,uni,        des) (*units=uni, type="instance",            desc=des*) parameter integer nam=def from[  0:inf);
// `define IPIoc(nam,def,uni,lwr,upr,des) (*units=uni, type="instance",            desc=des*) parameter integer nam=def from(lwr:upr];
// `define IPIoo(nam,def,uni,lwr,upr,des) (*units=uni, type="instance",            desc=des*) parameter integer nam=def from(lwr:upr);
// `define IPIoz(nam,def,uni,        des) (*units=uni, type="instance",            desc=des*) parameter integer nam=def from(  0:inf);
// `define IPInb(nam,def,uni,        des) (*units=uni, type="instance",            desc=des*) parameter integer nam=def;
// `define IPIsw(nam,def,uni,        des) (*units=uni, type="instance",            desc=des*) parameter integer nam=def from[  0:inf);
// ---- end `include "Common104_macrodefs.include" ----

// ---- begin `include "JUNCAP200_macrodefs.include" ----
//======================================================================================
//======================================================================================
// Filename: JUNCAP200_macrodefs.include
//======================================================================================
//======================================================================================
//
//  (c) Copyright notice
//
//  Since 2015 until today, PSP has been co-developed by NXP Semiconductors and
//  CEA-Leti. For this part of the model, each claim undivided ownership and copyrights
//  Since 2012 until 2015, PSP has been co-developed by NXP Semiconductors and
//  Delft University of Technology. For this part of the model, each claim undivided
//  ownership and copyrights
//  Until and including 2011, PSP has been co-developed by NXP Semiconductors and
//  Arizona State University. For this part of the model, NXP Semiconductors claims
//  undivided ownership and copyrights.
//
//
//  Version: 200.7.0, March 2026
//
//======================================================================================
//======================================================================================
//
// Further information can be found in the file releasenotesPSP104.txt
//

///////////////////////////////////////////
//
// Macros and constants used in JUNCAP2
//
///////////////////////////////////////////

// Other constants
`define MINTEMP          -2.5e2
`define vbilow            5.0e-2
`define a                 2.0
`define epsch             0.1
`define dvbi              5.0e-2
`define epsav             1.0e-6
`define vbrmax            1.0e3
`define vmaxlarge         1.0e8
`define aerfc             0.29214664
`define twothirds         0.666666666666667

// Clipping values
// `define levelnumber        2.0e2
`define AB_cliplow         0.0
`define LS_cliplow         0.0
`define LG_cliplow         0.0
`define MULT_cliplow       0.0
`define TRJ_cliplow        `MINTEMP
`define IMAX_cliplow       1.0e-12
`define FREV_cliplow       1.0e1
`define FREV_cliphigh      1.0e10
// `define IFACTOR_cliplow    0.0
// `define CFACTOR_cliplow    0.0
`define CJORBOT_cliplow    1.0e-12
`define CJORSTI_cliplow    1.0e-18
`define CJORGAT_cliplow    1.0e-18
`define VBIR_cliplow       `vbilow
`define P_cliplow          5.0e-2
`define P_cliphigh         0.95
`define IDSATR_cliplow     0.0
`define CSRH_cliplow       0.0
`define XJUN_cliplow       1.0e-9
`define CTAT_cliplow       0.0
`define MEFFTAT_cliplow    1.0e-2
`define CBBT_cliplow       0.0
`define VBR_cliplow        0.1
`define PBR_cliplow        0.1
`define VJUNREF_cliplow    0.5
`define FJUNQ_cliplow      0.0
`define FCJOR2_cliplow     0.0
`define F2_cliplow         1.0e-2
`define VTRGAT_cliplow     -1.0e2
`define VTRGAT_cliphigh    1.0e2
`define ANUGAT_cliplow     1.0e-3
`define ANUGAT_cliphigh    10.0
`define ADVBR_cliplow      0.0
`define BDVBR_cliplow      0.2
`define ADBBT_cliplow      0.0
`define BDBBT_cliplow      0.2

/////////////////////////////////////////////////////////////////////////////
//
//  Macro definitions.
//
//  Note that because at present locally scoped variables
//  can only be in named blocks, the intermediate variables
//  used in the macros below must be explicitly declared
//  as variables.
//
/////////////////////////////////////////////////////////////////////////////

// Variable declarations of variables that need to be *local* in juncap-express initialization

`define LocalGlobalVars \
    /*  Declaration of variables needed in macro "calcerfcexpmtat" */ \
    real ysq, terfc, erfcpos; \
    \
    /*  Declaration of variables needed in hypfunction 5 */ \
    real h1, h2, h2d, h3, h4, h5; \
    \
    /*  Declaration of variables calculated outside macro "juncapfunction", voltage-dependent part */ \
    real idmult, vj, z, zinv, two_psistar, vjlim, vjsrh, vbbt, vav; \
    \
    /*  Declaration of variables used within macro "juncapfunction" */ \
    real tmp, id; \
    real isrh, vbi_minus_vjsrh, wsrhstep, dwsrh, wsrh, wdep, asrh; \
    real itat, btat, twoatatoverthreebtat, umaxbeforelimiting, umax, sqrtumax, umaxpoweronepointfive; \
    real wgamma, wtat, ktat, ltat, mtat, xerfc, erfctimesexpmtat, gammamax; \
    real ibbt, Fmaxr; \
    real fbreakdown;

//  Initialization of (local) variables; required for some verilog-A compilers
`define JuncapLocalVarInit \
    ysq          =  0.0; \
    terfc        =  0.0; \
    erfcpos      =  0.0; \
    h1           =  0.0; \
    h2           =  0.0; \
    h2d          =  0.0; \
    h3           =  0.0; \
    h4           =  0.0; \
    h5           =  0.0; \
    idmult       =  0.0; \
    vj           =  0.0; \
    z            =  0.0; \
    zinv         =  0.0; \
    two_psistar  =  0.0; \
    vjlim        =  0.0; \
    vjsrh        =  0.0; \
    vbbt         =  0.0; \
    vav          =  0.0; \
    tmp          =  0.0; \
    id           =  0.0; \
    isrh         =  0.0; \
    vbi_minus_vjsrh =  0.0; \
    wsrhstep     =  0.0; \
    dwsrh        =  0.0; \
    wsrh         =  0.0; \
    wdep         =  0.0; \
    asrh         =  0.0; \
    itat         =  0.0; \
    btat         =  0.0; \
    twoatatoverthreebtat =  0.0; \
    umaxbeforelimiting =  0.0; \
    umax         =  0.0; \
    sqrtumax     =  0.0; \
    umaxpoweronepointfive = 0.0; \
    wgamma       =  0.0; \
    wtat         =  0.0; \
    ktat         =  0.0; \
    ltat         =  0.0; \
    mtat         =  0.0; \
    xerfc        =  0.0; \
    erfctimesexpmtat =  0.0; \
    gammamax     =  0.0; \
    ibbt         =  0.0; \
    Fmaxr        =  0.0; \
    fbreakdown   =  0.0;

// Instance parameter dependent initialization
`define JuncapInitInstance(AB_i, LS_i, LG_i, idsatbot, idsatsti, idsatgat, vbibot, vbisti, vbigat, PBOT_i, PSTI_i, PGAT_i, VBIRBOT_i, VBIRSTI_i, VBIRGAT_i, VMAX, exp_VMAX_over_phitd, vbimin, vch, vfmin, vbbtlim) \
    if (idsatbot * AB_i > 0.0) begin \
        vmaxbot      =  phitd * ln(IMAX / (idsatbot * AB_i) + 1.0); \
    end else begin \
        vmaxbot      = `vmaxlarge; \
    end \
    if (idsatsti * LS_i > 0.0) begin \
        vmaxsti      =  phitd * ln(IMAX / (idsatsti * LS_i) + 1.0); \
    end else begin \
        vmaxsti      = `vmaxlarge; \
    end \
    if (idsatgat * LG_i > 0.0) begin \
        vmaxgat      =  phitd * ln(IMAX / (idsatgat * LG_i) + 1.0); \
    end else begin \
        vmaxgat      = `vmaxlarge; \
    end \
    VMAX         =  min(min(vmaxbot, vmaxsti), vmaxgat); \
    `expl(VMAX * phitdinv, exp_VMAX_over_phitd) \
    \
    /*  Determination of minimum value of the relevant built-in voltages */ \
    /*  and determination of limiting value of conditioned voltage for BBT calculation */ \
    vbibot2      =  vbibot; \
    vbisti2      =  vbisti; \
    vbigat2      =  vbigat; \
    pbot2        =  PBOT_i; \
    psti2        =  PSTI_i; \
    pgat2        =  PGAT_i; \
    vbibot2r     =  VBIRBOT_i; \
    vbisti2r     =  VBIRSTI_i; \
    vbigat2r     =  VBIRGAT_i; \
    if (AB_i == 0.0) begin \
        vbibot2      =  vbisti + vbigat; \
        pbot2        =  0.9 * min(PSTI_i, PGAT_i); \
        vbibot2r     =  VBIRSTI_i + VBIRGAT_i; \
    end \
    if (LS_i == 0.0) begin \
        vbisti2      =  vbibot + vbigat; \
        psti2        =  0.9 * min(PBOT_i, PGAT_i); \
        vbisti2r     =  VBIRBOT_i + VBIRGAT_i; \
    end \
    if (LG_i == 0.0) begin \
        vbigat2      =  vbibot + vbisti; \
        pgat2        =  0.9 * min(PBOT_i, PSTI_i); \
        vbigat2r     =  VBIRBOT_i + VBIRSTI_i; \
    end \
    vbimin       =  min(min(vbibot2, vbisti2), vbigat2); \
    vch          =  vbimin * `epsch; \
    pmax         =  max(max(pbot2, psti2), pgat2); \
    vfmin        =  vbimin * (1.0 - (pow(`a, (-1.0 / (pmax))))); \
    vbbtlim      =  min(min(vbibot2r, vbisti2r), vbigat2r) - `dvbi;

// Special power-functions

`define mypower(x,power,result) \
    if (power == 0.5) begin \
        result       =  sqrt(x); \
    end else begin \
        result       =  pow(x, power); \
    end

`define mypower2(x,power,result) \
    if (power == -1.0) begin \
        result       =  1.0 / (x); \
    end else begin \
        result       =  pow(x, power); \
    end

`define mypower3(x,power,result) \
    if (power == 4.0) begin \
        result       =  (x) * (x) * (x) * (x); \
    end else begin \
        result       =  pow(abs(x), power); \
    end

// Smoothing functions
`define hypfunction2(x,x0,eps,hyp2) \
    hyp2         =  0.5 * ((x) + (x0) - sqrt(((x) - (x0)) * ((x) - (x0)) + 4.0 * (eps) * (eps)));

`define hypfunction5(x,x0,eps,hyp5) \
    h1           =  4.0 * (eps) * (eps); \
    h2           =  (eps) / (x0); \
    h2d          =  (x) + (eps) * h2; \
    h3           =  (x0) + h2d; \
    h4           =  (x0) - h2d; \
    h5           =  sqrt(h4 * h4 + h1); \
    hyp5         =  2.0 * ((x) * (x0) / (h3 + h5));

// A special function used to calculate TAT-currents,
// including an approximation of the erfc-function

`define calcerfcexpmtat(y,m,result) \
    ysq          =  y * y; \
    if (y > 0.0) begin \
        terfc        =  1.0 / (1.0 + perfc * y); \
    end else begin \
        terfc        =  1.0 / (1.0 - perfc * y); \
    end \
    `expl_low(-ysq + m, tmp) \
    erfcpos = (`aerfc * terfc + berfc * (terfc * terfc) + cerfc * (terfc * terfc * terfc)) * tmp; \
    if (y > 0.0) begin \
        result       =  erfcpos; \
    end else begin \
        `expl_low(m, tmp) \
        result       =  2.0 * tmp - erfcpos; \
    end

// This is the main function of the JUNCAP2-model. It returns the current and charge
// for a single diode

`define juncapQfunction(VAK,vj,qpref,qpref2,vbiinv,one_minus_P,Qjprime) \
    `mypower((1.0 - vj * vbiinv), one_minus_P, tmp) \
    Qjprime      =  CFACTOR * (qpref * (1.0 - tmp) + qpref2 * (VAK - vj));

`define juncapIfunction(VAK,one_minus_P,idsat,CSRH,CTAT,vbi,wdepnulr,VBIRinv,P,ftd,btatpart,atat,one_over_one_minus_P,CBBT,VBIR,wdepnulrinv,fbbt,VBR,VBRinv,PBR,fstop,slope,Ijprime) \
    id           =  idsat * idmult; \
    if ((CSRH == 0.0) && (CTAT == 0.0)) begin \
        isrh         =  0.0; \
    end else begin \
        vbi_minus_vjsrh =  vbi-vjsrh; \
        wsrhstep     =  1.0 - sqrt(1.0 - two_psistar / vbi_minus_vjsrh); \
        if (P == 0.5) begin \
            dwsrh        =  0.0; \
        end else begin \
            dwsrh        =  ((wsrhstep * wsrhstep * ln(wsrhstep) / (1.0 - wsrhstep)) + wsrhstep) * (1.0 - 2.0 * P); \
        end \
        wsrh         =  wsrhstep + dwsrh; \
        `mypower(vbi_minus_vjsrh * VBIRinv, P, tmp) \
        wdep         =  wdepnulr * tmp; \
        asrh         =  ftd * ((zinv - 1.0) * wdep); \
        isrh         =  CSRH * (asrh * wsrh); \
    end \
    if (CTAT == 0.0) begin \
        itat         =  0.0; \
    end else begin \
        btat         =  btatpart * ((wdep * one_minus_P) / vbi_minus_vjsrh); \
        twoatatoverthreebtat = (`twothirds * atat) / btat; \
        umaxbeforelimiting = twoatatoverthreebtat * twoatatoverthreebtat; \
        umax         =  sqrt(umaxbeforelimiting * umaxbeforelimiting / (umaxbeforelimiting * umaxbeforelimiting + 1.0)); \
        sqrtumax     =  sqrt(umax); \
        umaxpoweronepointfive = umax * sqrtumax; \
        `mypower2((1.0 + btat * umaxpoweronepointfive), (-P * one_over_one_minus_P), wgamma) \
        wtat         =  wsrh * wgamma / (wsrh + wgamma); \
        ktat         =  sqrt(0.375 * (btat / sqrtumax)); \
        ltat         =  2.0 * (twoatatoverthreebtat * sqrtumax) - umax; \
        mtat         =  atat * twoatatoverthreebtat * sqrtumax - atat * umax + 0.5 * (btat * umaxpoweronepointfive); \
        xerfc        =  (ltat - 1.0) * ktat; \
        `calcerfcexpmtat(xerfc, mtat, erfctimesexpmtat) \
        gammamax     = `SQRTPI * 0.5 * (atat * erfctimesexpmtat  / ktat); \
        itat         =  CTAT * (asrh * gammamax * wtat); \
    end \
    if (CBBT == 0.0) begin \
        ibbt         =  0.0; \
    end else begin \
        `mypower(((VBIR - vbbt) * VBIRinv), P, tmp) \
        Fmaxr        =  one_over_one_minus_P * ((VBIR - vbbt) * wdepnulrinv / tmp); \
        `expl(-fbbt / Fmaxr, tmp) \
        ibbt         =  CBBT * (VAK * Fmaxr * Fmaxr * tmp); \
    end \
    if (VBR > `vbrmax) begin \
        fbreakdown   =  1.0; \
    end else begin \
        if (vav > -alphaav * VBR) begin \
            `mypower3(vav * VBRinv, PBR, tmp) \
            fbreakdown    =  1.0 / (1.0 - tmp); \
        end else begin \
            fbreakdown    =  fstop + (vav + alphaav * VBR) * slope; \
        end \
    end \
    Ijprime      =  IFACTOR * (id + isrh + itat + ibbt) * fbreakdown;

// The following code is written as a macro because the naming of the instance parameters is
// different for JUNCAP2 stand-alone and JUNCAP2-in-PSP: AB, LS, LG for JUNCAP2 stand-alone,
// ABSOURCE, LSSOURCE, LGSOURCE for source junction in PSP and ABDRAIN, LSDRAIN, LGDRAIN for
// drain junction in PSP

`define juncapcommoninit(V, AB_i, LS_i, LG_i, VMAX, exp_VMAX_over_phitd, vbimin, vch, vfmin, vbbtlim) \
    vbbt         =  0.0; \
    two_psistar  =  0.0; \
    if ( !( ((AB_i) == 0.0) && ((LS_i) == 0.0) && ((LG_i) == 0.0) ) ) begin \
        `hypfunction5(V, vfmin, vch, vj) \
        if (V < VMAX) begin \
            `expl(-0.5 * (V * phitdinv), z) \
            zinv         =  1.0 / z; \
            idmult       =  zinv * zinv; \
        end else begin \
            idmult       =  (1.0 + (V - VMAX) * phitdinv) * exp_VMAX_over_phitd; \
            zinv         =  sqrt(idmult); \
            z            =  1.0 / zinv; \
        end \
        idmult       =  idmult - 1.0; \
        if (V > 0.0) begin \
            two_psistar    =  2.0 * (phitd * ln(2.0 + z + sqrt((z + 1.0) * (z + 3.0)))); \
        end else begin \
            two_psistar    = -V + 2.0 * (phitd * ln(2.0 * zinv + 1.0 + sqrt((1.0 + zinv) * (1.0 + 3.0 * zinv)))); \
        end \
        vjlim        =  vbimin - two_psistar; \
        `hypfunction2(V, vjlim, phitd, vjsrh) \
        `hypfunction2(V, vbbtlim, phitr, vbbt) \
        `hypfunction2(V, 0.0, `epsav, vav) \
    end

`define juncapcommon(V, AB_i, LS_i, LG_i, qprefbot, qpref2bot, vbiinvbot, one_minus_PBOT, idsatbot, CSRHBOT_i, CTATBOT_i, vbibot, wdepnulrbot, VBIRBOTinv, PBOT_i, ftdbot, btatpartbot, atatbot, one_over_one_minus_PBOT, CBBTBOT_i, VBIRBOT_i, wdepnulrinvbot, fbbtbot, VBRBOT_i, VBRinvbot, PBRBOT_i, fstopbot, slopebot, qprefsti, qpref2sti, vbiinvsti, one_minus_PSTI, idsatsti, CSRHSTI_i, CTATSTI_i, vbisti, wdepnulrsti, VBIRSTIinv, PSTI_i, ftdsti, btatpartsti, atatsti, one_over_one_minus_PSTI, CBBTSTI_i, VBIRSTI_i, wdepnulrinvsti, fbbtsti, VBRSTI_i, VBRinvsti, PBRSTI_i, fstopsti, slopesti, qprefgat, qpref2gat, vbiinvgat, one_minus_PGAT, swgat2nd, qprefgat2nd, qpref2gat2nd, vbiinvgat2nd, one_minus_pgat2nd, VTRGAT_i, ANUGAT_i, idsatgat, CSRHGAT_i, CTATGAT_i, vbigat, wdepnulrgat, VBIRGATinv, PGAT_i, ftdgat, btatpartgat, atatgat, one_over_one_minus_PGAT, CBBTGAT_i, VBIRGAT_i, wdepnulrinvgat, fbbtgat, VBRGAT_i, VBRinvgat, PBRGAT_i, fstopgat, slopegat, VMAX, exp_VMAX_over_phitd, vbimin, vch, vfmin, vbbtlim, ijunbot, qjunbot, ijunsti, qjunsti, ijungat, qjungat) \
    `juncapcommoninit(V, AB_i, LS_i, LG_i, VMAX, exp_VMAX_over_phitd, vbimin, vch, vfmin, vbbtlim) \
    if ((AB_i) == 0.0) begin \
        ijunbot      =  0.0; \
        qjunbot      =  0.0; \
    end else begin \
        `juncapIfunction(V, one_minus_PBOT, idsatbot, CSRHBOT_i, CTATBOT_i, vbibot, wdepnulrbot, VBIRBOTinv, PBOT_i, ftdbot, btatpartbot, atatbot, one_over_one_minus_PBOT, CBBTBOT_i, VBIRBOT_i, wdepnulrinvbot, fbbtbot, VBRBOT_i, VBRinvbot, PBRBOT_i, fstopbot, slopebot, ijunbot) \
        `juncapQfunction(V, vj, qprefbot, qpref2bot, vbiinvbot, one_minus_PBOT, qjunbot) \
    end \
    if ((LS_i) == 0.0) begin \
        ijunsti      =  0.0; \
        qjunsti      =  0.0; \
    end else begin \
        `juncapIfunction(V, one_minus_PSTI, idsatsti, CSRHSTI_i, CTATSTI_i, vbisti, wdepnulrsti, VBIRSTIinv, PSTI_i, ftdsti, btatpartsti, atatsti, one_over_one_minus_PSTI, CBBTSTI_i, VBIRSTI_i, wdepnulrinvsti, fbbtsti, VBRSTI_i, VBRinvsti, PBRSTI_i, fstopsti, slopesti, ijunsti) \
        `juncapQfunction(V, vj, qprefsti, qpref2sti, vbiinvsti, one_minus_PSTI, qjunsti) \
    end \
    if ((LG_i) == 0.0) begin \
        ijungat      =  0.0; \
        qjungat      =  0.0; \
    end else begin \
        `juncapIfunction(V, one_minus_PGAT, idsatgat, CSRHGAT_i, CTATGAT_i, vbigat, wdepnulrgat, VBIRGATinv, PGAT_i, ftdgat, btatpartgat, atatgat, one_over_one_minus_PGAT, CBBTGAT_i, VBIRGAT_i, wdepnulrinvgat, fbbtgat, VBRGAT_i, VBRinvgat, PBRGAT_i, fstopgat, slopegat, ijungat) \
        if ((swgat2nd) == 1.0) begin \
            nu = `MAXE(V, VTRGAT_i, ANUGAT_i); \
            `hypfunction5(nu, vfmin, vch, vjtmp) \
            `juncapQfunction(nu, vjtmp, qprefgat, qpref2gat, vbiinvgat, one_minus_PGAT, qjungat) \
            nu = V + VTRGAT_i - nu; \
            `hypfunction5(nu, vfmin, vch, vjtmp) \
            `juncapQfunction(nu, vjtmp, qprefgat2nd, qpref2gat2nd, vbiinvgat2nd, one_minus_pgat2nd, qjungat2nd) \
            qjungat = qjungat + qjungat2nd; \
        end else begin \
            `juncapQfunction(V, vj, qprefgat, qpref2gat, vbiinvgat, one_minus_PGAT, qjungat) \
        end \
    end

//============================================================================================================
//  JUNCAP-express
//
//  The macros below are used in the express-version of JUNCAP2
//============================================================================================================

`define relerr      1.0e-3
`define P1(x)       ((x) + 1.0)

`define expll(x, xlow, expxlow, xhigh, expxhigh) \
    ((x) < (xlow)) ? (expxlow) / `P1((xlow) - (x)) : (((x) > (xhigh)) ? (expxhigh) * `P1((x) - (xhigh)) : exp(x))

`define juncapexpresscommon(V, AB_i, LS_i, LG_i, one_minus_PBOT, idsatbot, CSRHBOT_i, CTATBOT_i, vbibot, wdepnulrbot, VBIRBOTinv, PBOT_i, ftdbot, btatpartbot, atatbot, one_over_one_minus_PBOT, CBBTBOT_i, VBIRBOT_i, wdepnulrinvbot, fbbtbot, VBRBOT_i, VBRinvbot, PBRBOT_i, fstopbot, slopebot, one_minus_PSTI, idsatsti, CSRHSTI_i, CTATSTI_i, vbisti, wdepnulrsti, VBIRSTIinv, PSTI_i, ftdsti, btatpartsti, atatsti, one_over_one_minus_PSTI, CBBTSTI_i, VBIRSTI_i, wdepnulrinvsti, fbbtsti, VBRSTI_i, VBRinvsti, PBRSTI_i, fstopsti, slopesti, one_minus_PGAT, idsatgat, CSRHGAT_i, CTATGAT_i, vbigat, wdepnulrgat, VBIRGATinv, PGAT_i, ftdgat, btatpartgat, atatgat, one_over_one_minus_PGAT, CBBTGAT_i, VBIRGAT_i, wdepnulrinvgat, fbbtgat, VBRGAT_i, VBRinvgat, PBRGAT_i, fstopgat, slopegat, VMAX, exp_VMAX_over_phitd, vbimin, vch, vfmin, vbbtlim, ijunbot, ijunsti, ijungat) \
    `juncapcommoninit(V, AB_i, LS_i, LG_i, VMAX, exp_VMAX_over_phitd, vbimin, vch, vfmin, vbbtlim) \
    if ((AB_i) == 0.0) begin \
        ijunbot      =  0.0; \
    end else begin \
        `juncapIfunction(V, one_minus_PBOT, idsatbot, CSRHBOT_i, CTATBOT_i, vbibot, wdepnulrbot, VBIRBOTinv, PBOT_i, ftdbot, btatpartbot, atatbot, one_over_one_minus_PBOT, CBBTBOT_i, VBIRBOT_i, wdepnulrinvbot, fbbtbot, VBRBOT_i, VBRinvbot, PBRBOT_i, fstopbot, slopebot, ijunbot) \
    end \
    if ((LS_i) == 0.0) begin \
        ijunsti      =  0.0; \
    end else begin \
        `juncapIfunction(V, one_minus_PSTI, idsatsti, CSRHSTI_i, CTATSTI_i, vbisti, wdepnulrsti, VBIRSTIinv, PSTI_i, ftdsti, btatpartsti, atatsti, one_over_one_minus_PSTI, CBBTSTI_i, VBIRSTI_i, wdepnulrinvsti, fbbtsti, VBRSTI_i, VBRinvsti, PBRSTI_i, fstopsti, slopesti, ijunsti) \
    end \
    if ((LG_i) == 0.0) begin \
        ijungat      =  0.0; \
    end else begin \
        `juncapIfunction(V, one_minus_PGAT, idsatgat, CSRHGAT_i, CTATGAT_i, vbigat, wdepnulrgat, VBIRGATinv, PGAT_i, ftdgat, btatpartgat, atatgat, one_over_one_minus_PGAT, CBBTGAT_i, VBIRGAT_i, wdepnulrinvgat, fbbtgat, VBRGAT_i, VBRinvgat, PBRGAT_i, fstopgat, slopegat, ijungat) \
    end

// The "JuncapExpressInit"-macro below is split into three parts, as some verilog-A compilers cannot handle
// macros beyond a certain size. Moreover, it is useful to limit the list of input and output variables.

// Part 1
`define JuncapExpressInit1(AB_i, LS_i, LG_i, VJUNREF_i, one_minus_PBOT, idsatbot, CSRHBOT_i, CTATBOT_i, vbibot, wdepnulrbot, VBIRBOTinv, PBOT_i, ftdbot, btatpartbot, atatbot, one_over_one_minus_PBOT, CBBTBOT_i, VBIRBOT_i, wdepnulrinvbot, fbbtbot, VBRBOT_i, VBRinvbot, PBRBOT_i, fstopbot, slopebot, one_minus_PSTI, idsatsti, CSRHSTI_i, CTATSTI_i, vbisti, wdepnulrsti, VBIRSTIinv, PSTI_i, ftdsti, btatpartsti, atatsti, one_over_one_minus_PSTI, CBBTSTI_i, VBIRSTI_i, wdepnulrinvsti, fbbtsti, VBRSTI_i, VBRinvsti, PBRSTI_i, fstopsti, slopesti, one_minus_PGAT, idsatgat, CSRHGAT_i, CTATGAT_i, vbigat, wdepnulrgat, VBIRGATinv, PGAT_i, ftdgat, btatpartgat, atatgat, one_over_one_minus_PGAT, CBBTGAT_i, VBIRGAT_i, wdepnulrinvgat, fbbtgat, VBRGAT_i, VBRinvgat, PBRGAT_i, fstopgat, slopegat, VMAX, exp_VMAX_over_phitd, vbimin, vch, vfmin, vbbtlim) \
    FRACNA       =  0.4; \
    FRACNB       =  0.65; \
    FRACI        =  0.8; \
    /* Sample voltages */ \
    V1           = -FRACNA * VJUNREF_i; \
    V2           = -FRACNB * VJUNREF_i; \
    V3           = -FRACI * VJUNREF_i; \
    V4           =  0.1; \
    V5           =  0.2; \
    /*  Evaluate full JUNCAP-model at five voltages */ \
    `juncapexpresscommon(V1, AB_i, LS_i, LG_i, one_minus_PBOT, idsatbot, CSRHBOT_i, CTATBOT_i, vbibot, wdepnulrbot, VBIRBOTinv, PBOT_i, ftdbot, btatpartbot, atatbot, one_over_one_minus_PBOT, CBBTBOT_i, VBIRBOT_i, wdepnulrinvbot, fbbtbot, VBRBOT_i, VBRinvbot, PBRBOT_i, fstopbot, slopebot, one_minus_PSTI, idsatsti, CSRHSTI_i, CTATSTI_i, vbisti, wdepnulrsti, VBIRSTIinv, PSTI_i, ftdsti, btatpartsti, atatsti, one_over_one_minus_PSTI, CBBTSTI_i, VBIRSTI_i, wdepnulrinvsti, fbbtsti, VBRSTI_i, VBRinvsti, PBRSTI_i, fstopsti, slopesti, one_minus_PGAT, idsatgat, CSRHGAT_i, CTATGAT_i, vbigat, wdepnulrgat, VBIRGATinv, PGAT_i, ftdgat, btatpartgat, atatgat, one_over_one_minus_PGAT, CBBTGAT_i, VBIRGAT_i, wdepnulrinvgat, fbbtgat, VBRGAT_i, VBRinvgat, PBRGAT_i, fstopgat, slopegat, VMAX, exp_VMAX_over_phitd, vbimin, vch, vfmin, vbbtlim, ijunbot, ijunsti, ijungat) \
    I1           =  AB_i * ijunbot + LS_i * ijunsti + LG_i * ijungat; \
    `juncapexpresscommon(V2, AB_i, LS_i, LG_i, one_minus_PBOT, idsatbot, CSRHBOT_i, CTATBOT_i, vbibot, wdepnulrbot, VBIRBOTinv, PBOT_i, ftdbot, btatpartbot, atatbot, one_over_one_minus_PBOT, CBBTBOT_i, VBIRBOT_i, wdepnulrinvbot, fbbtbot, VBRBOT_i, VBRinvbot, PBRBOT_i, fstopbot, slopebot, one_minus_PSTI, idsatsti, CSRHSTI_i, CTATSTI_i, vbisti, wdepnulrsti, VBIRSTIinv, PSTI_i, ftdsti, btatpartsti, atatsti, one_over_one_minus_PSTI, CBBTSTI_i, VBIRSTI_i, wdepnulrinvsti, fbbtsti, VBRSTI_i, VBRinvsti, PBRSTI_i, fstopsti, slopesti, one_minus_PGAT, idsatgat, CSRHGAT_i, CTATGAT_i, vbigat, wdepnulrgat, VBIRGATinv, PGAT_i, ftdgat, btatpartgat, atatgat, one_over_one_minus_PGAT, CBBTGAT_i, VBIRGAT_i, wdepnulrinvgat, fbbtgat, VBRGAT_i, VBRinvgat, PBRGAT_i, fstopgat, slopegat, VMAX, exp_VMAX_over_phitd, vbimin, vch, vfmin, vbbtlim, ijunbot, ijunsti, ijungat) \
    I2           =  AB_i * ijunbot + LS_i * ijunsti + LG_i * ijungat; \
    `juncapexpresscommon(V3, AB_i, LS_i, LG_i, one_minus_PBOT, idsatbot, CSRHBOT_i, CTATBOT_i, vbibot, wdepnulrbot, VBIRBOTinv, PBOT_i, ftdbot, btatpartbot, atatbot, one_over_one_minus_PBOT, CBBTBOT_i, VBIRBOT_i, wdepnulrinvbot, fbbtbot, VBRBOT_i, VBRinvbot, PBRBOT_i, fstopbot, slopebot, one_minus_PSTI, idsatsti, CSRHSTI_i, CTATSTI_i, vbisti, wdepnulrsti, VBIRSTIinv, PSTI_i, ftdsti, btatpartsti, atatsti, one_over_one_minus_PSTI, CBBTSTI_i, VBIRSTI_i, wdepnulrinvsti, fbbtsti, VBRSTI_i, VBRinvsti, PBRSTI_i, fstopsti, slopesti, one_minus_PGAT, idsatgat, CSRHGAT_i, CTATGAT_i, vbigat, wdepnulrgat, VBIRGATinv, PGAT_i, ftdgat, btatpartgat, atatgat, one_over_one_minus_PGAT, CBBTGAT_i, VBIRGAT_i, wdepnulrinvgat, fbbtgat, VBRGAT_i, VBRinvgat, PBRGAT_i, fstopgat, slopegat, VMAX, exp_VMAX_over_phitd, vbimin, vch, vfmin, vbbtlim, ijunbot, ijunsti, ijungat) \
    I3           =  AB_i * ijunbot + LS_i * ijunsti + LG_i * ijungat;

// Part 2
`define JuncapExpressInit2(AB_i, LS_i, LG_i, one_minus_PBOT, idsatbot, CSRHBOT_i, CTATBOT_i, vbibot, wdepnulrbot, VBIRBOTinv, PBOT_i, ftdbot, btatpartbot, atatbot, one_over_one_minus_PBOT, CBBTBOT_i, VBIRBOT_i, wdepnulrinvbot, fbbtbot, VBRBOT_i, VBRinvbot, PBRBOT_i, fstopbot, slopebot, one_minus_PSTI, idsatsti, CSRHSTI_i, CTATSTI_i, vbisti, wdepnulrsti, VBIRSTIinv, PSTI_i, ftdsti, btatpartsti, atatsti, one_over_one_minus_PSTI, CBBTSTI_i, VBIRSTI_i, wdepnulrinvsti, fbbtsti, VBRSTI_i, VBRinvsti, PBRSTI_i, fstopsti, slopesti, one_minus_PGAT, idsatgat, CSRHGAT_i, CTATGAT_i, vbigat, wdepnulrgat, VBIRGATinv, PGAT_i, ftdgat, btatpartgat, atatgat, one_over_one_minus_PGAT, CBBTGAT_i, VBIRGAT_i, wdepnulrinvgat, fbbtgat, VBRGAT_i, VBRinvgat, PBRGAT_i, fstopgat, slopegat, VMAX, exp_VMAX_over_phitd, vbimin, vch, vfmin, vbbtlim) \
    /*  Forward currents */ \
    `juncapexpresscommon(V4, AB_i, LS_i, LG_i, one_minus_PBOT, idsatbot, CSRHBOT_i, CTATBOT_i, vbibot, wdepnulrbot, VBIRBOTinv, PBOT_i, ftdbot, btatpartbot, atatbot, one_over_one_minus_PBOT, CBBTBOT_i, VBIRBOT_i, wdepnulrinvbot, fbbtbot, VBRBOT_i, VBRinvbot, PBRBOT_i, fstopbot, slopebot, one_minus_PSTI, idsatsti, CSRHSTI_i, CTATSTI_i, vbisti, wdepnulrsti, VBIRSTIinv, PSTI_i, ftdsti, btatpartsti, atatsti, one_over_one_minus_PSTI, CBBTSTI_i, VBIRSTI_i, wdepnulrinvsti, fbbtsti, VBRSTI_i, VBRinvsti, PBRSTI_i, fstopsti, slopesti, one_minus_PGAT, idsatgat, CSRHGAT_i, CTATGAT_i, vbigat, wdepnulrgat, VBIRGATinv, PGAT_i, ftdgat, btatpartgat, atatgat, one_over_one_minus_PGAT, CBBTGAT_i, VBIRGAT_i, wdepnulrinvgat, fbbtgat, VBRGAT_i, VBRinvgat, PBRGAT_i, fstopgat, slopegat, VMAX, exp_VMAX_over_phitd, vbimin, vch, vfmin, vbbtlim, ijunbot, ijunsti, ijungat) \
    I4           =  AB_i * ijunbot + LS_i * ijunsti + LG_i * ijungat; \
    `juncapexpresscommon(V5, AB_i, LS_i, LG_i, one_minus_PBOT, idsatbot, CSRHBOT_i, CTATBOT_i, vbibot, wdepnulrbot, VBIRBOTinv, PBOT_i, ftdbot, btatpartbot, atatbot, one_over_one_minus_PBOT, CBBTBOT_i, VBIRBOT_i, wdepnulrinvbot, fbbtbot, VBRBOT_i, VBRinvbot, PBRBOT_i, fstopbot, slopebot, one_minus_PSTI, idsatsti, CSRHSTI_i, CTATSTI_i, vbisti, wdepnulrsti, VBIRSTIinv, PSTI_i, ftdsti, btatpartsti, atatsti, one_over_one_minus_PSTI, CBBTSTI_i, VBIRSTI_i, wdepnulrinvsti, fbbtsti, VBRSTI_i, VBRinvsti, PBRSTI_i, fstopsti, slopesti, one_minus_PGAT, idsatgat, CSRHGAT_i, CTATGAT_i, vbigat, wdepnulrgat, VBIRGATinv, PGAT_i, ftdgat, btatpartgat, atatgat, one_over_one_minus_PGAT, CBBTGAT_i, VBIRGAT_i, wdepnulrinvgat, fbbtgat, VBRGAT_i, VBRinvgat, PBRGAT_i, fstopgat, slopegat, VMAX, exp_VMAX_over_phitd, vbimin, vch, vfmin, vbbtlim, ijunbot, ijunsti, ijungat) \
    I5           =  AB_i * ijunbot + LS_i * ijunsti + LG_i * ijungat;

// Part 3
`define JuncapExpressInit3(AB_i, LS_i, LG_i, idsatbot, idsatsti, idsatgat, ISATFOR1, MFOR1, ISATFOR2, MFOR2, ISATREV, MREV, m0flag) \
    /*  Compute internal parameters from these five (I,V)-values */ \
    ISATFOR1     =  AB_i * idsatbot + LS_i * idsatsti + LG_i * idsatgat; \
    I4_cor       =  I4 - ISATFOR1 * (exp(V4 * phitdinv * MFOR1) - 1.0); \
    I5_cor       =  I5 - ISATFOR1 * (exp(V5 * phitdinv * MFOR1) - 1.0); \
    if ( !( ((AB_i) == 0.0) && ((LS_i) == 0.0) && ((LG_i) == 0.0) ) ) begin \
        if ((I4 > 0.0) && (I5 > 0.0)) begin \
            if ((((I4_cor / I4) > `relerr) || ((I5_cor / I5) > `relerr)) && (I4_cor > 0.0) && (I5_cor > 0.0) && (I5_cor > I4_cor)) begin \
                alphaje      =  I4_cor / I5_cor; \
                MFOR2        =  phitd * ln(alphaje) / (V4 - V5); \
                ISATFOR2     =  I4_cor / (exp(V4 * phitdinv * MFOR2) - 1.0); \
            end \
        end \
        I1_cor       =  I1 - ISATFOR1 * (exp(V1 * phitdinv * MFOR1) - 1.0) - ISATFOR2 * (exp(V1 * phitdinv * MFOR2) - 1.0); \
        I2_cor       =  I2 - ISATFOR1 * (exp(V2 * phitdinv * MFOR1) - 1.0) - ISATFOR2 * (exp(V2 * phitdinv * MFOR2) - 1.0); \
        I3_cor       =  I3 - ISATFOR1 * (exp(V3 * phitdinv * MFOR1) - 1.0) - ISATFOR2 * (exp(V3 * phitdinv * MFOR2) - 1.0); \
        if ((I1 < 0.0) && (I2 < 0.0) && (I3 < 0.0)) begin \
            if ((((I1_cor / I1) > `relerr) || ((I2_cor / I2) > `relerr) || ((I3_cor / I3) > `relerr)) \
                && (I1_cor < 0.0) && (I2_cor < 0.0) && (I3_cor < 0.0)) begin \
                alphaje      =  I1_cor / I2_cor; \
                m0_rev       = -phitd * ln(alphaje) / (V1 - V2); /* zeroth order approximation */ \
                tt0          =  V2 / (V2 - V1); \
                tt1          =  phitd * (alphaje - 1.0) * (pow(alphaje, tt0) - 1.0); \
                tt0          =  V1 / (V1 - V2); \
                tt2          =  pow(alphaje, tt0) * (V2 - V1) + alphaje * V1 - V2; \
                mcor_rev     =  tt1 / tt2; /* first order Newton correction */ \
                MREV         =  m0_rev + mcor_rev; \
                if (abs(V3 * phitdinv * MREV) < 1.0e-6) begin \
                    /* Taylor approximation needed */ \
                    /* Note: ISATREV and MREV have different meaning in this situation!! */ \
                    m0flag       =  1.0; \
                    ISATREV      =  I3_cor * (1.0 / V3 + 0.5 * phitdinv * MREV); \
                    MREV         = -0.5 * I3_cor * MREV * phitdinv / V3; \
                end else begin \
                    m0flag       =  0.0; \
                    ISATREV      = -I3_cor / (exp(-V3 * phitdinv * MREV) - 1.0); \
                end \
            end \
        end \
    end

// Part 4
`define JuncapExpressInit4(AB_i, LS_i, LG_i, FJUNQ_i, cjobot, cjosti, cjogat, zflagbot, zflagsti, zflaggat) \
    /*  Charge model initialization */ \
    zfrac        =  FJUNQ_i * (AB_i * cjobot + LS_i * cjosti + LG_i * cjogat); \
    if ((AB_i * cjobot) <= zfrac) begin \
        zflagbot     =  0.0; \
    end \
    if ((LS_i * cjosti) <= zfrac) begin \
        zflagsti     =  0.0; \
    end \
    if ((LG_i * cjogat) <= zfrac) begin \
        zflaggat     =  0.0; \
    end

// Part 5
`define JuncapExpressInit5(AB_i, LS_i, LG_i, ISATFOR1, ISATFOR2, ISATREV, xhighf1, expxhf1, xhighf2, expxhf2, xhighr, expxhr) \
    /*  Calculate limits beyond which exponentials are linearly extrapolated */ \
    if ( !( ((AB_i) == 0.0) && ((LS_i) == 0.0) && ((LG_i) == 0.0) ) ) begin \
        xhighf1      =  ln(0.5 * IMAX / (ISATFOR1 + 1.0e-21)); \
        xhighf2      =  ln(0.5 * IMAX / (ISATFOR2 + 1.0e-21)); \
        xhighr       =  ln(0.5 * IMAX / (abs(ISATREV) + 1.0e-21)); \
    end \
    xhighf1      =  min(xhighf1, `se05); \
    expxhf1      =  exp(xhighf1); \
    xhighf2      =  min(xhighf2, `se05); \
    expxhf2      =  exp(xhighf2); \
    xhighr       =  min(xhighr, `se05); \
    expxhr       =  exp(xhighr);

`define JuncapExpressCurrent(V, MFOR1, ISATFOR1, MFOR2, ISATFOR2, MREV, ISATREV, m0flag, xhighf1, expxhf1, xhighf2, expxhf2, xhighr, expxhr, ijun) \
    tm0          =  V * phitdinv * MFOR1; \
    tm1          = `expll(tm0, -`se05, `ke05, xhighf1, expxhf1); \
    ijunfor1     =  ISATFOR1 * (tm1 - 1.0); \
    tm0          =  V * phitdinv * MFOR2; \
    tm1          = `expll(tm0, -`se05, `ke05, xhighf2, expxhf2); \
    ijunfor2     =  ISATFOR2 * (tm1 - 1.0); \
    ijunrev      =  0.0; \
    if (m0flag > 0.0) begin \
        ijunrev      =  V * (ISATREV + V * MREV); \
    end else begin \
        tm0          = -V * phitdinv * MREV; \
        tm1          = `expll(tm0, -`se05, `ke05, xhighr, expxhr); \
        ijunrev      = -ISATREV * (tm1 - 1.0); \
    end \
    ijun         =  ijunfor1 + ijunfor2 + ijunrev;

`define JuncapExpressCharge(V, AB_i, LS_i, LG_i, qprefbot, qprefsti, qprefgat, qpref2bot, qpref2sti, qpref2gat, vbiinvbot, vbiinvsti, vbiinvgat, one_minus_PBOT, one_minus_PSTI, one_minus_PGAT, vfmin, vch, zflagbot, zflagsti, zflaggat, qjunbot, qjunsti, qjungat) \
    tmpv         =  0.0; \
    vjv          =  0.0; \
    `hypfunction5(V, vfmin, vch, vjv) \
    if (zflagbot > 0.5) begin \
        `mypower((1.0 - vjv * vbiinvbot), one_minus_PBOT, tmpv) \
        qjunbot      =  qprefbot * (1.0 - tmpv) + qpref2bot * (V - vjv); \
    end \
    if (zflagsti > 0.5) begin \
        `mypower((1.0 - vjv * vbiinvsti), one_minus_PSTI, tmpv) \
        qjunsti      =  qprefsti * (1.0 - tmpv) + qpref2sti * (V - vjv); \
    end \
    if (zflaggat > 0.5) begin \
        `mypower((1.0 - vjv * vbiinvgat), one_minus_PGAT, tmpv) \
        qjungat      = qprefgat * (1.0 - tmpv) + qpref2gat * (V - vjv); \
    end

// ---- end `include "JUNCAP200_macrodefs.include" ----

// ---- begin `include "JUNCAP200_InitModel.include" ----
//======================================================================================
//======================================================================================
// Filename: JUNCAP200_InitModel.include
//======================================================================================
//======================================================================================
//
//  (c) Copyright notice
//
//  Since 2015 until today, PSP has been co-developed by NXP Semiconductors and
//  CEA-Leti. For this part of the model, each claim undivided ownership and copyrights
//  Since 2012 until 2015, PSP has been co-developed by NXP Semiconductors and
//  Delft University of Technology. For this part of the model, each claim undivided
//  ownership and copyrights
//  Until and including 2011, PSP has been co-developed by NXP Semiconductors and
//  Arizona State University. For this part of the model, NXP Semiconductors claims
//  undivided ownership and copyrights.
//
//
//  Version: 200.7.0, March 2026
//
//======================================================================================
//======================================================================================
//
// Further information can be found in the file releasenotesPSP104.txt
//

    //  --------------------------------------------------------------------------------------------------------------
    //  Calculation of internal parameters which are independent on instance parameters
    //  --------------------------------------------------------------------------------------------------------------

`define JUNCAP200_InitModel_Model \
    \
    SWJUNEXP_i   =  0.0; \
    if (SWJUNEXP > 0.5) begin \
        SWJUNEXP_i   =  1.0; \
    end else begin \
        SWJUNEXP_i   =  0.0; \
    end \
    \
    /*  Variables related to reference temperature */ \
    tkr          = `KELVINCONVERSION + TRJ; \
    KBOL_over_QELE = `KBOL / `QELE; \
    phitr        =  KBOL_over_QELE * tkr; \
    phitrinv     =  1.0 / phitr; \
    \
    /*  Bandgap voltages at reference temperature */ \
    deltaphigr   = -(7.02e-4 * tkr * tkr) / (1108.0 + tkr); \
    phigrbot     =  PHIGBOT + deltaphigr; \
    phigrsti     =  PHIGSTI + deltaphigr; \
    phigrgat     =  PHIGGAT + deltaphigr; \
    \
    /*  One minus the grading coefficient */ \
    one_minus_PBOT =  1.0 - PBOT; \
    one_minus_PSTI =  1.0 - PSTI; \
    one_minus_PGAT =  1.0 - PGAT; \
    \
    /*  One over "one minus the grading coefficient" */ \
    one_over_one_minus_PBOT = 1.0 / one_minus_PBOT; \
    one_over_one_minus_PSTI = 1.0 / one_minus_PSTI; \
    one_over_one_minus_PGAT = 1.0 / one_minus_PGAT; \
    \
    /*  Zero-bias depletion widths at reference temperature, needed in SRH and TAT model */ \
    wdepnulrbot  =  EPSSI / CJORBOT; \
    wdepnulrsti  =  XJUNSTI * EPSSI / CJORSTI; \
    wdepnulrgat  =  XJUNGAT * EPSSI / CJORGAT; \
    \
    /*  Inverse values of "wdepnulr", used in BBT model */ \
    wdepnulrinvbot = 1.0 / wdepnulrbot; \
    wdepnulrinvsti = 1.0 / wdepnulrsti; \
    wdepnulrinvgat = 1.0 / wdepnulrgat; \
    \
    /*  Inverse values of built-in voltages at reference temperature, needed in SRH and BBT model */ \
    VBIRBOTinv   =  1.0 / VBIRBOT; \
    VBIRSTIinv   =  1.0 / VBIRSTI; \
    VBIRGATinv   =  1.0 / VBIRGAT; \
    \
    /*  Some constants needed in erfc-approximation, needed in TAT model */ \
    perfc        =  (`SQRTPI * `aerfc); \
    berfc        =  ((-5.0 * (`aerfc) + 6.0 - pow((perfc), -2.0)) / 3.0); \
    cerfc        =  (1.0 - (`aerfc) - (berfc)); \
    \
    /*  Values of fstop, needed in avalanche/breakdown model */ \
    alphaav      =  1.0 - 1.0 / FREV; \
    fstopbot     =  1.0 / (1.0 - pow(alphaav, PBRBOT)); \
    fstopsti     =  1.0 / (1.0 - pow(alphaav, PBRSTI)); \
    fstopgat     =  1.0 / (1.0 - pow(alphaav, PBRGAT)); \
    \
    /*  Inverse values of breakdown voltages, needed in avalanche/breakdown model */ \
    VBRinvbot    =  1.0 / VBRBOT; \
    VBRinvsti    =  1.0 / VBRSTI; \
    VBRinvgat    =  1.0 / VBRGAT; \
    \
    /*  Slopes for linear extrapolation close to and beyond breakdown, needed in avalanche/breakdown model */ \
    slopebot     = -(fstopbot * fstopbot * pow(alphaav, (PBRBOT - 1.0))) * PBRBOT * VBRinvbot; \
    slopesti     = -(fstopsti * fstopsti * pow(alphaav, (PBRSTI - 1.0))) * PBRSTI * VBRinvsti; \
    slopegat     = -(fstopgat * fstopgat * pow(alphaav, (PBRGAT - 1.0))) * PBRGAT * VBRinvgat; \
    \
    /* Switch computation for 2nd junction of gate-edge component for source-bulk junction */ \
    if (((FCJORGAT2)!=1.0) || ((FVBIRGAT2)!=1.0) || ((FPGAT2)!=1.0) || ((FPHIGGAT2)!=1.0)) begin \
        swgat2nd = 1.0; \
    end else begin \
        swgat2nd = 0.0; \
    end \
    \
    if ((swgat2nd) == 1.0) begin \
        \
        cjorgat2nd = `CLIP_LOW(CJORGAT * FCJORGAT2,`CJORGAT_cliplow); \
        vbirgat2nd = `CLIP_LOW(VBIRGAT * FVBIRGAT2,`VBIR_cliplow); \
        pgat2nd    = `CLIP_HIGH(`CLIP_LOW(PGAT * FPGAT2,`P_cliplow),`P_cliphigh); \
        phiggat2nd = PHIGGAT * FPHIGGAT2; \
        \
        /*  Bandgap voltages at reference temperature */ \
        phigrgat2nd  =  phiggat2nd + deltaphigr; \
        \
        /*  One minus the grading coefficient */ \
        one_minus_pgat2nd =  1.0 - pgat2nd; \
        \
        /*  One over "one minus the grading coefficient" */ \
        one_over_one_minus_pgat2nd = 1.0 / one_minus_pgat2nd; \
        \
    end

`define JUNCAP200_InitModel_Model_Drain_Junction \
    \
    /*  JUNCAP parameters definition for drain side */ \
    if (SWJUNASYM == 0.0) begin \
        CJORBOTD_i   =  CJORBOT; \
        CJORSTID_i   =  CJORSTI; \
        CJORGATD_i   =  CJORGAT; \
        VBIRBOTD_i   =  VBIRBOT; \
        VBIRSTID_i   =  VBIRSTI; \
        VBIRGATD_i   =  VBIRGAT; \
        PBOTD_i      =  PBOT; \
        PSTID_i      =  PSTI; \
        PGATD_i      =  PGAT; \
        PHIGBOTD_i   =  PHIGBOT; \
        PHIGSTID_i   =  PHIGSTI; \
        PHIGGATD_i   =  PHIGGAT; \
        IDSATRBOTD_i =  IDSATRBOT; \
        IDSATRSTID_i =  IDSATRSTI; \
        IDSATRGATD_i =  IDSATRGAT; \
        CSRHBOTD_i   =  CSRHBOT; \
        CSRHSTID_i   =  CSRHSTI; \
        CSRHGATD_i   =  CSRHGAT; \
        XJUNSTID_i   =  XJUNSTI; \
        XJUNGATD_i   =  XJUNGAT; \
        CTATBOTD_i   =  CTATBOT; \
        CTATSTID_i   =  CTATSTI; \
        CTATGATD_i   =  CTATGAT; \
        MEFFTATBOTD_i =  MEFFTATBOT; \
        MEFFTATSTID_i =  MEFFTATSTI; \
        MEFFTATGATD_i =  MEFFTATGAT; \
        CBBTBOTD_i   =  CBBTBOT; \
        CBBTSTID_i   =  CBBTSTI; \
        CBBTGATD_i   =  CBBTGAT; \
        FBBTRBOTD_i  =  FBBTRBOT; \
        FBBTRSTID_i  =  FBBTRSTI; \
        FBBTRGATD_i  =  FBBTRGAT; \
        STFBBTBOTD_i =  STFBBTBOT; \
        STFBBTSTID_i =  STFBBTSTI; \
        STFBBTGATD_i =  STFBBTGAT; \
        VBRBOTD_i    =  VBRBOT; \
        VBRSTID_i    =  VBRSTI; \
        VBRGATD_i    =  VBRGAT; \
        PBRBOTD_i    =  PBRBOT; \
        PBRSTID_i    =  PBRSTI; \
        PBRGATD_i    =  PBRGAT; \
        VJUNREFD_i   =  VJUNREF; \
        FJUNQD_i     =  FJUNQ; \
        ADVBRGATD_i  =  ADVBRGAT; \
        BDVBRGATD_i  =  BDVBRGAT; \
        ADBBTGATD_i  =  ADBBTGAT; \
        BDBBTGATD_i  =  BDBBTGAT; \
        FCJORGAT2D_i =  FCJORGAT2; \
        FVBIRGAT2D_i =  FVBIRGAT2; \
        FPGAT2D_i    =  FPGAT2; \
        FPHIGGAT2D_i =  FPHIGGAT2; \
        VTRGATD_i    =  VTRGAT; \
        ANUGATD_i    =  ANUGAT; \
    end else begin \
        CJORBOTD_i   =  CJORBOTD; \
        CJORSTID_i   =  CJORSTID; \
        CJORGATD_i   =  CJORGATD; \
        VBIRBOTD_i   =  VBIRBOTD; \
        VBIRSTID_i   =  VBIRSTID; \
        VBIRGATD_i   =  VBIRGATD; \
        PBOTD_i      =  PBOTD; \
        PSTID_i      =  PSTID; \
        PGATD_i      =  PGATD; \
        PHIGBOTD_i   =  PHIGBOTD; \
        PHIGSTID_i   =  PHIGSTID; \
        PHIGGATD_i   =  PHIGGATD; \
        IDSATRBOTD_i =  IDSATRBOTD; \
        IDSATRSTID_i =  IDSATRSTID; \
        IDSATRGATD_i =  IDSATRGATD; \
        CSRHBOTD_i   =  CSRHBOTD; \
        CSRHSTID_i   =  CSRHSTID; \
        CSRHGATD_i   =  CSRHGATD; \
        XJUNSTID_i   =  XJUNSTID; \
        XJUNGATD_i   =  XJUNGATD; \
        CTATBOTD_i   =  CTATBOTD; \
        CTATSTID_i   =  CTATSTID; \
        CTATGATD_i   =  CTATGATD; \
        MEFFTATBOTD_i =  MEFFTATBOTD; \
        MEFFTATSTID_i =  MEFFTATSTID; \
        MEFFTATGATD_i =  MEFFTATGATD; \
        CBBTBOTD_i   =  CBBTBOTD; \
        CBBTSTID_i   =  CBBTSTID; \
        CBBTGATD_i   =  CBBTGATD; \
        FBBTRBOTD_i  =  FBBTRBOTD; \
        FBBTRSTID_i  =  FBBTRSTID; \
        FBBTRGATD_i  =  FBBTRGATD; \
        STFBBTBOTD_i =  STFBBTBOTD; \
        STFBBTSTID_i =  STFBBTSTID; \
        STFBBTGATD_i =  STFBBTGATD; \
        VBRBOTD_i    =  VBRBOTD; \
        VBRSTID_i    =  VBRSTID; \
        VBRGATD_i    =  VBRGATD; \
        PBRBOTD_i    =  PBRBOTD; \
        PBRSTID_i    =  PBRSTID; \
        PBRGATD_i    =  PBRGATD; \
        VJUNREFD_i   =  VJUNREFD; \
        FJUNQD_i     =  FJUNQD; \
        ADVBRGATD_i  =  ADVBRGATD; \
        BDVBRGATD_i  =  BDVBRGATD; \
        ADBBTGATD_i  =  ADBBTGATD; \
        BDBBTGATD_i  =  BDBBTGATD; \
        FCJORGAT2D_i =  FCJORGAT2D; \
        FVBIRGAT2D_i =  FVBIRGAT2D; \
        FPGAT2D_i    =  FPGAT2D; \
        FPHIGGAT2D_i =  FPHIGGAT2D; \
        VTRGATD_i    =  VTRGATD; \
        ANUGATD_i    =  ANUGATD; \
    end \
    \
    /*  Bandgap voltages at reference temperature for drain-bulk junction */ \
    phigrbot_d   =  PHIGBOTD_i + deltaphigr; \
    phigrsti_d   =  PHIGSTID_i + deltaphigr; \
    phigrgat_d   =  PHIGGATD_i + deltaphigr; \
    \
    /*  One minus the grading coefficient for drain-bulk junction */ \
    one_minus_PBOT_d = 1.0 - PBOTD_i; \
    one_minus_PSTI_d = 1.0 - PSTID_i; \
    one_minus_PGAT_d = 1.0 - PGATD_i; \
    \
    /*  One over "one minus the grading coefficient" for drain-bulk junction */ \
    one_over_one_minus_PBOT_d = 1.0 / one_minus_PBOT_d; \
    one_over_one_minus_PSTI_d = 1.0 / one_minus_PSTI_d; \
    one_over_one_minus_PGAT_d = 1.0 / one_minus_PGAT_d; \
    \
    /*  Zero-bias depletion widths at reference temperature, needed in SRH and TAT model for drain-bulk junction */ \
    wdepnulrbot_d =  EPSSI / CJORBOTD_i; \
    wdepnulrsti_d =  XJUNSTID_i * EPSSI / CJORSTID_i; \
    wdepnulrgat_d =  XJUNGATD_i * EPSSI / CJORGATD_i; \
    \
    /*  Inverse values of "wdepnulr", used in BBT model for drain-bulk junction */ \
    wdepnulrinvbot_d = 1.0 / wdepnulrbot_d; \
    wdepnulrinvsti_d = 1.0 / wdepnulrsti_d; \
    wdepnulrinvgat_d = 1.0 / wdepnulrgat_d; \
    \
    /*  Inverse values of built-in voltages at reference temperature, needed in SRH and BBT model for drain-bulk junction */ \
    VBIRBOTinv_d =  1.0 / VBIRBOTD_i; \
    VBIRSTIinv_d =  1.0 / VBIRSTID_i; \
    VBIRGATinv_d =  1.0 / VBIRGATD_i; \
    \
    /*  Values of fstop, needed in avalanche/breakdown model for drain-bulk junction */ \
    fstopbot_d   =  1.0 / (1.0 - pow(alphaav, PBRBOTD_i)); \
    fstopsti_d   =  1.0 / (1.0 - pow(alphaav, PBRSTID_i)); \
    fstopgat_d   =  1.0 / (1.0 - pow(alphaav, PBRGATD_i)); \
    \
    /*  Inverse values of breakdown voltages, needed in avalanche/breakdown model for drain-bulk junction */ \
    VBRinvbot_d  =  1.0 / VBRBOTD_i; \
    VBRinvsti_d  =  1.0 / VBRSTID_i; \
    VBRinvgat_d  =  1.0 / VBRGATD_i; \
    \
    /*  Slopes for linear extrapolation close to and beyond breakdown, needed in avalanche/breakdown model for drain-bulk junction */ \
    slopebot_d   = -(fstopbot_d * fstopbot_d * pow(alphaav, (PBRBOTD_i - 1.0))) * PBRBOTD_i * VBRinvbot_d; \
    slopesti_d   = -(fstopsti_d * fstopsti_d * pow(alphaav, (PBRSTID_i - 1.0))) * PBRSTID_i * VBRinvsti_d; \
    slopegat_d   = -(fstopgat_d * fstopgat_d * pow(alphaav, (PBRGATD_i - 1.0))) * PBRGATD_i * VBRinvgat_d; \
    \
    /* Switch computation for 2nd junction of gate-edge component for source-bulk junction */ \
    if (((FCJORGAT2D_i)!=1.0) || ((FVBIRGAT2D_i)!=1.0) || ((FPGAT2D_i)!=1.0) || ((FPHIGGAT2D_i)!=1.0)) begin \
        swgat2nd_d = 1.0; \
    end else begin \
        swgat2nd_d = 0.0; \
    end \
    \
    if ((swgat2nd_d) == 1.0) begin \
        \
        cjorgat2nd_d = `CLIP_LOW(CJORGATD_i * FCJORGAT2D_i,`CJORGAT_cliplow); \
        vbirgat2nd_d = `CLIP_LOW(VBIRGATD_i * FVBIRGAT2D_i,`VBIR_cliplow); \
        pgat2nd_d    = `CLIP_HIGH(`CLIP_LOW(PGATD_i * FPGAT2D_i,`P_cliplow),`P_cliphigh); \
        phiggat2nd_d = PHIGGATD_i * FPHIGGAT2D_i; \
        \
        /*  Bandgap voltages at reference temperature */ \
        phigrgat2nd_d  =  phiggat2nd_d + deltaphigr; \
        \
        /*  One minus the grading coefficient */ \
        one_minus_pgat2nd_d =  1.0 - pgat2nd_d; \
        \
        /*  One over "one minus the grading coefficient" */ \
        one_over_one_minus_pgat2nd_d = 1.0 / one_minus_pgat2nd_d; \
        \
    end

    //  --------------------------------------------------------------------------------------------------------------
    //  Calculation of internal parameters which are dependent on instance parameters
    //  --------------------------------------------------------------------------------------------------------------

`define JUNCAP200_InitModel_Instance \
    \
    /*  Variables related to device temperature */ \
    tkd          =  max($temperature + DTA + TRISE, `KELVINCONVERSION + `MINTEMP); \
    auxt         =  tkd / tkr; \
    phitd        =  KBOL_over_QELE * tkd; \
    phitdinv     =  1.0 / phitd; \
    \
    /* Bandgap voltages at device temperature */ \
    deltaphigd   = -(7.02e-4 * tkd * tkd) / (1108.0 + tkd); \
    phigdbot     =  PHIGBOT + deltaphigd; \
    phigdsti     =  PHIGSTI + deltaphigd; \
    phigdgat     =  PHIGGAT + deltaphigd; \
    \
    /*  Factors ftd for ideal-current model */ \
    ftdbot      =  (pow(auxt, 1.5)) * exp(0.5 * ((phigrbot * phitrinv) - (phigdbot * phitdinv))); \
    ftdsti      =  (pow(auxt, 1.5)) * exp(0.5 * ((phigrsti * phitrinv) - (phigdsti * phitdinv))); \
    ftdgat      =  (pow(auxt, 1.5)) * exp(0.5 * ((phigrgat * phitrinv) - (phigdgat * phitdinv))); \
    \
    /*  Temperature-scaled saturation current for ideal-current model */ \
    idsatbot     =  IDSATRBOT * ftdbot * ftdbot; \
    idsatsti     =  IDSATRSTI * ftdsti * ftdsti; \
    idsatgat     =  IDSATRGAT * ftdgat * ftdgat; \
    \
    /*  Built-in voltages before limiting */ \
    ubibot      =  VBIRBOT * auxt - 2.0 * phitd * ln(ftdbot); \
    ubisti      =  VBIRSTI * auxt - 2.0 * phitd * ln(ftdsti); \
    ubigat      =  VBIRGAT * auxt - 2.0 * phitd * ln(ftdgat); \
    \
    /*  Built-in voltages limited to phitd */ \
    vbibot       =  ubibot + phitd * ln(1 + exp((`vbilow - ubibot) * phitdinv)); \
    vbisti       =  ubisti + phitd * ln(1 + exp((`vbilow - ubisti) * phitdinv)); \
    vbigat       =  ubigat + phitd * ln(1 + exp((`vbilow - ubigat) * phitdinv)); \
    \
    /*  Inverse values of built-in voltages */ \
    vbiinvbot    =  1.0 / vbibot; \
    vbiinvsti    =  1.0 / vbisti; \
    vbiinvgat    =  1.0 / vbigat; \
    \
    /*  Temperature-scaled zero-bias capacitance */ \
    cjobot       =  CJORBOT * pow((VBIRBOT * vbiinvbot), PBOT); \
    cjosti       =  CJORSTI * pow((VBIRSTI * vbiinvsti), PSTI); \
    cjogat       =  CJORGAT * pow((VBIRGAT * vbiinvgat), PGAT); \
    \
    /*  Prefactor in physical part of charge model */ \
    qprefbot     =  cjobot * vbibot * one_over_one_minus_PBOT; \
    qprefsti     =  cjosti * vbisti * one_over_one_minus_PSTI; \
    qprefgat     =  cjogat * vbigat * one_over_one_minus_PGAT; \
    \
    /*  Prefactor in mathematical extension of charge model */ \
    qpref2bot    = `a * cjobot; \
    qpref2sti    = `a * cjosti; \
    qpref2gat    = `a * cjogat; \
    \
    /*  Half the bandgap energy, limited to values > phitd, needed in TAT model */ \
    deltaEbot    =  max(0.5 * phigdbot, phitd); \
    deltaEsti    =  max(0.5 * phigdsti, phitd); \
    deltaEgat    =  max(0.5 * phigdgat, phitd); \
    \
    /*  Values of atat, needed in TAT model */ \
    atatbot      =  deltaEbot * phitdinv; \
    atatsti      =  deltaEsti * phitdinv; \
    atatgat      =  deltaEgat * phitdinv; \
    \
    /*  Values of btatpart, needed in TAT model */ \
    btatpartbot  =  sqrt(32.0 * MEFFTATBOT * `MELE * `QELE * (deltaEbot * deltaEbot * deltaEbot)) / (3.0 * `HBAR); \
    btatpartsti  =  sqrt(32.0 * MEFFTATSTI * `MELE * `QELE * (deltaEsti * deltaEsti * deltaEsti)) / (3.0 * `HBAR); \
    btatpartgat  =  sqrt(32.0 * MEFFTATGAT * `MELE * `QELE * (deltaEgat * deltaEgat * deltaEgat)) / (3.0 * `HBAR); \
    \
    /*  Temperature-scaled values of FBBT, needed in BBT model */ \
    fbbtbot      =  FBBTRBOT * (1.0 + STFBBTBOT * (tkd - tkr)); \
    fbbtsti      =  FBBTRSTI * (1.0 + STFBBTSTI * (tkd - tkr)); \
    fbbtgat      =  FBBTRGAT * (1.0 + STFBBTGAT * (tkd - tkr)); \
    fbbtbot      = `CLIP_LOW(fbbtbot, 0.0); \
    fbbtsti      = `CLIP_LOW(fbbtsti, 0.0); \
    fbbtgat      = `CLIP_LOW(fbbtgat, 0.0); \
    \
    if ((swgat2nd) == 1.0) begin \
        \
        /*  Bandgap voltages at device temperature */ \
        phigdgat2nd  =  phiggat2nd + deltaphigd; \
        \
        /*  Factors ftd for ideal-current model */ \
        ftdgat2nd   =  (pow(auxt, 1.5)) * exp(0.5 * ((phigrgat2nd * phitrinv) - (phigdgat2nd * phitdinv))); \
        \
        /*  Built-in voltages before limiting */ \
        ubigat2nd   =  vbirgat2nd * auxt - 2.0 * phitd * ln(ftdgat2nd); \
        \
        /*  Built-in voltages limited to phitd */ \
        vbigat2nd    =  ubigat2nd + phitd * ln(1 + exp((`vbilow - ubigat2nd) * phitdinv)); \
        \
        /*  Inverse values of built-in voltages */ \
        vbiinvgat2nd   =  1.0 / vbigat2nd; \
        \
        /*  Temperature-scaled zero-bias capacitance */ \
        cjogat2nd    =  cjorgat2nd * pow((vbirgat2nd * vbiinvgat2nd), pgat2nd); \
        \
        /*  Prefactor in physical part of charge model */ \
        qprefgat2nd  =  cjogat2nd * vbigat2nd * one_over_one_minus_pgat2nd; \
        \
        /*  Prefactor in mathematical extension of charge model  */ \
        qpref2gat2nd = `a * cjogat2nd; \
    end

`define JUNCAP200_InitModel_Instance_Drain_Junction \
    \
    /*  Bandgap voltages at device temperature for drain-bulk junction */ \
    phigdbot_d   =  PHIGBOTD_i + deltaphigd; \
    phigdsti_d   =  PHIGSTID_i + deltaphigd; \
    phigdgat_d   =  PHIGGATD_i + deltaphigd; \
    \
    /*  Factors ftd for ideal-current model for drain-bulk junction */ \
    ftdbot_d     =  (pow(auxt, 1.5)) * exp(0.5 * ((phigrbot_d * phitrinv) - (phigdbot_d * phitdinv))); \
    ftdsti_d     =  (pow(auxt, 1.5)) * exp(0.5 * ((phigrsti_d * phitrinv) - (phigdsti_d * phitdinv))); \
    ftdgat_d     =  (pow(auxt, 1.5)) * exp(0.5 * ((phigrgat_d * phitrinv) - (phigdgat_d * phitdinv))); \
    \
    /*  Temperature-scaled saturation current for ideal-current model for drain-bulk junction */ \
    idsatbot_d   =  IDSATRBOTD_i * ftdbot_d * ftdbot_d; \
    idsatsti_d   =  IDSATRSTID_i * ftdsti_d * ftdsti_d; \
    idsatgat_d   =  IDSATRGATD_i * ftdgat_d * ftdgat_d; \
    \
    /*  Built-in voltages before limiting for drain-bulk junction */ \
    ubibot_d     =  VBIRBOTD_i * auxt - 2.0 * phitd * ln(ftdbot_d); \
    ubisti_d     =  VBIRSTID_i * auxt - 2.0 * phitd * ln(ftdsti_d); \
    ubigat_d     =  VBIRGATD_i * auxt - 2.0 * phitd * ln(ftdgat_d); \
    \
    /*  Built-in voltages limited to phitd for drain-bulk junction */ \
    vbibot_d     =  ubibot_d + phitd * ln(1.0 + exp((`vbilow - ubibot_d) * phitdinv)); \
    vbisti_d     =  ubisti_d + phitd * ln(1.0 + exp((`vbilow - ubisti_d) * phitdinv)); \
    vbigat_d     =  ubigat_d + phitd * ln(1.0 + exp((`vbilow - ubigat_d) * phitdinv)); \
    \
    /*  Inverse values of built-in voltages for drain-bulk junction */ \
    vbiinvbot_d  =  1.0 / vbibot_d; \
    vbiinvsti_d  =  1.0 / vbisti_d; \
    vbiinvgat_d  =  1.0 / vbigat_d; \
    \
    /*  Temperature-scaled zero-bias capacitance for drain-bulk junction */ \
    cjobot_d     =  CJORBOTD_i * pow((VBIRBOTD_i * vbiinvbot_d), PBOTD_i); \
    cjosti_d     =  CJORSTID_i * pow((VBIRSTID_i * vbiinvsti_d), PSTID_i); \
    cjogat_d     =  CJORGATD_i * pow((VBIRGATD_i * vbiinvgat_d), PGATD_i); \
    \
    /*  Prefactor in physical part of charge model for drain-bulk junction */ \
    qprefbot_d   =  cjobot_d * vbibot_d * one_over_one_minus_PBOT_d; \
    qprefsti_d   =  cjosti_d * vbisti_d * one_over_one_minus_PSTI_d; \
    qprefgat_d   =  cjogat_d * vbigat_d * one_over_one_minus_PGAT_d; \
    \
    /*  Prefactor in mathematical extension of charge model for drain-bulk junction */ \
    qpref2bot_d  = `a * cjobot_d; \
    qpref2sti_d  = `a * cjosti_d; \
    qpref2gat_d  = `a * cjogat_d; \
    \
    /*  Half the bandgap energy, limited to values > phitd, needed in TAT model for drain-bulk junction */ \
    deltaEbot_d  =  max(0.5 * phigdbot_d, phitd); \
    deltaEsti_d  =  max(0.5 * phigdsti_d, phitd); \
    deltaEgat_d  =  max(0.5 * phigdgat_d, phitd); \
    \
    /*  Values of atat, needed in TAT model for drain-bulk junction */ \
    atatbot_d    =  deltaEbot_d * phitdinv; \
    atatsti_d    =  deltaEsti_d * phitdinv; \
    atatgat_d    =  deltaEgat_d * phitdinv; \
    \
    /*  Values of btatpart, needed in TAT model for drain-bulk junction */ \
    btatpartbot_d =  sqrt(32.0 * MEFFTATBOTD_i * `MELE * `QELE * (deltaEbot_d * deltaEbot_d * deltaEbot_d)) / (3.0 * `HBAR); \
    btatpartsti_d =  sqrt(32.0 * MEFFTATSTID_i * `MELE * `QELE * (deltaEsti_d * deltaEsti_d * deltaEsti_d)) / (3.0 * `HBAR); \
    btatpartgat_d =  sqrt(32.0 * MEFFTATGATD_i * `MELE * `QELE * (deltaEgat_d * deltaEgat_d * deltaEgat_d)) / (3.0 * `HBAR); \
    \
    /*  Temperature-scaled values of FBBT, needed in BBT model for drain-bulk junction */ \
    fbbtbot_d    =  FBBTRBOTD_i * (1.0 + STFBBTBOTD_i * (tkd - tkr)); \
    fbbtsti_d    =  FBBTRSTID_i * (1.0 + STFBBTSTID_i * (tkd - tkr)); \
    fbbtgat_d    =  FBBTRGATD_i * (1.0 + STFBBTGATD_i * (tkd - tkr)); \
    fbbtbot_d    = `CLIP_LOW(fbbtbot_d, 0.0); \
    fbbtsti_d    = `CLIP_LOW(fbbtsti_d, 0.0); \
    fbbtgat_d    = `CLIP_LOW(fbbtgat_d, 0.0); \
    \
    if ((swgat2nd_d) == 1.0) begin \
        \
        /*  Bandgap voltages at device temperature */ \
        phigdgat2nd_d  =  phiggat2nd_d + deltaphigd; \
        \
        /*  Factors ftd for ideal-current model */ \
        ftdgat2nd_d   =  (pow(auxt, 1.5)) * exp(0.5 * ((phigrgat2nd_d * phitrinv) - (phigdgat2nd_d * phitdinv))); \
        \
        /*  Built-in voltages before limiting */ \
        ubigat2nd_d   =  vbirgat2nd_d * auxt - 2.0 * phitd * ln(ftdgat2nd_d); \
        \
        /*  Built-in voltages limited to phitd */ \
        vbigat2nd_d    =  ubigat2nd_d + phitd * ln(1 + exp((`vbilow - ubigat2nd_d) * phitdinv)); \
        \
        /*  Inverse values of built-in voltages */ \
        vbiinvgat2nd_d   =  1.0 / vbigat2nd_d; \
        \
        /*  Temperature-scaled zero-bias capacitance */ \
        cjogat2nd_d    =  cjorgat2nd_d * pow((vbirgat2nd_d * vbiinvgat2nd_d), pgat2nd_d); \
        \
        /*  Prefactor in physical part of charge model */ \
        qprefgat2nd_d  =  cjogat2nd_d * vbigat2nd_d * one_over_one_minus_pgat2nd_d; \
        \
        /*  Prefactor in mathematical extension of charge model  */ \
        qpref2gat2nd_d = `a * cjogat2nd_d; \
        \
    end
// ---- end `include "JUNCAP200_InitModel.include" ----

// ---- begin `include "PSP104_macrodefs.include" ----
//======================================================================================
//======================================================================================
// Filename: PSP104_macrodefs.include
//======================================================================================
//======================================================================================
//
//  (c) Copyright notice
//
//  Since 2015 until today, PSP has been co-developed by NXP Semiconductors and
//  CEA-Leti. For this part of the model, each claim undivided ownership and copyrights
//  Since 2012 until 2015, PSP has been co-developed by NXP Semiconductors and
//  Delft University of Technology. For this part of the model, each claim undivided
//  ownership and copyrights
//  Until and including 2011, PSP has been co-developed by NXP Semiconductors and
//  Arizona State University. For this part of the model, NXP Semiconductors claims
//  undivided ownership and copyrights.
//
//
//  Version: 104.1.0 (PSP), 200.7.0 (JUNCAP), March 2026
//
//======================================================================================
//======================================================================================
//
// Further information can be found in the file releasenotesPSP104.txt
//

/////////////////////////////////////////////
//
// Macros and constants used in PSP
//
/////////////////////////////////////////////

`define PMOS                 -1
`define NMOS                 +1

// Some functions
`define MINA(x,y,a)           0.5*((x)+(y)-sqrt(((x)-(y))*((x)-(y))+(a)))
`define MAXA(x,y,a)           0.5*((x)+(y)+sqrt(((x)-(y))*((x)-(y))+(a)))

`define MNE(x,y,a,mne) \
    tme1    =  4.0 - (a); \
    tme2    =  (x) + (y); \
    mne     =  2.0 / tme1 * (tme2 - sqrt(tme2 * tme2 - tme1 * (x) * (y)));

`define MXE(x,y,a,mxe) \
    tme1    =  4.0 - (a); \
    tme2    =  (x) + (y); \
    mxe     =  2.0 / tme1 * (tme2 + sqrt(tme2 * tme2 - tme1 * (x) * (y)));

// Physical constants
`define QMN                   5.951993
`define QMP                   7.448711

// Other constants (PSP-mos)
// `define DELTA1                0.02
`define invSqrt2              7.0710678118654746e-01
`define oneSixth              1.6666666666666667e-01
`define LEN                   1.0e-06
`define WEN                   1.0e-06
`define fact_sat              0.99
`define x_dsat_lim            4.60517018598809 /* =  -ln(1.0 - `fact_sat) */
`define SDVBRGAT              1.0e-3  /* Gate-dependent breakdown voltage shift smoothing value */
`define SDBBTGAT              1.0e-3  /* Gate-dependent band-to-band tunneling shift smoothing value */

/////////////////////////////////////////////////////////////////////////////
//
//  Macro definitions.
//
//  Note that because at present locally scoped variables
//  can only be in named blocks, the intermediate variables
//  used in the macros below must be explicitly declared
//  as variables in the main code.
//
/////////////////////////////////////////////////////////////////////////////

//  Function for parameter definition in the case of separate calculation of charge model in saturation
//  --------------------------------------------------------------------------------------------------------------
`define DefACparam(param_i,param_dc,param_ac) \
    param_i      =  (param_dc); \
    if ($param_given(param_ac) == 1) \
        param_i      =  (param_ac);

//  Function for binning rules
//  --------------------------------------------------------------------------------------------------------------
`define BinningRuleFct(LocParam,PoParam,PlParam,PwParam,PlwParam) \
    if (($param_given(PoParam) == 1) || ($param_given(PlParam) == 1) || ($param_given(PwParam) == 1) || ($param_given(PlwParam) == 1)) \
        LocParam     =  (PoParam) + (PlParam) * iLE + (PwParam) * iWE + (PlwParam) * iAE;

`define BinningRuleScalFct(LocParam,fscaling,PoParam,PlParam,PwParam,PlwParam) \
    if (($param_given(PoParam) == 1) || ($param_given(PlParam) == 1) || ($param_given(PwParam) == 1) || ($param_given(PlwParam) == 1)) \
        LocParam     =  (fscaling) * ((PoParam) + (PlParam) * iLE + (PwParam) * iWE + (PlwParam) * iAE);

`define BinningRuleScalFctAC(LocParam,fscaling,PoParam_ac,PlParam_ac,PwParam_ac,PlwParam_ac,PoParam_dc,PlParam_dc,PwParam_dc,PlwParam_dc) \
    if (($param_given(PoParam_ac) == 1) || ($param_given(PlParam_ac) == 1) || ($param_given(PwParam_ac) == 1) || ($param_given(PlwParam_ac) == 1) \
        || ($param_given(PoParam_dc) == 1) || ($param_given(PlParam_dc) == 1) || ($param_given(PwParam_dc) == 1) || ($param_given(PlwParam_dc) == 1)) begin \
        `DefACparam(PoParam_i, PoParam_dc, PoParam_ac) \
        `DefACparam(PlParam_i, PlParam_dc, PlParam_ac) \
        `DefACparam(PwParam_i, PwParam_dc, PwParam_ac) \
        `DefACparam(PlwParam_i, PlwParam_dc, PlwParam_ac) \
        LocParam     =  (fscaling) * (PoParam_i + PlParam_i * iLE + PwParam_i * iWE + PlwParam_i * iAE); \
    end

//  sigma function used in surface potential and other calculations
//  --------------------------------------------------------------------------------------------------------------
//  Note: one call uses expressions for arguments so parentheses around the arguments in the expressions are necessary
`define sigma(a,c,tau,eta,y) \
    nu           =  (a) + (c); \
    mutau        =  nu * nu + (tau) * (0.5 * ((c) * (c)) - (a)); \
    y            =  (eta) + (a) * nu * (tau) / (mutau + (nu / mutau) * (tau) * (tau) * (c) * ((c) * (c) * `oneThird - (a)));

// modified version of sigma function, which takes 4 arguments
//  --------------------------------------------------------------------------------------------------------------
`define sigma2(a,b,c,tau,eta,y) \
    nu           =  (a) + (c); \
    mutau        =  (nu) * (nu) + (tau) * (0.5 * ((c) * (c)) - (a) * (b)); \
    y            =  (eta) + (a) * nu * (tau) / (mutau + (nu / mutau) * (tau) * (tau) * (c) * ((c) * (c) * `oneThird - (a) * (b)));

//  sp_s function: surface potential calculation
//  --------------------------------------------------------------------------------------------------------------
`define sp_s(sp,xg,xn,delta) \
    if (abs(xg) <= margin) begin \
        SP_S_temp1   =  inv_xi * inv_xi * `oneSixth * `invSqrt2; \
        sp           =  (xg) * inv_xi * (1.0 + (xg) * (1.0 - (delta)) * Gf * SP_S_temp1); \
    end else begin \
        if ((xg) < -margin) begin \
            SP_S_yg      = -(xg); \
            SP_S_ysub    =  1.25 * (SP_S_yg * inv_xi); \
            SP_S_eta     =  0.5 * (SP_S_ysub + 10.0 - sqrt((SP_S_ysub - 6.0) * (SP_S_ysub - 6.0) + 64.0)); \
            SP_S_temp    =  SP_S_yg - SP_S_eta; \
            SP_S_a       =  SP_S_temp * SP_S_temp + Gf2 * (SP_S_eta + 1.0); \
            SP_S_c       =  2.0 * SP_S_temp - Gf2; \
            SP_S_tau     = -SP_S_eta + ln(SP_S_a * inv_Gf2); \
            `sigma(SP_S_a, SP_S_c, SP_S_tau, SP_S_eta, SP_S_y0) \
            `expl_high(SP_S_y0, SP_S_delta0) \
            SP_S_delta1  =  1.0 / SP_S_delta0; \
            SP_S_temp    =  1.0 / (2.0 + SP_S_y0 * SP_S_y0); \
            SP_S_xi0     =  SP_S_y0 * SP_S_y0 * SP_S_temp; \
            SP_S_xi1     =  4.0 * (SP_S_y0 * SP_S_temp * SP_S_temp); \
            SP_S_xi2     =  (8.0 * SP_S_temp - 12.0 * SP_S_xi0) * SP_S_temp * SP_S_temp; \
            SP_S_temp    =  SP_S_yg - SP_S_y0; \
            SP_S_temp1   =  (delta) * SP_S_delta1; \
            SP_S_pC      =  2.0 * SP_S_temp + Gf2 * (SP_S_delta0 - 1.0 - SP_S_temp1 + (delta) * (1.0 - SP_S_xi1)); \
            SP_S_qC      =  SP_S_temp * SP_S_temp - Gf2 * (SP_S_delta0 - SP_S_y0 - 1.0 + SP_S_temp1 + (delta) * (SP_S_y0 - 1.0 - SP_S_xi0)); \
            SP_S_temp    =  2.0 - Gf2 * (SP_S_delta0 + SP_S_temp1 - (delta) * SP_S_xi2); \
            SP_S_temp    =  SP_S_pC * SP_S_pC - 2.0 * (SP_S_qC * SP_S_temp); \
            sp           = -SP_S_y0 - 2.0 * (SP_S_qC / (SP_S_pC + sqrt(SP_S_temp))); \
        end else begin \
            SP_xg1       =  1.0 / (1.25 + Gf * 7.324648775608221e-01); \
            SP_S_A_fac   =  (xi * 1.25 * SP_xg1 - 1.0) * SP_xg1; \
            SP_S_xbar    =  (xg) * inv_xi * (1.0 + SP_S_A_fac * (xg)); \
            `expl_low(-SP_S_xbar, SP_S_temp) \
            SP_S_w       =  1.0 - SP_S_temp; \
            SP_S_x1      =  (xg) + Gf2 * 0.5 - Gf * sqrt((xg) + Gf2 * 0.25 - SP_S_w); \
            SP_S_bx      =  (xn) + 3.0; \
            SP_S_eta     = `MINA(SP_S_x1, SP_S_bx, 5.0) - 0.5 * (SP_S_bx - sqrt(SP_S_bx * SP_S_bx + 5.0)); \
            SP_S_temp    =  (xg) - SP_S_eta; \
            SP_S_temp1   =  exp(-SP_S_eta); \
            SP_S_temp2   =  1.0 / (2.0 + SP_S_eta * SP_S_eta); \
            SP_S_xi0     =  SP_S_eta * SP_S_eta * SP_S_temp2; \
            SP_S_xi1     =  4.0 * (SP_S_eta * SP_S_temp2 * SP_S_temp2); \
            SP_S_xi2     =  (8.0 * SP_S_temp2 - 12.0 * SP_S_xi0) * SP_S_temp2 * SP_S_temp2; \
            SP_S_a       = `MAX(1.0e-40, SP_S_temp * SP_S_temp - Gf2 * (SP_S_temp1 + SP_S_eta - 1.0 - (delta) * (SP_S_eta + 1.0 + SP_S_xi0))); \
            SP_S_b       =  1.0 - 0.5 * (Gf2 * (SP_S_temp1 - (delta) * SP_S_xi2)); \
            SP_S_c       =  2.0 * SP_S_temp + Gf2 * (1.0 - SP_S_temp1 - (delta) * (1.0 + SP_S_xi1)); \
            SP_S_tau     =  (xn) - SP_S_eta + ln(SP_S_a / Gf2); \
            `sigma2(SP_S_a, SP_S_b, SP_S_c, SP_S_tau, SP_S_eta, SP_S_x0) \
            if (SP_S_x0 < `se05) begin \
                SP_S_delta0  =  exp(SP_S_x0); \
                SP_S_delta1  =  1.0 / SP_S_delta0; \
                SP_S_delta0  =  (delta) * SP_S_delta0; \
            end else begin \
                if (SP_S_x0 > (xn) - `se05) begin \
                    SP_S_delta0  =  exp(SP_S_x0 - (xn)); \
                    SP_S_delta1  =  (delta) / SP_S_delta0; \
                end else begin \
                    SP_S_delta0  = `ke05 / `P3((xn) - SP_S_x0 - `se05); \
                    SP_S_delta1  = `ke05 / `P3(SP_S_x0 - `se05); \
                end \
            end \
            SP_S_temp    =  1.0 / (2.0 + SP_S_x0 * SP_S_x0); \
            SP_S_xi0     =  SP_S_x0 * SP_S_x0 * SP_S_temp; \
            SP_S_xi1     =  4.0 * (SP_S_x0 * SP_S_temp * SP_S_temp); \
            SP_S_xi2     =  (8.0 * SP_S_temp - 12.0 * SP_S_xi0) * SP_S_temp * SP_S_temp; \
            SP_S_temp    =  (xg) - SP_S_x0; \
            SP_S_pC      =  2.0 * SP_S_temp + Gf2 * (1.0 - SP_S_delta1 + SP_S_delta0 - (delta) * (1.0 + SP_S_xi1)); \
            SP_S_qC      =  SP_S_temp * SP_S_temp - Gf2 * (SP_S_delta1 + SP_S_x0 - 1.0 + SP_S_delta0 - (delta) * (SP_S_x0 + 1.0 + SP_S_xi0)); \
            SP_S_temp    =  2.0 - Gf2 * (SP_S_delta1 + SP_S_delta0 - (delta) * SP_S_xi2); \
            SP_S_temp    =  SP_S_pC * SP_S_pC - 2.0 * (SP_S_qC * SP_S_temp); \
            sp           =  SP_S_x0 + 2.0 * (SP_S_qC / (SP_S_pC + sqrt(SP_S_temp))); \
        end \
    end

//  sp_s_d function: surface potential calculation at drain (subset of function sp_s)
//  --------------------------------------------------------------------------------------------------------------
`define sp_s_d(sp,xg,xn,delta) \
    if (abs(xg) <= margin) begin \
        SP_S_temp1   =  inv_xi * inv_xi * `oneSixth * `invSqrt2; \
        sp           =  (xg) * inv_xi * (1.0 + (xg) * (1.0 - (delta)) * Gf * SP_S_temp1); \
    end else begin \
        SP_S_bx      =  (xn) + 3.0; \
        SP_S_eta     = `MINA(SP_S_x1, SP_S_bx, 5.0) - 0.5 * (SP_S_bx - sqrt(SP_S_bx * SP_S_bx + 5.0)); \
        SP_S_temp    =  (xg) - SP_S_eta; \
        SP_S_temp1   =  exp(-SP_S_eta); \
        SP_S_temp2   =  1.0 / (2.0 + SP_S_eta * SP_S_eta); \
        SP_S_xi0     =  SP_S_eta * SP_S_eta * SP_S_temp2; \
        SP_S_xi1     =  4.0 * (SP_S_eta * SP_S_temp2 * SP_S_temp2); \
        SP_S_xi2     =  (8.0 * SP_S_temp2 - 12.0 * SP_S_xi0) * SP_S_temp2 * SP_S_temp2; \
        SP_S_a       = `MAX(1.0e-40, SP_S_temp * SP_S_temp - Gf2 * (SP_S_temp1 + SP_S_eta - 1.0 - (delta) * (SP_S_eta + 1.0 + SP_S_xi0))); \
        SP_S_b       =  1.0 - 0.5 * (Gf2 * (SP_S_temp1 - (delta) * SP_S_xi2)); \
        SP_S_c       =  2.0 * SP_S_temp + Gf2 * (1.0 - SP_S_temp1 - (delta) * (1.0 + SP_S_xi1)); \
        SP_S_tau     =  (xn) - SP_S_eta + ln(SP_S_a / Gf2); \
        `sigma2(SP_S_a, SP_S_b, SP_S_c, SP_S_tau, SP_S_eta, SP_S_x0) \
        if (SP_S_x0 < `se05) begin \
            SP_S_delta0  =  exp(SP_S_x0); \
            SP_S_delta1  =  1.0 / SP_S_delta0; \
            SP_S_delta0  =  (delta) * SP_S_delta0; \
        end else begin \
            if (SP_S_x0 > (xn) - `se05) begin \
                SP_S_delta0  =  exp(SP_S_x0 - (xn)); \
                SP_S_delta1  =  (delta) / SP_S_delta0; \
            end else begin \
                SP_S_delta0  = `ke05 / `P3((xn) - SP_S_x0 - `se05); \
                SP_S_delta1  = `ke05 / `P3(SP_S_x0 - `se05); \
            end \
        end \
        SP_S_temp    =  1.0 / (2.0 + SP_S_x0 * SP_S_x0); \
        SP_S_xi0     =  SP_S_x0 * SP_S_x0 * SP_S_temp; \
        SP_S_xi1     =  4.0 * (SP_S_x0 * SP_S_temp * SP_S_temp); \
        SP_S_xi2     =  (8.0 * SP_S_temp-12.0 * SP_S_xi0) * SP_S_temp * SP_S_temp; \
        SP_S_temp    =  (xg) - SP_S_x0; \
        SP_S_pC      =  2.0 * SP_S_temp + Gf2 * (1.0 - SP_S_delta1 + SP_S_delta0 - (delta) * (1.0 + SP_S_xi1)); \
        SP_S_qC      =  SP_S_temp * SP_S_temp - Gf2 * (SP_S_delta1 + SP_S_x0 - 1.0 + SP_S_delta0 - (delta) * (SP_S_x0 + 1.0 + SP_S_xi0)); \
        SP_S_temp    =  2.0 - Gf2 * (SP_S_delta1 + SP_S_delta0 - (delta) * SP_S_xi2); \
        SP_S_temp    =  SP_S_pC * SP_S_pC - 2.0 * (SP_S_qC * SP_S_temp); \
        sp           =  SP_S_x0 + 2.0 * (SP_S_qC / (SP_S_pC + sqrt(SP_S_temp))); \
    end

//  sp_ovInit function: surface potential calculation for the overlap regions initialization
//  --------------------------------------------------------------------------------------------------------------
`define sp_ovInit(GOV, GOV2, SP_OV_eps2, SP_OV_a, SP_OV_delta1) \
    inv_GOV      =  1.0 / (GOV); \
    SP_OV_eps    =  3.1 * (GOV) + 8.5; \
    SP_OV_eps2   =  SP_OV_eps * SP_OV_eps; \
    SP_OV_delta  =  0.5 * SP_OV_eps; \
    if (inv_GOV < 0.06) begin \
        SP_OV_a      =  64.0 * inv_GOV; \
    end else begin \
        if (inv_GOV <= 0.45) begin \
            SP_OV_a      =  22.0 * inv_GOV + 3.0; \
        end else begin \
            if (inv_GOV <= 1.6) begin \
                SP_OV_a      = -7.2 * inv_GOV + 15.5; \
            end else begin \
                SP_OV_a      =  (GOV); \
            end \
        end \
    end \
    SP_OV_delta1 =  SP_OV_delta + (GOV2) * 0.5 - (GOV) * sqrt(SP_OV_delta + (GOV2) * 0.25 + SP_OV_a);

//  qi_edge    charge calculation for the edge transistor
//  --------------------------------------------------------------------------------------------------------------
`define qi_edge(qieff_edge,xg_edge,xn_edge) \
    Q_EDGE_xsth  =  xbedge + (xn_edge); \
    Q_EDGE_xth0  =  Q_EDGE_xsth +  Gfedge * sqrt(Q_EDGE_xsth); \
    Q_EDGE_xth   =  Q_EDGE_xth0 + dxthedge; \
    Q_EDGE_n     =  1.0 + Gfedge / (2.0 * sqrt(Q_EDGE_xsth)); \
    Q_EDGE_n_inv =  1.0 / Q_EDGE_n; \
    Q_EDGE_xgt   =  (xg_edge) - Q_EDGE_xth; \
    if (Q_EDGE_xgt > -12.0) begin \
        Q_EDGE_xgt0  =  Q_EDGE_xgt + lnGfedge2 - 1.0; \
        Q_EDGE_xgt0e =  0.5 * (Q_EDGE_xgt0 + sqrt(Q_EDGE_xgt0 * Q_EDGE_xgt0 + 10.0)); \
        Q_EDGE_qi0si =  Q_EDGE_xgt - Q_EDGE_n * ln(Q_EDGE_xgt0e) + lnGfedge2; \
        Q_EDGE_qi0   =  0.5 * (Q_EDGE_qi0si + sqrt(Q_EDGE_qi0si * Q_EDGE_qi0si + 2.0)); \
        `expl_high((Q_EDGE_xgt - Q_EDGE_qi0), Q_EDGE_exp_x) \
        Q_EDGE_d0    =  Gfedge2 * Q_EDGE_exp_x; \
        Q_EDGE_d0p   =  pow(Q_EDGE_d0, Q_EDGE_n_inv); \
        Q_EDGE_sqerr =  Q_EDGE_n * Q_EDGE_n + (2.0 * (Q_EDGE_qi0 + Q_EDGE_n) - Q_EDGE_d0p) * Q_EDGE_d0p; \
        Q_EDGE_errq  =  Q_EDGE_n * ((sqrt(Q_EDGE_sqerr) - Q_EDGE_n) / Q_EDGE_d0p - 1.0); \
        qieff_edge   =  Q_EDGE_qi0 - Q_EDGE_errq; \
    end else begin \
        `expl_low((Q_EDGE_n_inv * (Q_EDGE_xgt + lnGfedge2)), qieff_edge) \
    end

//  CollapsableR macro: used for parasitic resistances
//  --------------------------------------------------------------------------------------------------------------
//  Note: if R=0, the Verilog-A compiler should recognize that the corresponding nodes can be collapsed
`define CollapsableR(G, R, SN, N1, N2, Rname) \
    if ((R) > 0.0) begin \
        I(N1, N2)    <+  MULT_inst * MULT_I * (G) * V(N1, N2); \
        /* line below can be removed if compiler issue occurs */ \
        I(N1, N2)    <+  white_noise(MULT_inst * MULT_I * (SN), Rname); \
    end else begin \
        V(N1, N2)    <+  0.0; \
    end

//  Local variable declaration (used in SPCalculation_s/SPCalculation_d sections, PSP104_SPCalculation.include and SP macro)
//  --------------------------------------------------------------------------------------------------------------
`define SPcalcLocalVarDecl \
    real phib, aphi, G_0, V_xb, Vsbstar, thesatloc, arloc; \
    real Vgb1, dVbstar, Vsbx, Gf, Gf2, xbct, xsbstar, xgct, xwict, xctmax, xnct, xmict, xsubct, xct, dCTG, ct_fact; \
    real phitct, dphit1, phit1, inv_phit1, inv_Gf2, Ux, xg, Vdsp, delPhiB, xb, delxb, xno_s, xn_s, nscr, xthscr, xgtscr; \
    real xgtscr0, qiscr0si, qiscr0, dscr0, qiscr, qbscr, fscr, xi, margin, inv_xi, x_s, delta_ns, xi0s, xi1s, xi2s; \
    real delta_1s, Es, Ds, Ps, sqs, alphas, Rxcor, xgs, qis, qbs, rhob, rhog, GR, Eeffs, Mutmp, Gmobs, xitsb, wsat, factheta; \
    real Vdsat_lim, thesat1, asat, x_inf0, midPhi0, qisat, qbsat, alphasat, Gmobmusat, Gmobcssat, GRsat, delta_gmob, x_inf; \
    real ysat, za, x_0, x_sat, V_dsat, Vdse, Udse, xn_d, k_ds, delta_nd, x_d, x_ds, pC, qC, dps, xi0d, Ed, Pd, sqd, Dd; \
    real qbd, x_m, Em, D_bar, Dm, Pm, xgm, eta_p, sqm, alpha, d0, x_pm, p_pd, q_pd, xi_pd, u_pd, km, km0, qim, qim1; \
    real qbm, qeff, qeff1, Eeffm, Gmob, s1, Voxm, thesateff; \
    real SP_S_temp, SP_S_temp1, SP_S_temp2; \
    real SP_S_yg, SP_S_ysub, SP_S_eta, SP_S_a, SP_S_c, SP_S_tau, SP_S_y0, SP_S_delta0, SP_S_delta1, SP_S_xi0; \
    real SP_S_xi1, SP_S_xi2, SP_S_pC, SP_S_qC, SP_xg1, SP_S_A_fac, SP_S_xbar, SP_S_w, SP_S_x1, SP_S_bx, SP_S_b; \
    real SP_S_x0;

//  TempInitialize macro: initialize the temperature dependent variables
//  --------------------------------------------------------------------------------------------------------------
`define TempInitialize \
    TKD_sq       =  TKD * TKD; \
    delT         =  TKD - TKR; \
    rTn          =  TKR / TKD; \
    ln_rTn       =  ln(rTn); \
    phit         =  TKD * `KBOL / `QELE; \
    inv_phit     =  1.0 / phit; \
    Eg           =  1.179 - 9.025e-05 * TKD - 3.05e-07 * TKD_sq; \
    phibFac      =  (1.045 + 4.5e-04 * TKD) * (0.523 + 1.4e-03 * TKD - 1.48e-06 * TKD_sq) * TKD_sq / 9.0e04; \
    phibFac      = `MAX(phibFac, 1.0e-03); \
    \
    /*  Parameter for white noise of parasitic resistances */ \
    nt0          =  4.0 * `KBOL * TKD;

//  TempScaling macro: calculation of temperature dependent variables
//  --------------------------------------------------------------------------------------------------------------
`define TempScaling \
    phib_dc      =  Eg + DPHIB_i + 2.0 * phit * ln(NEFF_i * pow(phibFac, -0.75) * 4.0e-26); \
    phib_dc      = `MAX(phib_dc, 5.0e-02); \
    G_0_dc       =  sqrt(2.0 * `QELE * NEFF_i * EPSSI * inv_phit) / CoxPrime; \
    \
    /* Poly-silicon depletion */ \
    kp           =  0.0; \
    np           =  0.0; \
    if (NP_i > 0.0) begin \
        arg2max      =  8.0e07 / tox_sq; \
        np           = `MAX(NP_i, arg2max); \
        np           = `MAX(5.0e24, np); \
        kp           =  2.0 * CoxPrime * CoxPrime * phit / (`QELE * np * EPSSI); \
    end \
    \
    /* QM corrections */ \
    qlim2        =  100.0 * phit * phit; \
    if (QMC > 0.0) begin \
        qb0          =  sqrt(phit * G_0_dc * G_0_dc * phib_dc); \
        dphibq       =  0.75 * qq * pow(qb0, `twoThirds); \
        phib_dc      =  phib_dc + dphibq; \
        G_0_dc       =  G_0_dc * (1.0 + 2.0 * `twoThirds * dphibq / qb0); \
    end \
    sqrt_phib_dc =  sqrt(phib_dc); \
    phix_dc      =  0.95 * phib_dc; \
    aphi_dc      =  0.0025 * phib_dc * phib_dc; \
    bphi_dc      =  aphi_dc; \
    phix2        =  0.5 * sqrt(bphi_dc); \
    phix1_dc     =  `MINA(phix_dc - phix2, 0.0, aphi_dc); \
    alpha_b      =  0.5 * (phib_dc + Eg); \
    us1          =  sqrt(VSBNUD_i + phib_dc) - sqrt_phib_dc; \
    us21         =  sqrt(VSBNUD_i + DVSBNUD_i + phib_dc) - sqrt_phib_dc - us1; \
    \
    /* Additional variables for separate surface potential calculation for CV */ \
    phib_ac      =  Eg + DPHIB_i + DELVTAC_i + 2.0 * phit * ln(NEFFAC_i * pow(phibFac, -0.75) * 4.0e-26); \
    phib_ac      = `MAX(phib_ac, 5.0e-02); \
    G_0_ac       =  sqrt(2.0 * `QELE * NEFFAC_i * EPSSI * inv_phit) / CoxPrime; \
    \
    if (QMC > 0.0) begin \
        qb0          =  sqrt(phit * G_0_ac * G_0_ac * phib_ac); \
        dphibq       =  0.75 * qq * pow(qb0, `twoThirds); \
        phib_ac      =  phib_ac + dphibq; \
        G_0_ac       =  G_0_ac * (1.0 + 2.0 * `twoThirds * dphibq / qb0); \
    end \
    \
    phix_ac      =  0.95 * phib_ac; \
    aphi_ac      =  0.0025 * phib_ac * phib_ac; \
    bphi_ac      =  aphi_ac; \
    phix2        =  0.5 * sqrt(bphi_ac); \
    phix1_ac     = `MINA(phix_ac - phix2, 0.0, aphi_ac); \
    \
    /* Temperature scaling of parameters*/ \
    VFB_T        =  VFB_i + STVFB_i * delT * (1.0 + ST2VFB_i * delT) + DELVTO_i; \
    \
    /* Interface states parameters*/ \
    tf_ct        =  exp(STCT_i * ln_rTn); \
    CT_T         =  CT_i * tf_ct; \
    CTG_T        =  CTG_i / rTn; \
    \
    /* Mobility parameters */ \
    tf_bet       =  exp(STBET_i * ln_rTn); \
    BETN_T       =  BETN_i * tf_bet; \
    BET_i        =  FACTUO_i * BETN_T * CoxPrime; \
    THEMU_T      =  THEMU_i * exp(STTHEMU_i * ln_rTn); \
    tf_mue       =  exp(STMUE_i * ln_rTn); \
    MUE_T        =  MUE_i * tf_mue; \
    THECS_T      =  THECS_i * exp(STTHECS_i * ln_rTn); \
    tf_cs        =  exp(STCS_i * ln_rTn); \
    CS_T         =  CS_i * tf_cs; \
    tf_xcor      =  exp(STXCOR_i * ln_rTn); \
    XCOR_T       =  XCOR_i * tf_xcor; \
    \
    /* Series resistance */ \
    tf_ther      =  exp(STRS_i * ln_rTn); \
    RS_T         =  RS_i * tf_ther; \
    THER_i       =  2.0 * BET_i * RS_T; \
    \
    /* Velocity saturation */ \
    tf_thesat    =  exp(STTHESAT_i * ln_rTn); \
    THESAT_T     =  THESAT_i * tf_thesat; \
    THESATAC_T   =  THESATAC_i * tf_thesat; \
    \
    /* Impact ionization */ \
    A2_T         =  A2_i * exp(-STA2_i * ln_rTn); \
    \
    /* Noise */ \
    nt           =  FNT_i * 4.0 * `KBOL * TKD; \
    Sfl_prefac   =  phit * phit * BET_i / Cox_over_q; \
    \
    /* Edge transistor */ \
    if ((SWEDGE != 0) && (BETNEDGE_i > 0.0)) begin \
        VFBEDGE_T    =  VFBEDGE_i + STVFBEDGE_i * delT + DELVTOEDGE_i; \
        tf_betedge   =  exp(STBETEDGE_i * ln_rTn); \
        BETNEDGE_T   =  BETNEDGE_i * tf_betedge; \
        BETEDGE_i    =  FACTUOEDGE_i * BETNEDGE_T * CoxPrime; \
        phit0edge    =  phit * (1.0 + CTEDGE_i * rTn); \
        phibedge     =  Eg + DPHIBEDGE_i + 2.0 * phit0edge * ln(NEFFEDGE_i * pow(phibFac, -0.75) * 4.0e-26); \
        phibedge     = `MAX(phibedge, 5.0e-02); \
        Gfedge       =  sqrt(2.0 * `QELE * NEFFEDGE_i * EPSSI * inv_phit) / CoxPrime; \
        Gfedge2      =  Gfedge * Gfedge; \
        lnGfedge2    =  ln(Gfedge2); \
        phixedge     =  0.95 * phibedge; \
        aphiedge     =  0.0025 * phibedge * phibedge; \
        bphiedge     =  aphiedge; \
        phix2edge    =  0.5 * sqrt(bphiedge); \
        phix1edge    = `MINA(phixedge - phix2edge, 0.0, aphiedge); \
        Sfl_prefac_edge =  phit * phit * BETEDGE_i / Cox_over_q; \
        ntedge       =  FNTEDGE_i * 4.0 * `KBOL * TKD; \
    end else begin \
        VFBEDGE_T    =  0.0; \
        tf_betedge   =  1.0; \
        BETNEDGE_T   =  0.0; \
        BETEDGE_i    =  0.0; \
        phit0edge    =  phit; \
        phibedge     =  0.0; \
        Gfedge       =  1.0; \
        Gfedge2      =  1.0; \
        lnGfedge2    =  0.0; \
        phixedge     =  0.0; \
        aphiedge     =  0.0; \
        bphiedge     =  0.0; \
        phix2edge    =  0.0; \
        phix1edge    =  0.0; \
        Sfl_prefac_edge =  0.0; \
        ntedge       =  1.0; \
    end

//  Model's core for currents and charges calculation (initially into PSP104_SPCalculation.include)
//  --------------------------------------------------------------------------------------------------------------
`define SPCalculation_s \
    \
    /* Bias definition */  \
    Vgb1         =  Vgb - dVbstar - VFB_T; \
    Vsbx         =  Vsbstar + 0.5 * (V_ds - Vdsx); \
    \
    /* Bias dependence of interface states */ \
    dCTG         =  1.0; \
    if (CTG_i > 0.0) begin \
        xbct         =  phib * inv_phit; \
        xsbstar      =  Vsbx * inv_phit; \
        xgct         =  Vgb1 * inv_phit; \
        temp1        =  1.0 + 0.5 * G_0 / sqrt(xbct); \
        temp2        =  xbct + G_0 * sqrt(xbct); \
        xwict        =  (xgct - temp2) / temp1 + 0.5 * xbct - (1.0 + CTB_i) * xsbstar; \
        xctmax       =  0.5 * xbct + 2.0; \
        xnct         =  xbct + xsbstar; \
        temp1        =  xgct - xnct - G_0 * sqrt(xnct) - 2.0 * ln(xbct / G_0 + sqrt(xbct)); \
        xmict        =  2.0 * temp1 + xctmax; \
        temp1        = `MAXA(xwict, xmict, 20.0); \
        temp2        =  2.0 * (xgct - xsbstar) - xctmax; \
        xsubct       = `MINA(temp1, temp2, 20.0); \
        temp1        = `MINA(xsubct, xctmax, 5.0); \
        xct          = `MAXA(temp1, -xctmax, 20.0); \
        temp2        =  CTG_T * (xct / xctmax + 1.0); \
        `expl_low(temp2, dCTG) \
    end \
    ct_fact      =  1.0 + CT_T * dCTG; \
    phitct       =  phit * ct_fact; \
    \
    /* Short channel effects */ \
    dphit1       =  PSCE_i * (1.0 + PSCED_i * Vdsx) * (1.0 + PSCEB_i * Vsbx); \
    phit1        =  phitct * (1.0 + dphit1); \
    inv_phit1    =  1.0 / phit1; \
    Gf           =  G_0 * sqrt(phit * inv_phit1); \
    Gf2          =  Gf * Gf; \
    inv_Gf2      =  1.0 / Gf2; \
    Ux           =  Vsbstar * inv_phit1; \
    xg           =  Vgb1 * inv_phit1; \
    Vdsp         =  2.0 * Vdsx / (1.0 + sqrt(1.0 + CFD_i * Vdsx)); \
    delPhiB      =  CF_i * Vdsp * (1.0 + CFB_i * Vsbx); \
    xb           =  phib * inv_phit1; \
    temp1        =  sqrt(V_xb * V_xb + aphi); \
    temp2        =  sqrt((V_xb - delPhiB) * (V_xb - delPhiB) + aphi); \
    delxb        =  0.5 * inv_phit1 * (delPhiB + temp1 - temp2); \
    xno_s        =  xb + Ux; \
    xn_s         =  xno_s - delxb; \
    \
    /* Screening function in strong inversion */ \
    if (SWNUD > 0.0) begin \
        if (abs(xn_s) < 1e-5) begin \
            nscr         =  1.0 + Gf * (1.0 - 0.5 * xn_s * (1.0 - 0.3125 * xn_s)); \
        end else begin \
            if (xn_s < `se) begin \
                delta_ns     =  exp(-xn_s); \
            end else begin \
                delta_ns     = `ke / `P3(xn_s - `se); \
            end \
            temp = (xn_s > 0 ? 1.0 : -1.0); \
            nscr = 1.0 + temp * Gf * (1.0 - delta_ns * (1.0 - xn_s)) / (2.0 * sqrt(xn_s * (1.0 - delta_ns))); \
        end \
    end else begin \
        nscr         =  1.0 + 0.5 * Gf / sqrt(xn_s); \
    end \
    xthscr       =  xn_s + Gf * sqrt(xn_s) - nscr * ln(nscr - 1.0); \
    xgtscr       =  (xg - xthscr) / nscr; \
    qbscr        =  0.5 * Gf2 * (sqrt(1.0 + 8.0 / Gf2) - 1.0); \
    qiscr        =  0.0; \
    fscr         =  1.0; \
    if (xgtscr > -30.0) begin \
        xgtscr0      =  nscr * xgtscr - 1.0; \
        temp         =  0.5 * (xgtscr0 + sqrt(xgtscr0 * xgtscr0 + 10.0)); \
        qiscr0si     =  xgtscr - ln(temp); \
        qiscr0       =  0.5 * (qiscr0si + sqrt(qiscr0si * qiscr0si + 2.0)); \
        `expl_high((xgtscr - qiscr0), temp) \
        dscr0        =  temp / nscr; \
        temp         =  2.0 * (qiscr0 + 1.0) - dscr0; \
        if (dscr0 > 1.0e-06) begin \
            qiscr        =  nscr * (qiscr0 - (sqrt(1.0 + dscr0 * temp) - 1.0) / dscr0 + 1.0); \
        end else begin \
            qiscr        =  nscr * 0.5 * dscr0 * (1.0 + 0.25 * temp * temp); \
        end \
        temp         =  0.5 * (xg - qiscr + 2.0 + sqrt((xg - qiscr - 2.0) * (xg - qiscr - 2.0) + 1.0)); \
        qbscr        =  0.5 * Gf2 * (sqrt(1.0 + 4.0 / Gf2 * temp) - 1.0); \
        fscr         =  qbscr / (qbscr + qiscr); \
        xn_s         =  xno_s - fscr * delxb; \
    end \
    \
    /* Surface potential at source side */ \
    xi           =  1.0 + Gf * `invSqrt2; \
    margin       =  1.0e-05 * xi; \
    inv_xi       =  1.0 /  xi; \
    SP_S_x1      =  0.0; \
    x_s          =  0.0; \
    if (xn_s < `se) \
        delta_ns     =  exp(-xn_s); \
    else \
        delta_ns     = `ke / `P3(xn_s - `se); \
    `sp_s(x_s, xg, xn_s, delta_ns) \
    \
    /* Initialisation of some variables */ \
    xi1s         =  0.0; \
    xi2s         =  0.0; \
    delta_1s     =  0.0; \
    Es           =  0.0; \
    Ds           =  0.0; \
    Ps           =  0.0; \
    sqs          =  0.0; \
    alphas       =  1.0; \
    Rxcor        =  1.0; \
    xgs          =  xg - x_s; \
    qis          =  0.0; \
    qbs          =  phit1 * xgs; \
    rhob         =  1.0; \
    rhog         =  1.0; \
    Gmobs        =  1.0; \
    xitsb        =  1.0; \
    factheta     =  1.0; \
    \
    if (xg > 0.0) begin \
        temp         =  1.0 / (2.0 + x_s * x_s); \
        xi0s         =  x_s * x_s * temp; \
        xi1s         =  4.0 * (x_s * temp * temp); \
        xi2s         =  (8.0 * temp - 12.0 * xi0s) * temp * temp; \
        delta_1s     =  0.0; \
        if (x_s < `se05) begin \
            delta_1s     =  exp(x_s); \
            Es           =  1.0 / delta_1s; \
            delta_1s     =  delta_ns * delta_1s; \
        end else if (x_s > (xn_s - `se05)) begin \
            delta_1s     =  exp(x_s - xn_s); \
            Es           =  delta_ns / delta_1s; \
        end else begin \
            delta_1s     = `ke05 / `P3(xn_s - x_s - `se05); \
            Es           = `ke05 / `P3(x_s - `se05); \
        end \
        Ds           =  delta_1s - delta_ns * (x_s + 1.0 + xi0s); \
        if (x_s < 1.0e-05) begin \
            Ps           =  0.5 * (x_s * x_s * (1.0 - `oneThird * (x_s * (1.0 - 0.25 * x_s)))); \
            Ds           = `oneSixth * (delta_ns * x_s * x_s * x_s * (1.0 + 1.75 * x_s)); \
            temp         =  sqrt(1.0 - `oneThird * (x_s * (1.0 - 0.25 * x_s))); \
            sqs          = `invSqrt2 * (x_s * temp); \
            alphas       =  1.0 + `invSqrt2 * (Gf * (1.0 - 0.5 * x_s + `oneSixth * (x_s * x_s)) / temp); \
        end else begin \
            Ps           =  x_s - 1.0 + Es; \
            sqs          =  sqrt(Ps); \
            alphas        =  1.0 + 0.5 * (Gf * (1.0 - Es) / sqs); \
        end \
        \
        /* Variables for calculation of drain saturation voltage */ \
        Rxcor        =  (1.0 + 0.2 * XCOR_T * Vsbx) / (1.0 + XCOR_T * Vsbx); \
        if (Ds > `ke05) begin \
            xgs          =  Gf * sqrt(Ps + Ds); \
            qis          =  Gf2 * Ds * phit1 / (xgs + Gf * sqs); \
            qbs          =  sqs * Gf * phit1; \
            if (RSB_i < 0.0) begin \
                rhob         =  1.0 / (1.0 - RSB_i * Vsbx); \
            end else begin \
                rhob         =  1.0 + RSB_i * Vsbx; \
            end \
            if (RSG_i < 0.0) begin \
                rhog         =  1.0 - RSG_i * qis; \
            end else begin \
                rhog         =  1.0 / (1.0 + RSG_i * qis); \
            end \
            GR           =  THER_i * rhob * rhog * qis; \
            Eeffs        =  E_eff0 * (qbs + eta_mu * qis); \
            temp1        =  ln(Ps / (Ps + Ds + 1.0e-14)); \
            Mutmp        =  pow(Eeffs * MUE_T, THEMU_T) + CS_T * exp(0.5 * THECS_T * temp1); \
            Gmobs        =  (1.0 + Mutmp + GR) * Rxcor; \
            if (THESATB_i < 0.0) begin \
                xitsb        =  1.0 / (1.0 - THESATB_i * Vsbx); \
            end else begin \
                xitsb        =  1.0 + THESATB_i * Vsbx; \
            end \
            temp2        =  qis * xitsb; \
            wsat         =  temp2 / (THESATT_i + temp2); \
            if (THESATG_i < 0.0) begin \
                factheta     =  1.0 / (1.0 - THESATG_i * wsat); \
            end else begin \
                factheta     =  1.0 + THESATG_i * wsat; \
            end \
        end \
    end /* (xg > 0.0) */

`define SPCalculation_d \
    /* Initialisation of some variables */ \
    thesat1      =  0.0; \
    Vdsat_lim    =  phit1 * `x_dsat_lim; \
    V_dsat       =  Vdsat_lim; \
    Vdse         =  V_ds; \
    Udse         =  V_ds * inv_phit1; \
    x_d          =  x_s; \
    x_ds         =  0.0; \
    dps          =  0.0; \
    Ed           =  Es; \
    Pd           =  Ps; \
    Dd           =  Ds; \
    qbd          =  qbs; \
    x_m          =  x_s; \
    Em           =  Es; \
    Dm           =  Ds; \
    Pm           =  Ps; \
    xgm          =  xg - x_s; \
    eta_p        =  1.0; \
    alpha        =  1.0; \
    sqm          =  0.0; \
    qim          =  qis; \
    qeff1        =  xgm * phit1; \
    qim1         =  0.0; \
    qbm          =  qbs; \
    s1           =  0.0; \
    Gmob         =  1.0; \
    thesateff    =  thesatloc; \
    Voxm         =  qeff1; \
    \
    if (xg > 0.0) begin \
        /* Drain saturation voltage */ \
        if (Ds > `ke05) begin \
            thesateff    =  thesatloc * factheta; \
            thesat1      =  thesateff / Gmobs; \
            asat         =  xgs + 0.5 * Gf2; \
            temp         =  Gf2 * delta_1s / asat / asat; \
            if (temp > 1.0e-04) begin \
                temp1        =  1.0 - temp; \
                if (temp1 < 1.0e-10) begin \
                    temp2        =  1.0; \
                end else begin \
                    temp2        =  1.0 - sqrt(temp1); \
                end \
            end else begin \
                temp2        =  0.5 * temp; \
            end \
            x_inf0       =  temp2 * asat; \
            if ((CS_T > 0.0) && (THECS_T > 0.0)) begin \
                midPhi0      =  0.475 * phit1 * x_inf0; \
                temp         =  qis - alphas * midPhi0; \
                qisat        =  0.5 * (temp + sqrt(temp * temp + 1.0e-12)); \
                qbsat        =  phit1 * xgs - qis + (alphas - 1.0) * midPhi0; \
                alphasat     =  1.0 + 0.5 * Gf2 * phit1 / qbsat; \
                temp         =  qbsat + eta_mu * qisat; \
                Gmobmusat    =  pow(E_eff0 * temp * MUE_T, THEMU_T); \
                temp1        =  THEMU_T * (alphasat * (1.0 - eta_mu) - 1.0) / temp * Gmobmusat; \
                temp         =  qisat / qbsat; \
                Gmobcssat    =  CS_T * pow(1.0 + temp, -THECS_T); \
                temp2        =  THECS_T * (alphasat - 1.0 + 1.0 / (temp + 1.0)) / qbsat * Gmobcssat; \
                GRsat        =  THER_i * rhob * rhog * qisat; \
                temp         =  1.0 + (temp1 - THER_i * rhob * rhog * alphasat) / temp2; \
                if (temp < `se05) begin \
                    temp1        =  0.5 * ln(1.0 + exp(2.0 * temp)); \
                end else begin \
                    temp1        =  temp; \
                end \
                delta_gmob   = -midPhi0 * temp2 * temp1 / (1.0 + Gmobmusat + Gmobcssat + GRsat); \
                x_inf        =  x_inf0 * (1.0 + delta_gmob / (1.0 + sqrt(1.0 + delta_gmob * delta_gmob))); \
            end else begin \
                x_inf        =  x_inf0; \
            end \
            ysat         =  phit1 * thesat1 * x_inf * `invSqrt2; \
            if (CHNL_TYPE==`PMOS) begin \
                ysat         =  ysat / sqrt(1.0 + ysat); \
            end \
            za           =  2.0 / (1.0 + sqrt(1.0 + 4.0 * ysat)); \
            temp         =  za * ysat; \
            x_0          =  x_inf * za * (1.0 + 0.86 * temp * (1.0 - temp * za) / (1.0 + 4.0 * temp * temp * za)); \
            x_sat        = `fact_sat * x_0; \
            temp         =  x_sat * (x_sat - 2.0 * asat) * inv_Gf2 / Ds; \
            V_dsat       =  phit1 * (x_sat - ln(1.0 + `MAX(temp, -`fact_sat))); \
        end else begin \
            V_dsat       =  Vdsat_lim; \
        end \
        \
        /* Effective drain voltage */ \
        temp         =  1.0 + arloc; \
        temp1        =  sqrt(temp) * V_ds / V_dsat; \
        temp2        =  temp1 * temp1 + temp; \
        temp         =  2.0 * temp1; \
        Vdse         =  V_dsat * temp / (sqrt(temp2 - temp) + sqrt(temp2 + temp)); \
        \
        /* Surface potential at drain side */ \
        Udse         =  Vdse * inv_phit1; \
        xn_d         =  xn_s + Udse; \
        if (Udse < `se) begin \
            k_ds         =  exp(-Udse); \
        end else begin \
            k_ds         = `ke / `P3(Udse - `se); \
        end \
        delta_nd     =  delta_ns * k_ds; \
        \
        `sp_s_d(x_d, xg, xn_d, delta_nd) \
        x_ds         =  x_d - x_s; \
        \
        /* Approximations for extremely small x_ds: capacitance calculation */ \
        if (x_ds < 1.0e-10) begin \
            pC           =  2.0 * (xg - x_s) + Gf2 * (1.0 - Es + delta_1s * k_ds - delta_nd * (1.0 + xi1s)); \
            qC           =  Gf2 * (1.0 - k_ds) * Ds; \
            temp         =  2.0 - Gf2 * (Es + delta_1s * k_ds - delta_nd * xi2s); \
            temp         =  pC * pC - 2.0 * (temp * qC); \
            x_ds         =  2.0 * (qC / (pC + sqrt(temp))); \
            x_d          =  x_s + x_ds; \
        end \
        dps          =  x_ds * phit1; \
        \
        xi0d         =  x_d * x_d / (2.0 + x_d * x_d); \
        if (x_d < `se05) begin \
            Ed           =  exp(-x_d); \
            if (x_d < 1.0e-05) begin \
                Pd           =  0.5 * (x_d * x_d * (1.0 - `oneThird * (x_d * (1.0 - 0.25 * x_d)))); \
                temp         =  sqrt(1.0 - `oneThird * (x_d * (1.0 - 0.25 * x_d))); \
                sqd          = `invSqrt2 * (x_d * temp); \
                Dd           = `oneSixth * delta_nd * x_d * x_d * x_d * (1.0 + 1.75 * x_d); \
            end else begin \
                Pd           =  x_d - 1.0 + Ed; \
                sqd          =  sqrt(Pd); \
                Dd           =  delta_nd * (1.0 / Ed - x_d - 1.0 - xi0d); \
            end \
        end else begin \
            if (x_d > (xn_d - `se05)) begin \
                temp         =  exp(x_d - xn_d); \
                Ed           =  delta_nd / temp; \
                Dd           =  temp - delta_nd * (x_d + 1.0 + xi0d); \
            end else begin \
                Ed           = `ke05 / `P3(x_d - `se05); \
                temp         = `ke05 / `P3(xn_d - x_d - `se05); \
                Dd           =  temp - delta_nd * (x_d + 1.0 + xi0d); \
            end \
            Pd           =  x_d - 1.0 + Ed; \
            sqd          =  sqrt(Pd); \
        end \
        qbd          =  sqd * Gf * phit1; \
        \
        /* Mid-point surface potential */ \
        x_m          =  0.5 * (x_s + x_d); \
        Em           =  0.0; \
        temp         =  Ed * Es; \
        if (temp > 0.0) begin \
            Em           =  sqrt(temp); \
        end \
        D_bar        =  0.5 * (Ds + Dd); \
        Dm           =  D_bar + 0.125 * (x_ds * x_ds * (Em - 2.0 * inv_Gf2)); \
        \
        if (x_m < 1.0e-5) begin \
            Pm           =  0.5 * (x_m * x_m * (1.0 - `oneThird * (x_m * (1.0 - 0.25 * x_m)))); \
            xgm          =  Gf * sqrt(Dm + Pm); \
            \
            /* Polysilicon depletion */ \
            if (kp > 0.0) begin \
                eta_p        =  1.0 / sqrt(1.0 + kp * xgm); \
            end /* (kp > 0.0) */ \
            temp         =  sqrt(1.0 - `oneThird * (x_m * (1.0 - 0.25 * x_m))); \
            sqm          = `invSqrt2 * (x_m * temp); \
            alpha        =  eta_p + `invSqrt2 * (Gf * (1.0 - 0.5 * x_m + `oneSixth * (x_m * x_m)) / temp); \
        end else begin \
            Pm           =  x_m - 1.0 + Em; \
            xgm          =  Gf * sqrt(Dm + Pm); \
            \
            /* Polysilicon depletion */ \
            if (kp > 0.0) begin \
                d0           =  1.0 - Em + 2.0 * (xgm * inv_Gf2); \
                eta_p        =  1.0 / sqrt(1.0 + kp * xgm); \
                temp         =  eta_p / (eta_p + 1.0); \
                x_pm         =  kp * (temp * temp * Gf2 * Dm); \
                p_pd         =  2.0 * (xgm - x_pm) + Gf2 * (1.0 - Em + Dm); \
                q_pd         =  x_pm * (x_pm - 2.0 * xgm); \
                xi_pd        =  1.0 - 0.5 * (Gf2 * (Em + Dm)); \
                u_pd         =  q_pd * p_pd / (p_pd * p_pd - xi_pd * q_pd); \
                x_m          =  x_m + u_pd; \
                km           =  exp(u_pd); \
                Em           =  Em / km; \
                Dm           =  Dm * km; \
                Pm           =  x_m - 1.0 + Em; \
                xgm          =  Gf * sqrt(Dm + Pm); \
                km0          =  1.0 - Em + 2.0 * (xgm * eta_p * inv_Gf2); \
                x_ds         =  x_ds * km * (d0 + D_bar) / (km0 + km * D_bar); \
                dps          =  x_ds * phit1; \
            end /* (kp > 0.0) */ \
            sqm          =  sqrt(Pm); \
            alpha        =  eta_p + 0.5 * (Gf * (1.0 - Em) / sqm); \
        end \
        \
        /* Mid-point charges */ \
        qim          =  phit1 * (Gf2 * Dm / (xgm + Gf * sqm)); \
        qim1         =  qim + phit1 * alpha; \
        qbm          =  sqm * Gf * phit1; \
        \
        /* Series resistance */ \
        if (RSG_i < 0.0) begin \
            rhog         = 1.0 - RSG_i * qim; \
        end else begin \
            rhog         = 1.0 / (1.0 + RSG_i * qim); \
        end \
        GR           =  THER_i * rhob * rhog * qim; \
        \
        /* Mobility reduction */ \
        qeff         =  qbm + eta_mu * qim; \
        qeff1        =  qbm + eta_mu1 * qim; \
        Eeffm        =  E_eff0 * qeff; \
        temp1        =  ln(Pm / (Pm + Dm + 1.0e-14)); \
        Mutmp        =  pow(Eeffm * MUE_T, THEMU_T) + CS_T * exp(0.5 * THECS_T * temp1); \
        Gmob         =  (1.0 + Mutmp + GR) * Rxcor; \
        \
        /* Variables for calculation of channel length modulation */ \
        s1           =  ln((1.0 + (V_ds - dps) * inv_VP) / (1.0 + (Vdse - dps) * inv_VP)); \
        \
        /* Variables for calculation of velocity saturation */ \
        temp2        =  qim * xitsb; \
        wsat         =  temp2 / (THESATT_i + temp2); \
        if (THESATG_i < 0.0) begin \
            factheta     =  1.0 / (1.0 - THESATG_i * wsat); \
        end else begin \
            factheta     =  1.0 + THESATG_i * wsat; \
        end \
        thesateff    =  thesatloc * factheta; \
        \
        /* Variables for calculation of intrinsic charges and gate current */ \
        Voxm         =  xgm * phit1; \
        \
    end /* (xg > 0.0) */
// ---- end `include "PSP104_macrodefs.include" ----

// ---- begin `include "PSP104_opvar.include" ----
//======================================================================================
//======================================================================================
// Filename: PSP104_opvar.include
//======================================================================================
//======================================================================================
//
//  (c) Copyright notice
//
//  Since 2015 until today, PSP has been co-developed by NXP Semiconductors and
//  CEA-Leti. For this part of the model, each claim undivided ownership and copyrights
//  Since 2012 until 2015, PSP has been co-developed by NXP Semiconductors and
//  Delft University of Technology. For this part of the model, each claim undivided
//  ownership and copyrights
//  Until and including 2011, PSP has been co-developed by NXP Semiconductors and
//  Arizona State University. For this part of the model, NXP Semiconductors claims
//  undivided ownership and copyrights.
//
//
//  Version: 104.1.0 (PSP), 200.7.0 (JUNCAP), March 2026
//
//======================================================================================
//======================================================================================
//
// Further information can be found in the file releasenotesPSP104.txt
//

//  Declaration of variables for operating point info
//  --------------------------------------------------------------------------------------------------------------
`define OPVarDecl \
integer CHNL_OP_TYPE; \
real temp_op; \
real P_D_op, facvsb0_op, vtho_op, Vsbstar_op, facvsb_op, vth_op, vtho_i, vth_i, vthac_i; \
\
/* Device geometry and temperature */ \
`OPP(weff              ,"m"            ,"Effective channel width for geometrical models") \
`OPP(leff              ,"m"            ,"Effective channel length for geometrical models") \
`OPP(tk                ,"K"            ,"Device Temperature") \
\
/* Bias convention */ \
`OPP(ctype             ,""             ,"Flag for channel type") \
`OPP(sdint             ,""             ,"Flag for source-drain interchange") \
\
/* Currents and voltages */ \
`OPM(id                ,"A"            ,"Total drain current") \
`OPM(ig                ,"A"            ,"Total gate current") \
`OPM(is                ,"A"            ,"Total source current") \
`OPM(ib                ,"A"            ,"Total bulk current") \
`OPM(idsch             ,"A"            ,"Drain-source channel current incl. edge transistor current") \
`OPM(ids               ,"A"            ,"Drain-current current, excl. edge transistor currents, avalanche, tunnel, GISL, GIDL, and junction currents") \
`OPM(igs               ,"A"            ,"Gate-source tunneling current") \
`OPM(igd               ,"A"            ,"Gate-drain tunneling current") \
`OPM(igb               ,"A"            ,"Gate-bulk tunneling current") \
`OPM(idb               ,"A"            ,"Drain to bulk current") \
`OPM(isb               ,"A"            ,"Source to bulk current") \
`OPM(igcs              ,"A"            ,"Gate-channel tunneling current (source component)") \
`OPM(igcd              ,"A"            ,"Gate-channel tunneling current (drain component)") \
`OPM(iavl              ,"A"            ,"Substrate current due to weak avalanche") \
`OPM(igisl             ,"A"            ,"Gate-induced source leakage current") \
`OPM(igidl             ,"A"            ,"Gate-induced drain leakage current") \
`OPM(ijs               ,"A"            ,"Total source junction current") \
`OPM(ijd               ,"A"            ,"Total drain junction current") \
`OPM(idsedge           ,"A"            ,"Drain current of edge transistors") \
`OPP(vgs               ,"V"            ,"Gate-source voltage") \
`OPP(vgd               ,"V"            ,"Gate-drain voltage") \
`OPP(vds               ,"V"            ,"Drain-source voltage") \
`OPP(vsb               ,"V"            ,"Source-bulk voltage") \
`OPP(vdb               ,"V"            ,"Drain-bulk voltage") \
`OPP(vgs_i             ,"V"            ,"Internal gate-source voltage") \
`OPP(vgd_i             ,"V"            ,"Internal gate-drain voltage") \
`OPP(vds_i             ,"V"            ,"Internal drain-source voltage") \
`OPP(vsb_i             ,"V"            ,"Internal source-bulk voltage") \
`OPP(vdb_i             ,"V"            ,"Internal drain-bulk voltage") \
`OPP(vtho              ,"V"            ,"Zero-bias threshold voltage") \
`OPP(vth               ,"V"            ,"Threshold voltage including back bias and drain bias effects") \
`OPP(vthac             ,"V"            ,"Threshold voltage for charge in case of lateral non-uniform doping profile (SWDELVTAC=1)") \
`OPP(vgt               ,"V"            ,"Effective gate drive voltage including back bias and drain bias effects") \
`OPP(vdsat             ,"V"            ,"Drain saturation voltage at actual bias") \
`OPP(vdsat_marg        ,"V"            ,"Saturation limit") \
\
/* Small-signal equivalent circuit */ \
`OPM(gm_i              ,"S"            ,"Intrinsic transconductance") \
`OPM(gmb_i             ,"S"            ,"Intrinsic substrate transconductance") \
`OPM(gds_i             ,"S"            ,"Intrinsic output conductance") \
`OPM(gm                ,"S"            ,"Transconductance") \
`OPM(gmb               ,"S"            ,"Substrate transconductance") \
`OPM(gds               ,"S"            ,"Output conductance") \
`OPM(gjs               ,"S"            ,"Source junction conductance") \
`OPM(gjd               ,"S"            ,"Drain junction conductance") \
`OPM(cdd_i             ,"F"            ,"Intrinsic drain capacitance") \
`OPM(cdg_i             ,"F"            ,"Intrinsic drain-gate capacitance") \
`OPM(cds_i             ,"F"            ,"Intrinsic drain-source capacitance") \
`OPM(cdb_i             ,"F"            ,"Intrinsic drain-bulk capacitance") \
`OPM(cgd_i             ,"F"            ,"Intrinsic gate-drain capacitance") \
`OPM(cgg_i             ,"F"            ,"Intrinsic gate capacitance") \
`OPM(cgs_i             ,"F"            ,"Intrinsic gate-source capacitance") \
`OPM(cgb_i             ,"F"            ,"Intrinsic gate-bulk capacitance") \
`OPM(csd_i             ,"F"            ,"Intrinsic source-drain capacitance") \
`OPM(csg_i             ,"F"            ,"Intrinsic source-gate capacitance") \
`OPM(css_i             ,"F"            ,"Intrinsic source capacitance") \
`OPM(csb_i             ,"F"            ,"Intrinsic source-bulk capacitance") \
`OPM(cbd_i             ,"F"            ,"Intrinsic bulk-drain capacitance") \
`OPM(cbg_i             ,"F"            ,"Intrinsic bulk-gate capacitance") \
`OPM(cbs_i             ,"F"            ,"Intrinsic bulk-source capacitance") \
`OPM(cbb_i             ,"F"            ,"Intrinsic bulk capacitance") \
`OPM(cgsol             ,"F"            ,"Total gate-source overlap capacitance") \
`OPM(cgdol             ,"F"            ,"Total gate-drain overlap capacitance") \
`OPM(cgbol             ,"F"            ,"Total gate-bulk overlap capacitance") \
`OPM(cjs               ,"F"            ,"Total source junction capacitance") \
`OPM(cjd               ,"F"            ,"Total drain junction capacitance") \
`OPD(rgate             ,"Ohm"          ,"Gate resistance") \
`OPD(rdrain            ,"Ohm"          ,"External drain resistance") \
`OPD(rsource           ,"Ohm"          ,"External source resistance") \
`OPD(rbbulk            ,"Ohm"          ,"Bulk resistance") \
`OPD(rjundrain         ,"Ohm"          ,"Drain-side bulk resistance") \
`OPD(rjunsource        ,"Ohm"          ,"Source-side bulk resistance") \
`OPD(rbwell            ,"Ohm"          ,"Well resistance") \
\
/* Noise sources and associated FoM */ \
`OPM(sfl               ,"A^2/Hz"       ,"Flicker noise current spectral density at 1 Hz") \
`OPM(sid               ,"A^2/Hz"       ,"White noise current spectral density") \
`OPM(sig               ,"A^2/Hz"       ,"Induced gate noise current spectral density at 1 Hz") \
`OPP(cigid             ,""             ,"Imaginary part of correlation coefficient between Sig and Sid") \
`OPP(fknee             ,"Hz"           ,"Cross-over frequency above which white noise is dominant") \
`OPM(sigs              ,"A^2/Hz"       ,"Gate-source current noise spectral density") \
`OPM(sigd              ,"A^2/Hz"       ,"Gate-drain current noise spectral density") \
`OPM(sibs              ,"A^2/Hz"       ,"Bulk-source current noise spectral density") \
`OPM(sibd              ,"A^2/Hz"       ,"Impact ionization current noise spectral density") \
`OPM(sijs              ,"A^2/Hz"       ,"Total source junction current noise spectral density") \
`OPM(sijd              ,"A^2/Hz"       ,"Total drain junction current noise spectral density") \
`OPM(sirg              ,"A^2/Hz"       ,"Noise spectral density induced by the gate resistance") \
`OPM(sird              ,"A^2/Hz"       ,"Noise spectral density induced by the external drain resistance") \
`OPM(sirs              ,"A^2/Hz"       ,"Noise spectral density induced by the external source resistance") \
`OPM(sirbulk           ,"A^2/Hz"       ,"Noise spectral density induced by the bulk resistance") \
`OPM(sirjund           ,"A^2/Hz"       ,"Noise spectral density induced by the drain-side bulk resistance") \
`OPM(sirjuns           ,"A^2/Hz"       ,"Noise spectral density induced by the source-side bulk resistance") \
`OPM(sirwell           ,"A^2/Hz"       ,"Noise spectral density induced by the well resistance") \
\
/* Analog FoM */ \
`OPP(vgain             ,""             ,"Transistor gain") \
`OPD(rout              ,"Ohm"          ,"Small-signal output resistance") \
`OPP(vearly            ,"V"            ,"Equivalent Early voltage") \
`OPM(beff              ,"A/V^2"        ,"Gain factor") \
`OPM(gmoverid          ,"S"            ,"Transconductor efficiency") \
`OPP(ft                ,"Hz"           ,"Unity gain frequency at actual bias")

`define OPVarDecl_she \
/* Power dissipation and temperature rise induced by SHE */ \
`OPM(pdiss             ,"W"            ,"Power dissipation") \
`OPP(dtsh              ,"K"            ,"Temperature rise due to self heating")

//  Configuration of variables for operating point info
//  --------------------------------------------------------------------------------------------------------------
`define OPConfig \
if ((SWOPPMOS > 0)&&(CHNL_TYPE == `PMOS)) begin \
    CHNL_OP_TYPE = -1; \
end else begin \
    CHNL_OP_TYPE =  1; \
end

//  Threshold voltages calculation
//  --------------------------------------------------------------------------------------------------------------
`define OPVThvarCalc \
P_D_op      =  1.0 + 0.25 * (Gf * kp); \
facvsb0_op  =  phib + 2.0 * phit; \
temp_op     =  VFB_T + P_D_op * facvsb0_op; \
vtho_op     =  temp_op + Gf * sqrt(phit1 * facvsb0_op); \
Vsbstar_op  =  Vsbstar; \
facvsb_op   =  Vsbstar + facvsb0_op - delPhiB; \
temp_op     =  VFB_T + P_D_op * facvsb_op; \
vth_op      =  temp_op - Vsbstar_op + Gf * sqrt(phit1 * facvsb_op);

//  S/D-interchange of .dc OP output variables
//  --------------------------------------------------------------------------------------------------------------
`define OPVarSDInterFunc(vard,vars) \
temp_op     =  vard; \
vard        =  vars; \
vars        =  temp_op;

//  Operating point info: local variables declaration
//  --------------------------------------------------------------------------------------------------------------
`define OPLocVarDecl \
\
real sdint_op, idsch_op, igcd_op, igcs_op, igisl_op, igidl_op, idsedge_op, iavld_op, iavls_op, igsov_op, igdov_op; \
real ijs_op, ijd_op, igs_op, igd_op, idb_op, isb_op, id_op, ig_op, is_op, ib_op, ids_op, vgs_op, vds_op, vsb_op; \
real vgs_i_op, vds_i_op, vsb_i_op, vgt_op, vdsat_marg_op, gmp_op, gmbp_op, gdsp_op, gmsp_op, gmsbp_op, gsdp_op; \
real gm_ip_op, gmb_ip_op, gds_ip_op, gbsp_op, gbdp_op, gjs_op, gjd_op, fjd, fjs, hjd, hjs, fs, fd, gfact, gm_i_op; \
real gmb_i_op, gds_i_op, gm_op, gmb_op, gds_op, gms_op, gmsb_op, gsd_op, cdd_ip_op, cdg_ip_op, cdb_ip_op, cgd_ip_op; \
real cgg_ip_op, cgb_ip_op, cbd_ip_op, cbg_ip_op, cbb_ip_op, cgsol_p_op, cgdol_p_op, cgbol_op, cjs_p_op, cjd_p_op; \
real cdd_p_op, cdg_p_op, cdb_p_op, cgd_p_op, cgg_p_op, cgb_p_op, cbd_p_op, cbg_p_op, cbb_p_op, cgs_p_op, cbs_p_op; \
real fcx, fcs, fcd, fcg, Ckg, Ckd, Ckb, Cks, cgsol_op, cgdol_op, cjs_op, cjd_op, fdeld, fdelg, fdelb, cdd_i_op; \
real cdg_i_op, cdb_i_op, cgd_i_op, cgg_i_op, cgb_i_op, cbd_i_op, cbg_i_op, cbb_i_op, rdrain_op, rsource_op; \
real rjundrain_op, rjunsource_op, sidp_op, sig1k_op, sigp_op, fknee_op, sigsp_op, sigdp_op, sibsp_op, sibdp_op; \
real siavld_op, siavls_op, sigcsx_op, sigcdx_op, sigsov_op, sigdov_op, sijd_op, sijs_op, fg, fcx2, wnoi, fsigd; \
real fsigs, fsigg, sfl_op, sid_op, sig_op, sigs_op, sigd_op, sibs_op, sibd_op, sirjund_op, sirjuns_op, sird_op; \
real sirs_op, vgain_op, rout_op, vearly_op, gmoverid_op, beff_op, ft_op;

//  Operating point info: standard OP-output variables
//  --------------------------------------------------------------------------------------------------------------
`define OPVarCalc \
\
/* S/D-interchange dependent variables */ \
sdint_op    =  sigVds; \
ids_op      =  I_ds; \
igcd_op     =  I_gcd; \
igcs_op     =  I_gcs; \
igisl_op    =  I_gisl; \
igidl_op    =  I_gidl; \
idsedge_op  =  I_dsedge; \
iavld_op    =  Iimpact; \
iavls_op    =  0.0; \
vgs_i_op    =  V_gs; \
vds_i_op    =  V_ds; \
vsb_i_op    =  V_sb; \
siavld_op   =  shot_iavl; \
siavls_op   =  0.0; \
sigcsx_op   =  shot_igcsx; \
sigcdx_op   =  shot_igcdx; \
idsch_op    =  ids_op + idsedge_op; \
gm_ip_op    =  CHNL_TYPE * ddx(idsch_op, V(gp)); \
gmb_ip_op   =  CHNL_TYPE * ddx(idsch_op, V(bp)); \
\
/* S/D-interchange independent variables */ \
if (sigVds < 0.0) begin \
    igsov_op    =  Igdov; \
    igdov_op    =  Igsov; \
    ijs_op      =  ijun_d; \
    ijd_op      =  ijun_s; \
    igs_op      =  igcs_op + igsov_op; \
    igd_op      =  igcd_op + igdov_op; \
    isb_op      =  iavls_op + igisl_op - ijs_op + gmin * V(di, bp); \
    idb_op      =  iavld_op + igidl_op - ijd_op + gmin * V(si, bp); \
    id_op       =  idsch_op + idb_op - igd_op; \
    is_op       = -(ids_op + idsedge_op + igs_op - isb_op); \
    vgs_op      =  CHNL_TYPE * V(g, d); \
    vds_op      =  CHNL_TYPE * V(s, d); \
    vsb_op      =  CHNL_TYPE * V(d, b); \
    vgt_op      =  vgs_op  - vth_i; \
    vdsat_marg_op = vds_op - Vdsat_dc; \
    gds_ip_op   =  CHNL_TYPE * ddx(idsch_op, V(si)); \
    gdsp_op     =  CHNL_TYPE * ddx(id_op, V(si)); \
    gsdp_op     = -CHNL_TYPE * ddx(is_op, V(si)); \
    gbsp_op     =  CHNL_TYPE * ddx(iavls_op + igisl_op, V(di)) + gmin; \
    gbdp_op     =  CHNL_TYPE * ddx(iavld_op + igidl_op, V(si)) + gmin; \
    gjs_op      = -CHNL_TYPE * ddx(ijs_op, V(di)); \
    gjd_op      = -CHNL_TYPE * ddx(ijd_op, V(si)); \
    cdd_ip_op   =  CHNL_TYPE * ddx(Qs, V(si)); \
    cgd_ip_op   = -CHNL_TYPE * ddx(Qg, V(si)); \
    cbd_ip_op   = -CHNL_TYPE * ddx(Qb, V(si)); \
    cdg_ip_op   = -CHNL_TYPE * ddx(Qs, V(gp)); \
    cdb_ip_op   = -CHNL_TYPE * ddx(Qs, V(bp)); \
    cgsol_p_op  =  CHNL_TYPE * ddx(Qfgd, V(gp)); \
    cgdol_p_op  =  CHNL_TYPE * ddx(Qfgs, V(gp)); \
    cjs_p_op    = -CHNL_TYPE * ddx(qjun_d, V(di)); \
    cjd_p_op    = -CHNL_TYPE * ddx(qjun_s, V(si)); \
    rdrain_op   =  RSE_i; \
    rsource_op  =  RDE_i; \
    rjundrain_op =  RJUNS_i; \
    rjunsource_op =  RJUND_i; \
    sigsov_op   =  shot_igdov; \
    sigdov_op   =  shot_igsov; \
    sijd_op     =  jnoisex_s; \
    sijs_op     =  jnoisex_d; \
    sird_op     =  rsourcenoise; \
    sirs_op     =  rdrainnoise; \
    sirjund_op  =  rjunsnoise; \
    sirjuns_op  =  rjundnoise; \
end else begin \
    igsov_op    =  Igsov; \
    igdov_op    =  Igdov; \
    ijs_op      =  ijun_s; \
    ijd_op      =  ijun_d; \
    igs_op      =  igcs_op + igsov_op; \
    igd_op      =  igcd_op + igdov_op; \
    isb_op      =  iavls_op + igisl_op - ijs_op + gmin * V(si, bp); \
    idb_op      =  iavld_op + igidl_op - ijd_op + gmin * V(di, bp); \
    id_op       =  idsch_op + idb_op - igd_op; \
    is_op       = -(ids_op + idsedge_op + igs_op - isb_op); \
    vgs_op      =  CHNL_TYPE * V(g, s); \
    vds_op      =  CHNL_TYPE * V(d, s); \
    vsb_op      =  CHNL_TYPE * V(s, b); \
    vgt_op      =  vgs_op - vth_i; \
    vdsat_marg_op =  vds_op - Vdsat_dc; \
    gds_ip_op   =  CHNL_TYPE * ddx(idsch_op, V(di)); \
    gdsp_op     =  CHNL_TYPE * ddx(id_op, V(di)); \
    gsdp_op     = -CHNL_TYPE * ddx(is_op, V(di)); \
    gbsp_op     =  CHNL_TYPE * ddx(iavls_op + igisl_op, V(si)) + gmin; \
    gbdp_op     =  CHNL_TYPE * ddx(iavld_op + igidl_op, V(di)) + gmin; \
    gjs_op      = -CHNL_TYPE * ddx(ijs_op, V(si)); \
    gjd_op      = -CHNL_TYPE * ddx(ijd_op, V(di)); \
    cdd_ip_op   =  CHNL_TYPE * ddx(Qd, V(di)); \
    cgd_ip_op   = -CHNL_TYPE * ddx(Qg, V(di)); \
    cbd_ip_op   = -CHNL_TYPE * ddx(Qb, V(di)); \
    cdg_ip_op   = -CHNL_TYPE * ddx(Qd, V(gp)); \
    cdb_ip_op   = -CHNL_TYPE * ddx(Qd, V(bp)); \
    cgsol_p_op  =  CHNL_TYPE * ddx(Qfgs, V(gp)); \
    cgdol_p_op  =  CHNL_TYPE * ddx(Qfgd, V(gp)); \
    cjs_p_op    = -CHNL_TYPE * ddx(qjun_s, V(si)); \
    cjd_p_op    = -CHNL_TYPE * ddx(qjun_d, V(di)); \
    rdrain_op   =  RDE_i; \
    rsource_op  =  RSE_i; \
    rjundrain_op =  RJUND_i; \
    rjunsource_op =  RJUNS_i; \
    sigsov_op   =  shot_igsov; \
    sigdov_op   =  shot_igdov; \
    sijd_op     =  jnoisex_d; \
    sijs_op     =  jnoisex_s; \
    sird_op     =  rdrainnoise; \
    sirs_op     =  rsourcenoise; \
    sirjund_op  =  rjundnoise; \
    sirjuns_op  =  rjunsnoise; \
end \
gmp_op      =  CHNL_TYPE * ddx(id_op, V(gp)); \
gmbp_op     =  CHNL_TYPE * ddx(id_op, V(bp)); \
gmsp_op     = -CHNL_TYPE * ddx(is_op, V(gp)); \
gmsbp_op    = -CHNL_TYPE * ddx(is_op, V(bp)); \
\
ig_op       =  igs_op + igd_op + I_gb; \
ib_op       = -(I_gb + idb_op + isb_op); \
cgg_ip_op   =  CHNL_TYPE * ddx(Qg, V(gp)); \
cgb_ip_op   = -CHNL_TYPE * ddx(Qg, V(bp)); \
cbg_ip_op   = -CHNL_TYPE * ddx(Qb, V(gp)); \
cbb_ip_op   =  CHNL_TYPE * ddx(Qb, V(bp)); \
cgbol_op    =  CHNL_TYPE * ddx(Qgb_ov, V(gp)); \
sidp_op     =  sqid * sqid; \
temp_op     =  2.0e03 * `PI * CGeff; \
sig1k_op    =  temp_op * temp_op * mig; \
sigp_op     =  nt * sig1k_op / (1.0 + sig1k_op * mig); \
if (sidp_op <= 0.0) begin \
    fknee_op    =  0.0; \
end else begin \
    fknee_op    =  S_fl / sidp_op; \
end \
sigsp_op    =  sigcsx_op + sigsov_op; \
sigdp_op    =  sigcdx_op + sigdov_op; \
sibsp_op    =  sijs_op + siavls_op; \
sibdp_op    =  sijd_op + siavld_op;

`define OPVarCalcRacc \
/* Access resistance dependent variables */ \
if (SWOPREXT > 0.0) begin \
    fjd         =  rdrain_op * (gbdp_op + gjd_op); \
    fjs         =  rsource_op * (gbsp_op + gjs_op); \
    hjd         =  1.0 + fjd; \
    hjs         =  1.0 + fjs; \
    fs          =  rsource_op * (gm_ip_op + gmb_ip_op + gds_ip_op); \
    fd          =  rdrain_op * gds_ip_op; \
    gfact       =  1.0 / (hjs * hjd + fs * hjd + fd * hjs); \
    gm_i_op     =  gfact * hjs * gm_ip_op; \
    gmb_i_op    =  gfact * (gmb_ip_op - fjs * gm_ip_op); \
    gds_i_op    =  gfact * gds_ip_op; \
    gm_op       =  gfact * hjs * gmp_op; \
    gmb_op      =  gfact * (gmbp_op - fjs * gmp_op); \
    gds_op      =  gfact * gdsp_op; \
    gms_op      =  gfact * hjd * gmsp_op; \
    gmsb_op     =  gfact * (gmsbp_op - fjd * gmsp_op); \
    gsd_op      =  gfact * gsdp_op; \
    fcx         =  1.0 / (1.0 + fs + fd); \
    fcs         =  fs * fcx; \
    fcd         =  fd * fcx; \
    cgdol_op    =  cgdol_p_op * (1.0 - fcd); \
    cgsol_op    =  cgsol_p_op * (1.0 - fcs); \
    cjd_op      =  cjd_p_op * (1.0 - fcd); \
    cjs_op      =  cjs_p_op * (1.0 - fcs); \
    cdd_p_op    =  cdd_ip_op + cgdol_p_op + cjd_p_op; \
    cdg_p_op    =  cdg_ip_op + cgdol_p_op; \
    cdb_p_op    =  cdb_ip_op + cjd_p_op; \
    cgd_p_op    =  cgd_ip_op + cgdol_p_op; \
    cgg_p_op    =  cgg_ip_op + cgsol_p_op + cgdol_p_op + cgbol_op; \
    cgb_p_op    =  cgb_ip_op + cgbol_op; \
    cbd_p_op    =  cbd_ip_op + cjd_p_op; \
    cbg_p_op    =  cbg_ip_op + cgbol_op; \
    cbb_p_op    =  cbb_ip_op + cgbol_op + cjs_p_op + cjd_p_op; \
    cgs_p_op    =  cgg_p_op - cgd_p_op - cgb_p_op; \
    cbs_p_op    =  cbb_p_op - cbd_p_op - cbg_p_op; \
    fcg         =  fcs + gm_ip_op * RG_i * fcx; \
    Ckg         =  cdg_p_op * fcx - cbg_p_op * fcs + cgg_p_op * fcg; \
    Ckd         =  cdd_p_op * fcx + cbd_p_op * fcs + cgd_p_op * fcg; \
    Ckb         =  cdb_p_op * fcx + cbb_p_op * fcs - cgb_p_op * fcg; \
    Cks         =  Ckg - Ckd + Ckb; \
    fdeld       =  (Ckd * rdrain_op - Cks * rsource_op) * fcx; \
    fdelg       =  (cgd_p_op * rdrain_op - cgs_p_op * rsource_op) * fcx; \
    fdelb       =  (cbd_p_op * rdrain_op - cbs_p_op * rsource_op) * fcx; \
    cdd_i_op    =  Ckd - gds_ip_op * fdeld - cgdol_op - cjd_op; \
    cdg_i_op    =  Ckg + gm_ip_op * fdeld - cgdol_op; \
    cdb_i_op    =  Ckb + gmb_ip_op * fdeld - cjd_op; \
    cgd_i_op    =  cgd_p_op - gds_ip_op * fdelg - cgdol_op; \
    cgg_i_op    =  cgg_p_op + gm_ip_op * fdelg - cgsol_op - cgdol_op - cgbol_op; \
    cgb_i_op    =  cgb_p_op - gmb_ip_op * fdelg - cgbol_op; \
    cbd_i_op    =  cbd_p_op - gds_ip_op * fdelb - cjd_op; \
    cbg_i_op    =  cbg_p_op - gm_ip_op * fdelb - cgbol_op; \
    cbb_i_op    =  cbb_p_op + gmb_ip_op * fdelb - cgbol_op - cjs_op - cjd_op; \
    fg          =  RG_i * gm_ip_op; \
    fcx2        =  fcx * fcx; \
    wnoi        =  2.0e03 * `PI; \
    fsigd       =  cgd_p_op * rdrain_op * wnoi; \
    fsigs       =  cgs_p_op * rsource_op * wnoi; \
    fsigg       =  cgg_p_op * RG_i * wnoi; \
    sfl_op      =  fcx2 * S_fl; \
    sid_op      =  fcx2 * (sidp_op + fs * fs * sirs_op + fd * fd * sird_op + fg * fg * rgatenoise); \
    sig_op      =  fsigd * fsigd * sird_op + fsigs * fsigs * sirs_op + fsigg * fsigg * rgatenoise + sigp_op; \
    sigs_op     =  fcx2 * sigsp_op; \
    sigd_op     =  fcx2 * sigdp_op; \
    sibs_op     =  fcx2 * sibsp_op; \
    sibd_op     =  fcx2 * sibdp_op; \
end else begin \
    gm_i_op     =  gm_ip_op; \
    gmb_i_op    =  gmb_ip_op; \
    gds_i_op    =  gds_ip_op; \
    gm_op       =  gmp_op; \
    gmb_op      =  gmbp_op; \
    gds_op      =  gdsp_op; \
    gms_op      =  gmsp_op; \
    gmsb_op     =  gmsbp_op; \
    gsd_op      =  gsdp_op; \
    cgdol_op    =  cgdol_p_op; \
    cgsol_op    =  cgsol_p_op; \
    cjd_op      =  cjd_p_op; \
    cjs_op      =  cjs_p_op; \
    cdd_i_op    =  cdd_ip_op; \
    cdg_i_op    =  cdg_ip_op; \
    cdb_i_op    =  cdb_ip_op; \
    cgd_i_op    =  cgd_ip_op; \
    cgg_i_op    =  cgg_ip_op; \
    cgb_i_op    =  cgb_ip_op; \
    cbd_i_op    =  cbd_ip_op; \
    cbg_i_op    =  cbg_ip_op; \
    cbb_i_op    =  cbb_ip_op; \
    sfl_op      =  S_fl; \
    sid_op      =  sidp_op; \
    sig_op      =  sigp_op; \
    sigs_op     =  sigsp_op; \
    sigd_op     =  sigdp_op; \
    sibs_op     =  sibsp_op; \
    sibd_op     =  sibdp_op; \
end

`define OPVarCalcAnalog \
/* Analog FoM */ \
if (abs(gds_i_op) < 1.0e-18) begin \
    vgain_op    =  0.0; \
    rout_op     =  0.0; \
    vearly_op   =  0.0; \
end else begin \
    vgain_op    =  gm_i_op / gds_i_op; \
    rout_op     =  1.0 / gds_i_op; \
    vearly_op   =  ids_op / gds_i_op; \
end \
if (ids_op < 1.0e-18) begin \
    gmoverid_op =  0.0; \
end else begin \
    gmoverid_op =  gm_i_op / ids_op; \
end \
if (abs(vgt_op) < 1.0e-12) begin \
    beff_op     =  0.0; \
end else begin \
    beff_op     =  2.0 * ids_op / (vgt_op * vgt_op); \
end \
temp_op     =  cgg_i_op + cgsol_op + cgdol_op + cgbol_op; \
if (abs(temp_op) < 1.0e-30) begin \
    ft_op       =  0.0; \
end else begin \
    ft_op       =  gm_i_op / (2.0 * `PI * temp_op); \
end

`define OPVarSDInter \
/* S/D Interchange management for SWOPDRAIN=1 */ \
if ((sigVds < 0.0) && (SWOPDRAIN > 0)) begin \
    sdint_op    =  1.0; \
    `OPVarSDInterFunc(id_op, is_op) \
    idsch_op    = -idsch_op; \
    ids_op      = -ids_op; \
    `OPVarSDInterFunc(igd_op, igs_op) \
    `OPVarSDInterFunc(idb_op, isb_op) \
    `OPVarSDInterFunc(igcd_op, igcs_op) \
    `OPVarSDInterFunc(igidl_op, igisl_op) \
    `OPVarSDInterFunc(ijd_op, ijs_op) \
    idsedge_op  = -idsedge_op; \
    vgs_op      =  vgs_op - vds_op; \
    vsb_op      =  vds_op + vsb_op; \
    vds_op      = -vds_op; \
    vgs_i_op    =  vgs_i_op - vds_i_op; \
    vsb_i_op    =  vds_i_op + vsb_i_op; \
    vds_i_op    = -vds_i_op; \
    gm_op       =  gms_op; \
    gmb_op      =  gmsb_op; \
    gds_op      =  gsd_op; \
    `OPVarSDInterFunc(gjd_op, gjs_op) \
    cgd_i_op    =  cgg_i_op - cgb_i_op - cgd_i_op; \
    cbd_i_op    =  cbb_i_op - cbg_i_op - cbd_i_op; \
    cdd_i_op    =  cdd_i_op - cdg_i_op - cdb_i_op + cgd_i_op + cbd_i_op; \
    cdg_i_op    =  cgg_i_op - cdg_i_op - cbg_i_op; \
    cdb_i_op    =  cbb_i_op - cgb_i_op - cdb_i_op; \
    `OPVarSDInterFunc(cgdol_op, cgsol_op) \
    `OPVarSDInterFunc(cjd_op, cjs_op) \
    `OPVarSDInterFunc(rdrain_op, rsource_op) \
    `OPVarSDInterFunc(rjundrain_op, rjunsource_op) \
    `OPVarSDInterFunc(sigd_op, sigs_op) \
    `OPVarSDInterFunc(sibd_op, sibs_op) \
    `OPVarSDInterFunc(sijd_op, sijs_op) \
    `OPVarSDInterFunc(sird_op, sirs_op) \
    `OPVarSDInterFunc(sirjund_op, sirjuns_op) \
end

`define OPVarDef \
\
/* Device geometry and temperature */ \
weff        =  WE; \
leff        =  LE; \
tk          =  TKD; \
\
/* Bias convention */ \
sdint       =  sdint_op; \
ctype       =  CHNL_TYPE; \
\
/* Currents and voltages */ \
id          =  CHNL_OP_TYPE * MULT_inst * MULT_I  * id_op; \
ig          =  CHNL_OP_TYPE * MULT_inst * MULT_I  * ig_op; \
is          =  CHNL_OP_TYPE * MULT_inst * MULT_I  * is_op; \
ib          =  CHNL_OP_TYPE * MULT_inst * MULT_I  * ib_op; \
idsch       =  CHNL_OP_TYPE * MULT_inst * MULT_I  * idsch_op; \
ids         =  CHNL_OP_TYPE * MULT_inst * MULT_I  * ids_op; \
igs         =  CHNL_OP_TYPE * MULT_inst * MULT_I  * igs_op; \
igd         =  CHNL_OP_TYPE * MULT_inst * MULT_I  * igd_op; \
igb         =  CHNL_OP_TYPE * MULT_inst * MULT_I  * I_gb; \
idb         =  CHNL_OP_TYPE * MULT_inst * MULT_I  * idb_op; \
isb         =  CHNL_OP_TYPE * MULT_inst * MULT_I  * isb_op; \
igcs        =  CHNL_OP_TYPE * MULT_inst * MULT_I  * igcs_op; \
igcd        =  CHNL_OP_TYPE * MULT_inst * MULT_I  * igcd_op; \
iavl        =  CHNL_OP_TYPE * MULT_inst * MULT_I  * Iimpact; \
igisl       =  CHNL_OP_TYPE * MULT_inst * MULT_I  * igisl_op; \
igidl       =  CHNL_OP_TYPE * MULT_inst * MULT_I  * igidl_op; \
ijs         =  CHNL_OP_TYPE * MULT_inst * MULT_I  * ijs_op; \
ijd         =  CHNL_OP_TYPE * MULT_inst * MULT_I  * ijd_op; \
idsedge     =  CHNL_OP_TYPE * MULT_inst * MULT_I  * idsedge_op; \
vgs         =  CHNL_OP_TYPE * vgs_op; \
vgd         =  CHNL_OP_TYPE * (vgs_op - vds_op); \
vds         =  CHNL_OP_TYPE * vds_op; \
vsb         =  CHNL_OP_TYPE * vsb_op; \
vdb         =  CHNL_OP_TYPE * (vds_op + vsb_op); \
vgs_i       =  CHNL_OP_TYPE * vgs_i_op; \
vgd_i       =  CHNL_OP_TYPE * (vgs_i_op - vds_i_op); \
vds_i       =  CHNL_OP_TYPE * vds_i_op; \
vsb_i       =  CHNL_OP_TYPE * vsb_i_op; \
vdb_i       =  CHNL_OP_TYPE * (vds_i_op + vsb_i_op); \
vtho        =  CHNL_OP_TYPE * vtho_i; \
vth         =  CHNL_OP_TYPE * vth_i; \
vthac       =  CHNL_OP_TYPE * vthac_i; \
vgt         =  CHNL_OP_TYPE * vgt_op; \
vdsat       =  CHNL_OP_TYPE * Vdsat_dc; \
vdsat_marg  =  CHNL_OP_TYPE * vdsat_marg_op; \
\
/* Small-signal equivalent circuit */ \
gm_i        =  MULT_inst * MULT_I  * gm_i_op; \
gmb_i       =  MULT_inst * MULT_I  * gmb_i_op; \
gds_i       =  MULT_inst * MULT_I  * gds_i_op; \
gm          =  MULT_inst * MULT_I  * gm_op; \
gmb         =  MULT_inst * MULT_I  * gmb_op; \
gds         =  MULT_inst * MULT_I  * gds_op; \
gjs         =  MULT_inst * MULT_I  * gjs_op; \
gjd         =  MULT_inst * MULT_I  * gjd_op; \
cdd_i       =  MULT_inst * MULT_Q * cdd_i_op; \
cdg_i       =  MULT_inst * MULT_Q * cdg_i_op; \
cdb_i       =  MULT_inst * MULT_Q * cdb_i_op; \
cds_i       =  cdd_i - cdg_i - cdb_i; \
cgg_i       =  MULT_inst * MULT_Q * cgg_i_op; \
cgd_i       =  MULT_inst * MULT_Q * cgd_i_op; \
cgb_i       =  MULT_inst * MULT_Q * cgb_i_op; \
cgs_i       =  cgg_i - cgd_i - cgb_i; \
cbb_i       =  MULT_inst * MULT_Q * cbb_i_op; \
cbd_i       =  MULT_inst * MULT_Q * cbd_i_op; \
cbg_i       =  MULT_inst * MULT_Q * cbg_i_op; \
cbs_i       =  cbb_i - cbd_i - cbg_i; \
css_i       =  cds_i + cgs_i + cbs_i; \
csd_i       =  cdd_i - cgd_i - cbd_i; \
csg_i       =  cgg_i - cdg_i - cbg_i; \
csb_i       =  cbb_i - cdb_i - cgb_i; \
cgsol       =  MULT_inst * MULT_Q * cgsol_op; \
cgdol       =  MULT_inst * MULT_Q * cgdol_op; \
cgbol       =  MULT_inst * MULT_Q * cgbol_op; \
cjs         =  MULT_inst * MULT_Q * cjs_op; \
cjd         =  MULT_inst * MULT_Q * cjd_op; \
rgate       =  RG_i; \
rdrain      =  rdrain_op; \
rsource     =  rsource_op; \
rbbulk      =  RBULK_i; \
rjundrain   =  rjundrain_op; \
rjunsource  =  rjunsource_op; \
rbwell      =  RWELL_i; \
\
/* Noise sources and associated FoM */ \
sfl         =  MULT_inst * MULT_FN * sfl_op; \
sid         =  MULT_inst * MULT_I  * sid_op; \
sig         =  MULT_inst * MULT_I  * sig_op; \
cigid       =  c_igid; \
fknee       =  fknee_op; \
sigs        =  MULT_inst * MULT_I  * sigs_op; \
sigd        =  MULT_inst * MULT_I  * sigd_op; \
sibs        =  MULT_inst * MULT_I  * sibs_op; \
sibd        =  MULT_inst * MULT_I  * sibd_op; \
sijs        =  MULT_inst * MULT_I  * sijs_op; \
sijd        =  MULT_inst * MULT_I  * sijd_op; \
sirg        =  rgatenoise; \
sird        =  sird_op; \
sirs        =  sirs_op; \
sirbulk     =  rbulknoise; \
sirjund     =  sirjund_op; \
sirjuns     =  sirjuns_op; \
sirwell     =  rwellnoise; \
\
/* Analog FoM */ \
vgain       =  vgain_op; \
rout        =  rout_op; \
vearly      =  vearly_op; \
beff        =  beff_op; \
gmoverid    =  gmoverid_op; \
ft          =  ft_op;

//  Operating point info: Local parameters output for PSP-model including self-heating effect
`define OPVarDef_she \
pdiss       =  MULT_inst * MULT_I  * Pdiss; \
dtsh        =  TKD - TKA;
// ---- end `include "PSP104_opvar.include" ----

/////////////////////////////////////////////////////////////////////////////
//
//  PSP global model code
//
/////////////////////////////////////////////////////////////////////////////

// ---- begin `include "PSP104_nqs_macrodefs.include" ----
//======================================================================================
//======================================================================================
// Filename: PSP104_nqs_macrodefs.include
//======================================================================================
//======================================================================================
//
//  (c) Copyright notice
//
//  Since 2015 until today, PSP has been co-developed by NXP Semiconductors and
//  CEA-Leti. For this part of the model, each claim undivided ownership and copyrights
//  Since 2012 until 2015, PSP has been co-developed by NXP Semiconductors and
//  Delft University of Technology. For this part of the model, each claim undivided
//  ownership and copyrights
//  Until and including 2011, PSP has been co-developed by NXP Semiconductors and
//  Arizona State University. For this part of the model, NXP Semiconductors claims
//  undivided ownership and copyrights.
//
//
//  Version: 104.1.0 (PSP), 200.7.0 (JUNCAP), March 2026
//
//======================================================================================
//======================================================================================
//
// Further information can be found in the file releasenotesPSP104.txt
//

//////////////////////////////////////////
//
// Macros used in PSP-NQS
//
//////////////////////////////////////////

// Function to calculate bulk charge from surface potential
`define PhiToQb(phi,Qb_tmp) \
    if (abs(phi) <= margin_ac) \
        Qb_tmp      = -0.70710678 * phi * Gf_ac * (1.0 - `oneSixth * phi * (1.0 - `oneSixth * phi)); \
    else begin \
        `expl((-phi), temp) \
        Qb_tmp      =  Gf_ac * sqrt(temp + phi - 1.0); \
        if (phi > margin_ac) \
            Qb_tmp      = -Qb_tmp; \
    end

// Function used in fq-macro
`define PhiTod2Qis(xphi,d2Qis) \
    if (abs(xphi) <= margin_ac) begin \
        Qb_tmp      = -0.70710678 * xphi * Gf_ac * (1.0 - `oneSixth * xphi * (1.0 - `oneSixth * xphi)); \
        dQbs        = -0.70710678 * Gf_ac * (1.0 - `oneThird * xphi * (1.0 - 0.25 * xphi)); \
        d2Qis       = -0.235702 * Gf_ac * (1.0 - 0.5 * xphi); \
    end else begin \
        `expl((-xphi),temp) \
        Qb_tmp      =  Gf_ac * sqrt(temp + xphi - 1.0); \
        if (xphi > margin_ac) \
            Qb_tmp     = -Qb_tmp; \
        dQbs        =  0.5 * Gf_ac * Gf_ac * (1.0 - temp) / Qb_tmp; \
        d2Qis       =  (dQbs * dQbs - 0.5 * Gf_ac * Gf_ac) / Qb_tmp + dQbs; \
    end

// Function used in QiToPhi
`define sps(sp, xg) \
    if (abs(xg) <= marginp) begin \
        sp          =  (xg) / a_factrp; \
    end else begin \
        if ((xg) < -marginp) begin \
            NQS_yg      = -(xg); \
            NQS_z       =  1.25 * NQS_yg / a_factrp; \
            NQS_eta     =  (NQS_z + 10.0 - sqrt((NQS_z - 6.0) * (NQS_z - 6.0) + 64.0)) * 0.5; \
            NQS_a       =  (NQS_yg - NQS_eta) * (NQS_yg - NQS_eta) + Gp2 * (NQS_eta + 1.0); \
            NQS_c       =  2.0 * (NQS_yg - NQS_eta) - Gp2; \
            NQS_tau     =  ln(NQS_a / Gp2) - NQS_eta; \
            `sigma(NQS_a, NQS_c, NQS_tau, NQS_eta, NQS_y0) \
            `expl(NQS_y0, NQS_D0) \
            NQS_xi      =  1.0 - Gp2 * NQS_D0 * 0.5;  \
            NQS_p       =  2.0 * (NQS_yg - NQS_y0) + Gp2 * (NQS_D0 - 1.0); \
            NQS_q       =  (NQS_yg - NQS_y0) * (NQS_yg - NQS_y0) + Gp2 * (NQS_y0 + 1.0 - NQS_D0); \
            NQS_temp    =  NQS_p * NQS_p - 4.0 * NQS_xi * NQS_q; \
            NQS_w       =  2.0 * NQS_q / (NQS_p + sqrt(NQS_temp)); \
            sp          = -(NQS_y0 + NQS_w); \
        end else begin \
            NQS_xg1     =  1.0 / ( 1.25 + 7.32464877560822e-01 * Gp); \
            NQS_A_fac   =  (1.25 * a_factrp * NQS_xg1 - 1.0) * NQS_xg1; \
            NQS_xbar    =  (xg) / a_factrp * (1.0 + NQS_A_fac * (xg)); \
            `expl(-NQS_xbar, NQS_temp)   \
            NQS_w       =  1.0 - NQS_temp; \
            NQS_x0      =  (xg) + Gp2 * 0.5 - Gp * sqrt((xg) + Gp2 * 0.25 - NQS_w); \
            `expl((-NQS_x0), NQS_D0) \
            NQS_xi      =  1.0 - Gp2 * 0.5 * NQS_D0; \
            NQS_p       =  2.0 * ((xg) - NQS_x0) + Gp2 * (1.0 - NQS_D0); \
            NQS_q       =  ((xg) - NQS_x0) * ((xg) - NQS_x0) - Gp2 * (NQS_x0 - 1.0 + NQS_D0); \
            NQS_temp    =  NQS_p * NQS_p - 4.0 * NQS_xi * NQS_q; \
            NQS_u       =  2.0 * NQS_q / (NQS_p + sqrt(NQS_temp)); \
            sp          =  NQS_x0 + NQS_u; \
        end \
    end

// Function to calculate surface potential from inversion charge
`define QiToPhi(Qi,xg,xphi) \
    temp        =  (Qi) / pd + (xg); \
    `sps(xphi,temp)

// Calculation of fk
`define fq(Qi,xg,dQy,d2Qy,fk) \
    `QiToPhi((Qi), (xg), xphi) \
    `PhiTod2Qis(xphi, d2Qis) \
    dQis        =  pd - dQbs; \
    dQis_1      =  1.0 / dQis; \
    fQi         =  (Qi) * dQis_1 - 1.0; \
    dfQi        =  (1.0 - (Qi) * d2Qis * dQis_1 * dQis_1) * dQis_1; \
    fk0         =  dfQi * (dQy) * (dQy) + fQi * (d2Qy); \
    dpsy2       =  (dQy) * (dQy) * dQis_1 * dQis_1; \
    zsat_nqs    =  thesat2 * dpsy2; \
    if (CHNL_TYPE == `PMOS) \
        zsat_nqs    =  zsat_nqs / (1.0 + thesat1_ac * dps_ac); \
    temp        =  sqrt(1.0 + 2.0 * zsat_nqs); \
    Fvsat       =  2.0 / (1.0 + temp); \
    temp1       =  (d2Qy) - dpsy2 * d2Qis; \
    fk          =  Fvsat * (fk0 - zsat_nqs * fQi * temp1 * Fvsat / temp);

// Interpolation of surface potential along channel
`define Phiy(y) \
    x_m_ac + H_ac * (1.0 - sqrt(1.0 - 2.0 * dps_ac / H_ac * ((y) - ym))) * inv_phit1_ac

//  Computing initial (dc) values for internal nodes (from PSP104_InitNQS.include in previous versions)
`define InitNQS \
    \
    Qp1_0       =  0.0; \
    Qp2_0       =  0.0; \
    Qp3_0       =  0.0; \
    Qp4_0       =  0.0; \
    Qp5_0       =  0.0; \
    Qp6_0       =  0.0; \
    Qp7_0       =  0.0; \
    Qp8_0       =  0.0; \
    Qp9_0       =  0.0; \
    fk1         =  0.0; \
    fk2         =  0.0; \
    fk3         =  0.0; \
    fk4         =  0.0; \
    fk5         =  0.0; \
    fk6         =  0.0; \
    fk7         =  0.0; \
    fk8         =  0.0; \
    fk9         =  0.0; \
    if (SWNQS_i != 0) begin \
        dQis        =  0.0; \
        dQy         =  0.0; \
        dfQi        =  0.0; \
        fQi         =  0.0; \
        d2Qy        =  0.0; \
        Qp1         =  0.0; \
        Qp2         =  0.0; \
        Qp3         =  0.0; \
        Qp4         =  0.0; \
        Qp5         =  0.0; \
        Qp6         =  0.0; \
        Qp7         =  0.0; \
        Qp8         =  0.0; \
        Qp9         =  0.0; \
        phi_p1      =  0.0; \
        phi_p2      =  0.0; \
        phi_p3      =  0.0; \
        phi_p4      =  0.0; \
        phi_p5      =  0.0; \
        phi_p6      =  0.0; \
        phi_p7      =  0.0; \
        phi_p8      =  0.0; \
        phi_p9      =  0.0; \
        \
        /*  Setting initial values for charge along the channel from interpolated DC-solution */ \
        if (xg_ac > 0.0) begin \
            if (SWNQS_i == 1) begin \
                phi_p1      = `Phiy(0.5); \
                `PhiToQb(phi_p1,Qb_tmp) \
                Qp1_0       = -pd * (xg_ac - phi_p1) - Qb_tmp; \
                \
            end else if (SWNQS_i == 2) begin \
                phi_p1      = `Phiy(`oneThird); \
                `PhiToQb(phi_p1,Qb_tmp) \
                Qp1_0       = -pd * (xg_ac - phi_p1) - Qb_tmp; \
                \
                phi_p2      = `Phiy(`twoThirds); \
                `PhiToQb(phi_p2,Qb_tmp) \
                Qp2_0       = -pd * (xg_ac - phi_p2) - Qb_tmp; \
                \
                if (sigVds < 0) begin \
                    `swap(Qp1_0, Qp2_0) \
                end \
                \
            end else if (SWNQS_i == 3) begin \
                phi_p1      = `Phiy(0.25); \
                `PhiToQb(phi_p1,Qb_tmp) \
                Qp1_0       = -pd * (xg_ac - phi_p1) - Qb_tmp; \
                \
                phi_p2      = `Phiy(0.5); \
                `PhiToQb(phi_p2,Qb_tmp) \
                Qp2_0       = -pd * (xg_ac - phi_p2) - Qb_tmp; \
                \
                phi_p3      = `Phiy(0.75); \
                `PhiToQb(phi_p3,Qb_tmp) \
                Qp3_0       = -pd * (xg_ac - phi_p3) - Qb_tmp; \
                \
                if (sigVds < 0.0) begin \
                    `swap(Qp1_0, Qp3_0) \
                end \
                \
            end else if (SWNQS_i == 5) begin \
                phi_p1      = `Phiy(`oneSixth); \
                `PhiToQb(phi_p1,Qb_tmp) \
                Qp1_0       = -pd * (xg_ac - phi_p1) - Qb_tmp; \
                \
                phi_p2      = `Phiy(`oneThird); \
                `PhiToQb(phi_p2,Qb_tmp) \
                Qp2_0       = -pd * (xg_ac - phi_p2) - Qb_tmp; \
                \
                phi_p3      = `Phiy(0.5); \
                `PhiToQb(phi_p3,Qb_tmp) \
                Qp3_0       = -pd * (xg_ac - phi_p3) - Qb_tmp; \
                \
                phi_p4      = `Phiy(`twoThirds); \
                `PhiToQb(phi_p4,Qb_tmp) \
                Qp4_0       = -pd * (xg_ac - phi_p4) - Qb_tmp; \
                \
                phi_p5      = `Phiy(0.8333333333333333); \
                `PhiToQb(phi_p5,Qb_tmp) \
                Qp5_0       = -pd * (xg_ac - phi_p5) - Qb_tmp; \
                \
                if (sigVds < 0.0) begin \
                    `swap(Qp1_0, Qp5_0) \
                    `swap(Qp2_0, Qp4_0) \
                end \
                \
            end else if (SWNQS_i == 9) begin \
                phi_p1      = `Phiy(0.1); \
                `PhiToQb(phi_p1,Qb_tmp) \
                Qp1_0       = -pd * (xg_ac - phi_p1) - Qb_tmp; \
                \
                phi_p2      = `Phiy(0.2); \
                `PhiToQb(phi_p2,Qb_tmp) \
                Qp2_0       = -pd * (xg_ac - phi_p2) - Qb_tmp; \
                \
                phi_p3      = `Phiy(0.3); \
                `PhiToQb(phi_p3,Qb_tmp) \
                Qp3_0       = -pd * (xg_ac - phi_p3) - Qb_tmp; \
                \
                phi_p4      = `Phiy(0.4); \
                `PhiToQb(phi_p4,Qb_tmp) \
                Qp4_0       = -pd * (xg_ac - phi_p4) - Qb_tmp; \
                \
                phi_p5      = `Phiy(0.5); \
                `PhiToQb(phi_p5,Qb_tmp) \
                Qp5_0       = -pd * (xg_ac - phi_p5) - Qb_tmp; \
                \
                phi_p6      = `Phiy(0.6); \
                `PhiToQb(phi_p6,Qb_tmp) \
                Qp6_0       = -pd * (xg_ac - phi_p6) - Qb_tmp; \
                \
                phi_p7      = `Phiy(0.7); \
                `PhiToQb(phi_p7,Qb_tmp) \
                Qp7_0       = -pd * (xg_ac - phi_p7) - Qb_tmp; \
                \
                phi_p8      = `Phiy(0.8); \
                `PhiToQb(phi_p8,Qb_tmp) \
                Qp8_0       = -pd * (xg_ac - phi_p8) - Qb_tmp; \
                \
                phi_p9      = `Phiy(0.9); \
                `PhiToQb(phi_p9,Qb_tmp) \
                Qp9_0       = -pd * (xg_ac - phi_p9) - Qb_tmp; \
                \
                if (sigVds < 0.0) begin \
                    `swap(Qp1_0, Qp9_0) \
                    `swap(Qp2_0, Qp8_0) \
                    `swap(Qp3_0, Qp7_0) \
                    `swap(Qp4_0, Qp6_0) \
                end \
            end \
        end /* (x_g >0.0) */ \
    end /* (SWNQS_i != 0) */ \
    \
    x_sp        =  0.0; \
    x_dp        =  0.0; \
    Qp0         =  0.0; \
    QpN         =  0.0; \
    if (SWNQS_i != 0) begin \
        x_sp        =  x_m_ac - sigVds * 0.5 * dps_ac * inv_phit1_ac; \
        x_dp        =  x_m_ac + sigVds * 0.5 * dps_ac * inv_phit1_ac; \
        Qp0         =  0.0; \
        QpN         =  0.0; \
        if (x_sp > 0.0) begin \
            `PhiToQb(x_sp, QbSIGN) \
            Qp0         =  -pd * (xg_ac - x_sp) - QbSIGN; \
        end \
        if (x_dp > 0.0) begin \
            `PhiToQb(x_dp, QbSIGN) \
            QpN         =  -pd * (xg_ac - x_dp) - QbSIGN; \
        end \
    end

//  Calculate NQS-charge contributions (from PSP104_ChargesNQS.include in previous versions)
`define CalcChargesNQS \
    \
    Qp1          =  vnorm * V(SPLINE1); \
    Qp2          =  vnorm * V(SPLINE2); \
    Qp3          =  vnorm * V(SPLINE3); \
    Qp4          =  vnorm * V(SPLINE4); \
    Qp5          =  vnorm * V(SPLINE5); \
    Qp6          =  vnorm * V(SPLINE6); \
    Qp7          =  vnorm * V(SPLINE7); \
    Qp8          =  vnorm * V(SPLINE8); \
    Qp9          =  vnorm * V(SPLINE9); \
    \
    Tnorm        =  0.0; \
    \
    if (SWNQS_i != 0) begin \
        /* Dimension and mobility information is included in Tnorm */ \
        Tnorm        =  MUNQS_i * phit1_ac * BET_i / (COX_qm * Gmob_dL_ac); \
        thesat2      =  thesat1_ac * thesat1_ac * phit1_ac * phit1_ac; \
        \
        if (SWNQS_i == 1) begin \
            dQy          =  QpN - Qp0; \
            d2Qy         =  6.0 * (Qp0 + QpN) - 12.0 * Qp1; \
        end else if (SWNQS_i == 2) begin \
            dQy          =  (-7.0 * Qp0 - 3.0 * Qp1 + 12.0 * Qp2 - 2.0 * QpN) / 5.0; \
            d2Qy         = -18.0 / 5.0 * (-4.0 * Qp0 + 9.0 * Qp1 - 6.0 * Qp2 + QpN); \
        end else if (SWNQS_i == 3) begin \
            dQy          =  (-13.0 * Qp0 - 6.0 * Qp1 + 24.0 * Qp2 - 6.0 * Qp3 + QpN) / 7.0; \
            d2Qy         =  (180.0 * Qp0 - 408.0 * Qp1 + 288.0 * Qp2 - 72.0 * Qp3 + 12.0 * QpN) / 7.0; \
        end else if (SWNQS_i == 5) begin \
            dQy          =  (-181.0 * Qp0 - 84.0 * Qp1 + 24.0 * Qp4 - 6.0 * Qp5 - 90.0 * Qp3 + QpN \
            + 336.0 * Qp2) / 65.0; \
            d2Qy         =  (432.0 * Qp4 - 108.0 * Qp5 - 1620.0 * Qp3 + 18.0 * QpN + 3762.0 * Qp0 \
            - 8532.0 * Qp1 + 6048.0 * Qp2) / 65.0; \
        end else if (SWNQS_i == 9) begin \
            dQy          =  (1680.0 * Qp6 + 23400.0 * Qp4 + 5.0 * QpN - 87330.0 * Qp3 + 120.0 * Qp8 \
            - 450.0 * Qp7 - 81480.0 * Qp1 + 325920.0 * Qp2 \
            - 175565.0 * Qp0 - 30.0 * Qp9) / 37829.0 - 30.0 / 181.0 * Qp5; \
            d2Qy         =  (-13500.0 * Qp7 + 702000.0 * Qp4 - 2619900 * Qp3 - 13793100.0 * Qp1 \
            + 9777600.0 * Qp2 + 6081750.0 * Qp0 + 150.0 * QpN + 3600.0 * Qp8 \
            - 900.0 * Qp9 + 50400.0 * Qp6) / 37829.0 - 900.0 / 181.0 * Qp5; \
        end else begin \
            dQy          =  0.0; \
            d2Qy         =  0.0; \
        end \
        `fq(Qp1, xg_ac, dQy, d2Qy, fk1) \
    end else begin \
        thesat2      =  0.0; \
    end \
    \
    if (SWNQS_i >= 2) begin \
        if (SWNQS_i == 2) begin \
            dQy          =  (2.0 * Qp0 - 12.0 * Qp1 + 3.0 * Qp2 + 7.0 * QpN) / 5.0; \
            d2Qy         =  -18.0 / 5.0 * (-4.0 * QpN + 9.0 * Qp2 - 6.0 * Qp1 + Qp0); \
        end else if (SWNQS_i == 3) begin \
            dQy          =  0.5 * Qp0 - 3.0 * Qp1 + 3.0 * Qp3 - 0.5 * QpN; \
            d2Qy         =  (-48.0 * Qp0 + 288.0 * Qp1 - 480.0 * Qp2 + 288.0 * Qp3 - 48.0 * QpN) / 7.0; \
        end else if (SWNQS_i == 5) begin \
            dQy          =  (-291.0 * Qp1 - 6.0 * Qp2 - 84.0 * Qp4 + 21.0 * Qp5) / 65.0 \
            + (630.0 * Qp3 - 7.0 * QpN + 97.0 * Qp0) / 130.0; \
            d2Qy         =  (-1728.0 * Qp4 + 432.0 * Qp5 + 6480.0 * Qp3 - 72.0 * QpN - 1008.0 * Qp0 \
            + 6048.0 * Qp1 - 10152.0 * Qp2) / 65.0; \
        end else if (SWNQS_i == 9) begin \
            dQy          =  (-5880.0 * Qp6 - 81900.0 * Qp4 + 305655.0 * Qp3 - 420.0 * Qp8 \
            + 105.0 * Qp9 - 282255.0 * Qp1 + 1575.0 * Qp7 - 5850.0 * Qp2) / 37829.0 \
            + 105.0 / 181.0 * Qp5 + (94085.0 * Qp0 - 35.0 * QpN) / 75658.0; \
            d2Qy         =  (9777600.0 * Qp1 + 54000.0 * Qp7 - 2808000.0 * Qp4 + 10479600.0 * Qp3 \
            - 16413000.0 * Qp2 - 1629600.0 * Qp0 - 600.0 * QpN - 14400.0 * Qp8 \
            + 3600.0 * Qp9 - 201600.0 * Qp6) / 37829.0 + 3600.0 * Qp5 / 181.0; \
        end else begin \
            dQy          =  0.0; \
            d2Qy         =  0.0; \
        end \
        `fq(Qp2, xg_ac, dQy, d2Qy, fk2) \
    end \
    \
    if (SWNQS_i >= 3) begin \
        if (SWNQS_i == 3) begin \
            dQy          =  (13.0 * QpN + 6.0 * Qp3 - 24.0 * Qp2 + 6.0 * Qp1 - Qp0) / 7.0; \
            d2Qy         =  (180.0 * QpN - 408.0 * Qp3 + 288.0 * Qp2 - 72.0 * Qp1 + 12.0 * Qp0) / 7.0; \
        end else if (SWNQS_i == 5) begin \
            dQy          =  (QpN - 6.0 * Qp5 + 24.0 * Qp4 - 24.0 * Qp2 + 6.0 * Qp1 - Qp0) / 5.0; \
            d2Qy         =  (1296.0 * (Qp4 + Qp2) - 324.0 * (Qp5 + Qp1) - 2052.0 * Qp3 \
            + 54.0 * (QpN + Qp0)) / 13.0; \
        end else if (SWNQS_i == 9) begin \
            dQy          =  (21840.0 * Qp6 + 304200.0 * Qp4 + 65.0 * QpN - 420.0 * Qp3 + 1560.0 * Qp8 \
            - 12605.0 * Qp0 - 390.0 * Qp9 + 75630.0 * Qp1 - 5850.0 * Qp7 \
            - 302520.0 * Qp2) / 37829.0 - 390.0 / 181.0 * Qp5; \
            d2Qy         =  (-2619900.0 * Qp1 - 202500.0 * Qp7 + 10530000.0 * Qp4 - 16601100.0 * Qp3 \
            + 10479600.0 * Qp2 + 436650.0 * Qp0 + 2250.0 * QpN + 54000.0 * Qp8 \
            - 13500.0 * Qp9 + 756000.0 * Qp6) / 37829.0 - 13500.0 * Qp5 / 181.0; \
        end else begin \
            dQy          =  0.0; \
            d2Qy         =  0.0; \
        end \
        `fq(Qp3, xg_ac, dQy, d2Qy, fk3) \
    end \
    \
    if (SWNQS_i >= 4) begin \
        if (SWNQS_i == 5) begin \
            dQy          =  (-630.0 * Qp3 + 12.0 * Qp4 + 582.0 * Qp5 - 97.0 * QpN + 7.0 * Qp0 \
            - 42.0 * Qp1 + 168.0 * Qp2) / 130.0; \
            d2Qy         =  (-10152.0 * Qp4 + 6048.0 * Qp5 + 6480.0 * Qp3 - 1008.0 * QpN \
            - 72.0 * Qp0 + 432.0 * Qp1 - 1728.0 * Qp2) / 65.0; \
        end else if (SWNQS_i == 9) begin \
            dQy          =  (-81480.0 * Qp6 - 30.0 * Qp4 - 303975.0 * Qp3 - 5820.0 * Qp8 \
            + 1455.0 * Qp9 - 20265.0 * Qp1 + 21825.0 * Qp7 + 81060.0 * Qp2) / 37829.0 \
            - 485.0 / 75658.0 * QpN + 1455.0 * Qp5 / 181.0 + 6755.0 * Qp0 / 75658.0; \
            d2Qy         =  (702000.0 * Qp1 + 756000.0 * Qp7 - 16614600.0 * Qp4 + 10530000.0 * Qp3 \
            - 2808000.0 * Qp2 - 117000.0 * Qp0 - 8400.0 * QpN - 201600.0 * Qp8 \
            + 50400.0 * Qp9 - 2822400.0 * Qp6) / 37829.0 + 50400.0 * Qp5 / 181.0; \
        end else begin \
            dQy          =  0.0; \
            d2Qy         =  0.0; \
        end \
        `fq(Qp4, xg_ac, dQy, d2Qy, fk4) \
    end \
    \
    if (SWNQS_i >= 5) begin \
        if (SWNQS_i == 5) begin \
            dQy          =  (-336.0 * Qp4 + 84.0 * Qp5 + 90.0 * Qp3 + 181.0 * QpN - Qp0 + 6.0 * Qp1 \
            - 24.0 * Qp2) / 65.0; \
            d2Qy         =  (18.0 * Qp0 + 3762.0 * QpN + 6048.0 * Qp4 + 432.0 * Qp2 - 1620.0 * Qp3 \
            - 108.0 * Qp1 - 8532.0 * Qp5) / 65.0; \
        end else if (SWNQS_i == 9) begin \
            dQy          =  (1680.0 * (Qp6 - Qp4) + 5.0 * (QpN - Qp0) + 450.0 * (Qp3 - Qp7) \
            + 120.0 * (Qp8 - Qp2) - 30.0 * (Qp9 - Qp1)) / 209.0; \
            d2Qy         =  (-900.0 * (Qp1 + Qp9) - 13500.0 * (Qp7 + Qp3) - 79500.0 * Qp5 \
            + 50400.0 * (Qp4 + Qp6) + 3600.0 * (Qp2 + Qp8) + 150.0 * (Qp0 + QpN)) / 181.0; \
        end else begin \
            dQy          =  0.0; \
            d2Qy         =  0.0; \
        end \
        `fq(Qp5, xg_ac, dQy, d2Qy, fk5) \
    end \
    \
    if (SWNQS_i >= 6) begin \
        if (SWNQS_i == 9) begin \
            dQy          =  (30.0 * Qp6 + 81480.0 * Qp4 - 21825.0 * Qp3 - 81060.0 * Qp8 + 20265.0 * Qp9 \
            - 1455.0 * Qp1 + 303975.0 * Qp7 + 5820.0 * Qp2) / 37829.0 \
            -(6755.0 * QpN - 485.0 * Qp0) / 75658.0 - 1455.0 / 181.0 * Qp5; \
            d2Qy         =  (50400.0 * Qp1 + 10530000.0 * Qp7 - 2822400.0 * Qp4 + 756000.0 * Qp3 \
            - 201600.0 * Qp2 - 8400.0 * Qp0 - 117000.0 * QpN - 2808000.0 * Qp8 \
            + 702000.0 * Qp9 - 16614600.0 * Qp6) / 37829.0 + 50400.0 * Qp5 / 181.0; \
        end else begin \
            dQy          =  0.0; \
            d2Qy         =  0.0; \
        end \
        `fq(Qp6, xg_ac, dQy, d2Qy, fk6) \
    end \
    \
    if (SWNQS_i >= 7) begin \
        if (SWNQS_i == 9) begin \
            dQy          =  (-304200.0 * Qp6 - 21840.0 * Qp4 + 12605.0 * QpN + 5850.0 * Qp3 \
            + 302520.0 * Qp8 - 65.0 * Qp0 - 75630.0 * Qp9 + 390.0 * Qp1 + 420.0 * Qp7 \
            - 1560.0 * Qp2) / 37829.0 + 390.0 / 181.0 * Qp5; \
            d2Qy         =  (-13500.0 * Qp1 - 16601100.0 * Qp7 + 756000.0 * Qp4 - 202500.0 * Qp3 \
            + 54000.0 * Qp2 + 2250.0 * Qp0 + 436650.0 * QpN + 10479600.0 * Qp8 \
            - 2619900.0 * Qp9 + 10530000.0 * Qp6) / 37829.0 - 13500.0 * Qp5 / 181.0; \
        end else begin \
            dQy          =  0.0; \
            d2Qy         =  0.0; \
        end \
        `fq(Qp7, xg_ac, dQy, d2Qy, fk7) \
    end \
    \
    if (SWNQS_i >= 8) begin \
        if (SWNQS_i == 9) begin \
            dQy          =  (81900.0 * Qp6 + 5880.0 * Qp4 - 1575.0 * Qp3 + 5850.0 * Qp8 + 282255.0 * Qp9 \
            - 105.0 * Qp1 - 305655.0 * Qp7 + 420.0 * Qp2) / 37829.0 + (35.0 * Qp0 \
            - 94085.0 * QpN) / 75658.0 - 105.0 / 181.0 * Qp5; \
            d2Qy         =  (3600.0 * Qp1 + 10479600.0 * Qp7 - 201600.0 * Qp4 + 54000.0 * Qp3 \
            - 14400.0 * Qp2 - 600.0 * Qp0 - 1629600.0 * QpN - 16413000.0 * Qp8 \
            + 9777600.0 * Qp9 - 2808000.0 * Qp6) / 37829.0 + 3600.0 * Qp5 / 181.0; \
        end else begin \
            dQy          =  0.0; \
            d2Qy         =  0.0; \
        end \
        `fq(Qp8, xg_ac, dQy, d2Qy, fk8) \
    end \
    \
    if (SWNQS_i >= 9) begin \
        if (SWNQS_i == 9) begin \
            dQy          =  (-23400.0 * Qp6 - 1680.0 * Qp4 + 175565.0 * QpN + 450.0 * Qp3 \
            - 325920.0 * Qp8 - 5.0 * Qp0 + 81480.0 * Qp9 + 30.0 * Qp1 \
            + 87330.0 * Qp7 - 120.0 * Qp2) / 37829.0 + 30.0 * Qp5 / 181.0; \
            d2Qy         =  (-900.0 * Qp1 - 2619900.0 * Qp7 + 50400.0 * Qp4 - 13500.0 * Qp3 \
            + 3600.0 * Qp2 + 150.0 * Qp0 + 6081750.0 * QpN + 9777600.0 * Qp8 \
            - 13793100.0 * Qp9 + 702000.0 * Qp6) / 37829.0 - 900.0 * Qp5 / 181.0; \
        end else begin \
            dQy          =  0.0; \
            d2Qy         =  0.0; \
        end \
        `fq(Qp9, xg_ac, dQy, d2Qy, fk9) \
    end \
    \
    /*  Terminal charges for NQS */ \
    QS_NQS       =  0.0; \
    QD_NQS       =  0.0; \
    QG_NQS       =  0.0; \
    if (SWNQS_i != 0) begin \
        if (SWNQS_i == 1) begin \
            QS_NQS       =  (17.0 * Qp0 + 30.0 * Qp1 + QpN) / 96.0; \
            QD_NQS       =  (Qp0 + 30.0 * Qp1 + 17.0 * QpN) / 96.0; \
            `QiToPhi(Qp1,xg_ac, temp1) \
            QG_NQS       =  xg_ac - (x_sp + 4.0 * temp1 + x_dp) * `oneSixth; \
        end else if (SWNQS_i == 2) begin \
            QS_NQS       =  (11.0 * Qp0 + 24.0 * Qp1 + 9.0 * Qp2 + QpN) / 90.0; \
            QD_NQS       =  (11.0 * QpN + 24.0 * Qp2 + 9.0 * Qp1 + Qp0) / 90.0; \
            `QiToPhi(Qp1, xg_ac, temp1) \
            `QiToPhi(Qp2, xg_ac, temp2) \
            QG_NQS       =  xg_ac - (x_sp + 3.0 * (temp1 + temp2) + x_dp) * 0.125; \
        end else if (SWNQS_i == 3) begin \
            QS_NQS       =  (251.0 * Qp0 + 594.0 * Qp1 + 312.0 * Qp2 + 174.0 * Qp3 + 13.0 * QpN) / 2688.0; \
            QD_NQS       =  (251.0 * QpN + 594.0 * Qp3 + 312.0 * Qp2 + 174.0 * Qp1 + 13.0 * Qp0) / 2688.0; \
            `QiToPhi(Qp1, xg_ac, temp1) \
            `QiToPhi(Qp2, xg_ac, temp2) \
            `QiToPhi(Qp3, xg_ac, temp3) \
            QG_NQS       =  xg_ac - (x_sp + 4.0 * temp1 + 2.0 * temp2 + 4.0 * temp3 + x_dp) / 12.0; \
        end else if (SWNQS_i == 5) begin \
            QS_NQS       =  (1187.0 * Qp0 + 43.0 * QpN) / 18720.0 + (503.0 * Qp1 + 172.0 * Qp4 \
            + 87.0 * Qp5 + 265.0 * Qp3 + 328.0 * Qp2) / 3120.0; \
            QD_NQS       =  (1187.0 * QpN + 43.0 * Qp0) / 18720.0 + (503.0 * Qp5 + 172.0 * Qp2 \
            + 87.0 * Qp1 + 265.0 * Qp3 + 328.0 * Qp4) / 3120.0; \
            `QiToPhi(Qp1, xg_ac, temp1) \
            `QiToPhi(Qp2, xg_ac, temp2) \
            `QiToPhi(Qp3, xg_ac, temp3) \
            `QiToPhi(Qp4, xg_ac, temp4) \
            `QiToPhi(Qp5, xg_ac, temp5) \
            QG_NQS       =  xg_ac - (x_sp + 4.0 * (temp1 + temp3 + temp5) + 2.0 * (temp2 + temp4) + x_dp) / 18.0; \
        end else if (SWNQS_i == 9) begin \
            QS_NQS       =  (75653.0 * Qp8 + 225999.0 * Qp4) / 3782900.0 + (151321.0 * Qp9 \
            + 454023.0 * Qp7 + 1073767.0 * Qp3 + 1564569.0 * Qp1) / 15131600.0 \
            + 75623.0 * Qp6 / 1891450.0 + 145.0 * Qp5 / 2896.0 + 72263.0 * Qp2 / 945725.0 \
            + (3504517.0 * Qp0 + 75653.0 * QpN) / 90789600.0; \
            QD_NQS       =  (75653.0 * Qp2 + 225999.0 * Qp6) / 3782900.0 + (151321.0 * Qp1 \
            + 454023.0 * Qp3 + 1073767.0 * Qp7 + 1564569.0 * Qp9) / 15131600.0 \
            + 75623.0 * Qp4 / 1891450.0 + 145.0 * Qp5 / 2896.0 + 72263.0 * Qp8 / 945725.0 \
            + (3504517.0 * QpN + 75653.0 * Qp0) / 90789600.0; \
            `QiToPhi(Qp1, xg_ac, temp1) \
            `QiToPhi(Qp2, xg_ac, temp2) \
            `QiToPhi(Qp3, xg_ac, temp3) \
            `QiToPhi(Qp4, xg_ac, temp4) \
            `QiToPhi(Qp5, xg_ac, temp5) \
            `QiToPhi(Qp6, xg_ac, temp6) \
            `QiToPhi(Qp7, xg_ac, temp7) \
            `QiToPhi(Qp8, xg_ac, temp8) \
            `QiToPhi(Qp9, xg_ac, temp9) \
            QG_NQS       =  xg_ac - (x_sp + 4.0 * (temp1 + temp3 + temp5 + temp7 + temp9) \
            + 2.0 * (temp2 + temp4 + temp6 + temp8) + x_dp) / 30.0; \
        end \
        QG_NQS      =  pd * QG_NQS; \
        \
        if (sigVds > 0) begin \
            Qs          =  COX_qm * phit1_ac * QS_NQS; \
            Qd          =  COX_qm * phit1_ac * QD_NQS; \
        end else begin \
            Qs          =  COX_qm * phit1_ac * QD_NQS; \
            Qd          =  COX_qm * phit1_ac * QS_NQS; \
        end \
        Qg          =  COX_qm * phit1_ac * QG_NQS; \
        Qb          = -Qg - Qs - Qd; \
    end \
    \
    /* Update internal nodes */ \
    V(RES1)     <+  vnorm_inv * I(RES1) * r_nqs; \
    V(SPLINE1)  <+  vnorm_inv * idt(-Tnorm * fk1, Qp1_0); \
    V(RES2)     <+  vnorm_inv * I(RES2) * r_nqs; \
    V(SPLINE2)  <+  vnorm_inv * idt(-Tnorm * fk2, Qp2_0); \
    V(RES3)     <+  vnorm_inv * I(RES3) * r_nqs; \
    V(SPLINE3)  <+  vnorm_inv * idt(-Tnorm * fk3, Qp3_0); \
    V(RES4)     <+  vnorm_inv * I(RES4) * r_nqs; \
    V(SPLINE4)  <+  vnorm_inv * idt(-Tnorm * fk4, Qp4_0); \
    V(RES5)     <+  vnorm_inv * I(RES5) * r_nqs; \
    V(SPLINE5)  <+  vnorm_inv * idt(-Tnorm * fk5, Qp5_0); \
    V(RES6)     <+  vnorm_inv * I(RES6) * r_nqs; \
    V(SPLINE6)  <+  vnorm_inv * idt(-Tnorm * fk6, Qp6_0); \
    V(RES7)     <+  vnorm_inv * I(RES7) * r_nqs; \
    V(SPLINE7)  <+  vnorm_inv * idt(-Tnorm * fk7, Qp7_0); \
    V(RES8)     <+  vnorm_inv * I(RES8) * r_nqs; \
    V(SPLINE8)  <+  vnorm_inv * idt(-Tnorm * fk8, Qp8_0); \
    V(RES9)     <+  vnorm_inv * I(RES9) * r_nqs; \
    V(SPLINE9)  <+  vnorm_inv * idt(-Tnorm * fk9, Qp9_0);

// ---- end `include "PSP104_nqs_macrodefs.include" ----

module PSPNQS104VA(d, g, s, b);

// ---- begin `include "PSP104_module.include" ----
//======================================================================================
//======================================================================================
// Filename: PSP104_module.include
//======================================================================================
//======================================================================================
//
//  (c) Copyright notice
//
//  Since 2015 until today, PSP has been co-developed by NXP Semiconductors and
//  CEA-Leti. For this part of the model, each claim undivided ownership and copyrights
//  Since 2012 until 2015, PSP has been co-developed by NXP Semiconductors and
//  Delft University of Technology. For this part of the model, each claim undivided
//  ownership and copyrights
//  Until and including 2011, PSP has been co-developed by NXP Semiconductors and
//  Arizona State University. For this part of the model, NXP Semiconductors claims
//  undivided ownership and copyrights.
//
//
//  Version: 104.1.0 (PSP), 200.7.0 (JUNCAP), March 2026
//
//======================================================================================
//======================================================================================
//
// Further information can be found in the file releasenotesPSP104.txt
//

//  --------------------------------------------------------------------------------------------------------------
//  Node definitions
//  --------------------------------------------------------------------------------------------------------------

`ifdef SelfHeating
    inout d, g, s, b, dt;
`else // SelfHeating
    inout d, g, s, b;
`endif // SelfHeating
electrical d;
electrical g;
electrical s;
electrical b;
`ifdef SelfHeating
    thermal dt;
    branch (dt) br_rth, br_ith;
`endif // SelfHeating

//  Internal nodes and branches for correlated drain and gate noise
electrical noi;
branch (noi) NOII;
branch (noi) NOIR;
branch (noi) NOIC;

//  Internal nodes for gate and bulk resistors
electrical gp;
electrical si;
electrical di;
electrical bp;
electrical bi;
electrical bs;
electrical bd;

//  Internal nodes and branches for spline collocation (NQS)
`ifdef NQSmodel
    electrical int1;
    electrical int2;
    electrical int3;
    electrical int4;
    electrical int5;
    electrical int6;
    electrical int7;
    electrical int8;
    electrical int9;
    branch(int1) SPLINE1;
    branch(int2) SPLINE2;
    branch(int3) SPLINE3;
    branch(int4) SPLINE4;
    branch(int5) SPLINE5;
    branch(int6) SPLINE6;
    branch(int7) SPLINE7;
    branch(int8) SPLINE8;
    branch(int9) SPLINE9;
    branch(int1) RES1;
    branch(int2) RES2;
    branch(int3) RES3;
    branch(int4) RES4;
    branch(int5) RES5;
    branch(int6) RES6;
    branch(int7) RES7;
    branch(int8) RES8;
    branch(int9) RES9;
`endif // NQSmodel

//  --------------------------------------------------------------------------------------------------------------
//  Instance parameters
//  --------------------------------------------------------------------------------------------------------------

//  Instance parameters for global and binning models only
`IPRco(L              ,1.0e-6     ,"m"        ,1.0e-9      ,inf         ,"Design length")
`IPRco(W              ,1.0e-6     ,"m"        ,1.0e-9      ,inf         ,"Design width")
`IPRnb(SA             ,0.0        ,"m"                                  ,"Distance between OD-edge and poly from one side")
`IPRnb(SB             ,0.0        ,"m"                                  ,"Distance between OD-edge and poly from other side")
`IPRnb(SD             ,0.0        ,"m"                                  ,"Distance between neighbouring fingers")
`IPRcz(SCA            ,0.0        ,""                                   ,"Integral of the first distribution function for scattered well dopants")
`IPRcz(SCB            ,0.0        ,""                                   ,"Integral of the second distribution function for scattered well dopants")
`IPRcz(SCC            ,0.0        ,""                                   ,"Integral of the third distribution function for scattered well dopants")
`IPRnb(SC             ,0.0        ,"m"                                  ,"Distance between OD-edge and nearest well edge")
`IPRco(NF             ,1.0        ,""         ,1.0         ,inf         ,"Number of fingers")
`IPRcc(NGCON          ,1.0        ,""         ,1.0         ,2.0         ,"Number of gate contacts")
`IPRnb(XGW            ,1.0e-7     ,"m"                                  ,"Distance from the gate contact to the channel edge")
`IPRnb(NRS            ,0.0        ,""                                   ,"Number of squares of source diffusion")
`IPRnb(NRD            ,0.0        ,""                                   ,"Number of squares of drain diffusion")

//  Instance parameters for local model only
`IPRco(JW             ,1.0e-6     ,"m"        ,`LG_cliplow ,inf         ,"Gate-edge length of source/drain junction")

//  Instance parameters for global, binning, and local models
`IPRnb(DELVTO         ,0.0        ,"V"                                  ,"Threshold voltage shift parameter")
`IPRcz(FACTUO         ,1.0        ,""                                   ,"Zero-field mobility pre-factor")
`IPRnb(DELVTOEDGE     ,0.0        ,"V"                                  ,"Threshold voltage shift parameter of edge transistor")
`IPRcz(FACTUOEDGE     ,1.0        ,""                                   ,"Zero-field mobility pre-factor of edge transistor")
`IPRco(ABSOURCE       ,1.0e-12    ,"m^2"      ,`AB_cliplow ,inf         ,"Bottom area of source junction")
`IPRco(LSSOURCE       ,1.0e-6     ,"m"        ,`LS_cliplow ,inf         ,"STI-edge length of source junction")
`IPRco(LGSOURCE       ,1.0e-6     ,"m"        ,`LG_cliplow ,inf         ,"Gate-edge length of source junction")
`IPRco(ABDRAIN        ,1.0e-12    ,"m^2"      ,`AB_cliplow ,inf         ,"Bottom area of drain junction")
`IPRco(LSDRAIN        ,1.0e-6     ,"m"        ,`LS_cliplow ,inf         ,"STI-edge length of drain junction")
`IPRco(LGDRAIN        ,1.0e-6     ,"m"        ,`LG_cliplow ,inf         ,"Gate-edge length of drain junction")
`IPRco(AS             ,1.0e-12    ,"m^2"      ,`AB_cliplow ,inf         ,"Bottom area of source junction (alternative spec.)")
`IPRco(PS             ,1.0e-6     ,"m"        ,`LS_cliplow ,inf         ,"Perimeter of source junction")
`IPRco(AD             ,1.0e-12    ,"m^2"      ,`AB_cliplow ,inf         ,"Bottom area of drain junction (alternative spec.)")
`IPRco(PD             ,1.0e-6     ,"m"        ,`LS_cliplow ,inf         ,"Perimeter of drain junction")
`IPRcz(IFACTOR        ,1.0        ,""                                   ,"Multiplier for JUNCAP current")
`IPRcz(CFACTOR        ,1.0        ,""                                   ,"Multiplier for JUNCAP depletion capacitance")
`IPRco(MULT           ,1.0        ,""         ,0.0         ,inf         ,"Number of devices in parallel")
`IPRco(MULT_I         ,1.0        ,""         ,0.0         ,inf         ,"Currents multiplication factor")
`IPRco(MULT_Q         ,1.0        ,""         ,0.0         ,inf         ,"Charges multiplication factor")
`IPRco(MULT_FN        ,MULT_I     ,""         ,0.0         ,inf         ,"Flicker noise multiplication factor")
`IPRnb(TRISE          ,0.0        ,"K"                                  ,"Device temperature offset")
aliasparam DTEMP = TRISE;

//  --------------------------------------------------------------------------------------------------------------
//  PSP Model Parameters
//  --------------------------------------------------------------------------------------------------------------
// ---- begin `include "PSP104_parlist.include" ----
//======================================================================================
//======================================================================================
// Filename: PSP104_parlist.include
//======================================================================================
//======================================================================================
//
//  (c) Copyright notice
//
//  Since 2015 until today, PSP has been co-developed by NXP Semiconductors and
//  CEA-Leti. For this part of the model, each claim undivided ownership and copyrights
//  Since 2012 until 2015, PSP has been co-developed by NXP Semiconductors and
//  Delft University of Technology. For this part of the model, each claim undivided
//  ownership and copyrights
//  Until and including 2011, PSP has been co-developed by NXP Semiconductors and
//  Arizona State University. For this part of the model, NXP Semiconductors claims
//  undivided ownership and copyrights.
//
//
//  Version: 104.1.0 (PSP), 200.7.0 (JUNCAP), March 2026
//
//======================================================================================
//======================================================================================
//
// Further information can be found in the file releasenotesPSP104.txt
//
//  --------------------------------------------------------------------------------------------------------------
//  Special model parameters and switch parameters
//  --------------------------------------------------------------------------------------------------------------

//  Special model parameters, some are also simulator global variables
`MPInb(LEVEL          ,104        ,""                                   ,"Model level")
`MPIty(TYPE           ,1          ,""                                   ,"Channel type parameter, +1=NMOS -1=PMOS")
`MPRco(TR             ,21.0       ,"C"        ,-273.0      ,inf         ,"nominal (reference) temperature")
aliasparam TREF = TR;

//  Switch parameters that turn models or effects on or off
`MPIcc(SWGEO          ,1          ,""         ,0           ,1           ,"Flag for geometrical model, 0=local, 1=global")
`MPIcc(SWIGATE        ,0          ,""         ,0           ,1           ,"Flag for gate current: 0=off, 1=on")
`MPIcc(SWIMPACT       ,0          ,""         ,0           ,1           ,"Flag for impact ionization current, 0=turn off II")
`MPIcc(SWGIDL         ,0          ,""         ,0           ,1           ,"Flag for GIDL current, 0=turn off IGIDL")
`MPIcc(SWJUNCAP       ,0          ,""         ,0           ,3           ,"Flag for juncap, 0=turn off juncap")
`MPIcc(SWJUNASYM      ,0          ,""         ,0           ,1           ,"Flag for asymmetric junctions; 0=symmetric, 1=asymmetric")
`MPIcc(SWNUD          ,0          ,""         ,0           ,2           ,"Flag for NUD-effect; 0=off, 1=on, 2=on+CV-correction")
`MPIcc(SWEDGE         ,0          ,""         ,0           ,1           ,"Flag for drain current of edge transistors; 0=off, 1=on")
`MPIcc(SWDELVTAC      ,0          ,""         ,0           ,1           ,"Flag for separate capacitance calculation; 0=off, 1=on")
`MPIcc(SWQSAT         ,0          ,""         ,0           ,1           ,"Flag for separate capacitance calculation in saturation only: 0=off, 1=on")
`MPIcc(SWQPART        ,0          ,""         ,0           ,1           ,"Flag for drain/source charge partitioning; 0=linear distribution, 1=source")
`MPIcc(SWIGN          ,1          ,""         ,0           ,1           ,"Flag for induced gate noise; 0=off, 1=on")
`ifdef NQSmodel
`MPIcc(SWNQS          ,0          ,""         ,0           ,9           ,"Flag for NQS, 0=off, 1, 2, 3, 5, or 9=number of collocation points")
`endif // NQSmodel
`MPRcz(QMC            ,1.0        ,""                                   ,"Quantum-mechanical correction factor")

//  Switch parameters for operating point info
`MPIcc(SWOPREXT       ,0          ,""         ,0           ,1           ,"Indicates if the impact of rd, rg & rs is included in OP-output quantities, 0=not included, 1=included (value in low frequency limit))")
`MPIcc(SWOPPMOS       ,0          ,""         ,0           ,1           ,"Switch for pmos convention, 0=used the nmos convention, 1=the type of pmos is preserved")
`MPIcc(SWOPDRAIN      ,0          ,""         ,0           ,1           ,"Switch for drain configuration, 0=the drain is the electrical node such as Vds is positive (in nmos convention), 1=the drain is the first terminal")

//  Temperature offset parameter
`MPRnb(DTA            ,0.0        ,"K"                                  ,"Temperature offset w.r.t. ambient temperature")

//  --------------------------------------------------------------------------------------------------------------
//  PSP local model parameters
//  --------------------------------------------------------------------------------------------------------------

//  Flat-band voltage parameters
`MPRnb(VFB            ,-1.0       ,"V"                                  ,"Flat-band voltage at TR")
`MPRnb(STVFB          ,5.0e-04    ,"V/K"                                ,"Temperature dependence of VFB")
`MPRnb(ST2VFB         ,0.0        ,"K^-1"                               ,"Quadratic temperature dependence of VFB")

//  Process parameters
`MPRco(TOX            ,2.0e-09    ,"m"        ,1.0e-10     ,inf         ,"Gate oxide thickness")
`MPRco(EPSROX         ,3.9        ,""         ,1.0         ,inf         ,"Relative permittivity of the gate dielectric")
`MPRcc(NEFF           ,5.0e23     ,"m^-3"     ,1.0e20      ,1.0e26      ,"Effective substrate doping")
`MPRco(GFACNUD        ,1.0        ,""         ,0.01        ,inf         ,"Body-factor change due to NUD-effect")
`MPRcz(VSBNUD         ,0.0        ,"V"                                  ,"Lower Vsb value due to  NUD-effect")
`MPRco(DVSBNUD        ,1.0        ,"V"        ,0.1         ,inf         ,"Vsb-range for NUD-effect")
`MPRnb(DPHIB          ,0.0        ,"V"                                  ,"Offset voltage of PHIB")
`MPRcz(NP             ,1.0e26     ,"m^-3"                               ,"Gate poly-silicon doping")
`MPRco(TOXOV          ,2.0e-09    ,"m"        ,1.0e-10     ,inf         ,"Overlap oxide thickness")
`MPRco(TOXOVD         ,2.0e-09    ,"m"        ,1.0e-10     ,inf         ,"Overlap oxide thickness for drain side")
`MPRcc(NOV            ,5.0e25     ,"m^-3"     ,1.0e23      ,1.0e27      ,"Effective doping of overlap region")
`MPRcc(NOVD           ,5.0e25     ,"m^-3"     ,1.0e23      ,1.0e27      ,"Effective doping of overlap region for drain side")

//  Interface states parameters
`MPRcz(CT             ,0.0        ,""                                   ,"Interface states factor")
`MPRcc(CTB            ,0.0        ,""         ,0.0         ,0.5         ,"Bulk voltage dependence of interface states factor")
`MPRcc(CTG            ,0.0        ,""         ,0.0         ,1.0         ,"Gate voltage dependence of interface states factor")
`MPRnb(STCT           ,1.0        ,""                                   ,"Temperature dependence of CT")

//  DIBL parameters
`MPRcz(CF             ,0.0        ,""                                   ,"DIBL parameter")
`MPRcc(CFB            ,0.0        ,"V^-1"     ,0.0         ,1.0         ,"Bulk voltage dependence of DIBL")
`MPRcz(CFD            ,0.0        ,"V^-1"                               ,"Drain voltage dependence of DIBL")

//  Subthreshold slope parameters of short channel transistor
`MPRcz(PSCE           ,0.0        ,""                                   ,"Subthreshold slope coefficient for short channel transistor")
`MPRcc(PSCEB          ,0.0        ,"V^-1"     ,0.0         ,1.0         ,"Bulk voltage dependence parameter of subthreshold slope coefficient for short channel transistor")
`MPRcz(PSCED          ,0.0        ,"V^-1"                               ,"Drain voltage dependence parameter of subthreshold slope coefficient for short channel transistor")

//  Mobility parameters
`MPRcz(BETN           ,3.0e-02    ,"m^2/V/s"                            ,"Product of channel aspect ratio and zero-field mobility at TR")
`MPRnb(STBET          ,1.0        ,""                                   ,"Temperature dependence of BETN")
`MPRcz(MUE            ,0.5        ,"m/V"                                ,"High field mobility reduction coefficient at TR")
`MPRnb(STMUE          ,0.0        ,""                                   ,"Temperature dependence of MUE")
`MPRcz(THEMU          ,1.5        ,""                                   ,"High field mobility reduction exponent at TR")
`MPRnb(STTHEMU        ,1.5        ,""                                   ,"Temperature dependence of THEMU")
`MPRcz(CS             ,0.0        ,""                                   ,"Coulomb scattering parameter at TR")
`MPRnb(STCS           ,0.0        ,""                                   ,"Temperature dependence of CS")
`MPRcz(THECS          ,2.0        ,""                                   ,"Coulomb scattering exponent at TR")
`MPRnb(STTHECS        ,0.0        ,""                                   ,"Temperature dependence of THECS")
`MPRcz(XCOR           ,0.0        ,"V^-1"                               ,"Non-universality factor")
`MPRnb(STXCOR         ,0.0        ,""                                   ,"Temperature dependence of XCOR")
`MPRcz(FETA           ,1.0        ,""                                   ,"Effective field parameter")

//  Intrinsic series-resistance parameters
`MPRcz(RS             ,50.0       ,"Ohm"                                ,"Source/drain series resistance at TR")
`MPRnb(STRS           ,1.0        ,""                                   ,"Temperature dependence of RS")
`MPRcc(RSB            ,0.0        ,"V^-1"     ,-0.5        ,1.0         ,"Bulk voltage dependence of series resistance")
`MPRco(RSG            ,0.0        ,"V^-1"     ,-0.5        ,inf         ,"Gate voltage dependence of series resistance")

//  Velocity saturation parameters
`MPRcz(THESAT         ,0.3        ,"V^-1"                               ,"Velocity saturation parameter at TR")
`MPRnb(STTHESAT       ,1.0        ,""                                   ,"Temperature dependence of THESAT")
`MPRcc(THESATB        ,0.0        ,"V^-1"     ,-0.5        ,1.0         ,"Bulk voltage dependence of velocity saturation")
`MPRco(THESATG        ,0.0        ,"V^-1"     ,-0.5        ,inf         ,"Gate voltage dependence of velocity saturation")
`MPRco(THESATT        ,1.0        ,""         ,0.01        ,inf         ,"Threshold parameter of gate voltage dependence of velocity saturation")

//  Linear to saturation transition parameters
`MPRco(AX             ,8.0        ,""         ,2.0         ,inf         ,"Linear/saturation transition factor")

//  Channel length modulation parameters
`MPRcz(ALP            ,1.0e-02    ,""                                   ,"CLM pre-factor")
`MPRcz(ALP1           ,0.0        ,"V"                                  ,"CLM enhancement factor above threshold")
`MPRcz(ALP2           ,0.0        ,"V^-1"                               ,"CLM enhancement factor below threshold")
`MPRco(VP             ,0.05       ,"V"        ,1.0e-10     ,inf         ,"CLM logarithm dependence factor")

//  Impact ionization parameters
`MPRcz(A1             ,1.0        ,""                                   ,"Impact-ionization pre-factor")
`MPRcz(A2             ,10.0       ,"V"                                  ,"Impact-ionization exponent at TR")
`MPRnb(STA2           ,0.0        ,"V"                                  ,"Temperature dependence of A2")
`MPRcz(A3             ,1.0        ,""                                   ,"Saturation-voltage dependence of impact-ionization")
`MPRcz(A4             ,0.0        ,"V^-0.5"                             ,"Bulk voltage dependence of impact-ionization")
`MPRco(IMAXII         ,10.0       ,"A"        ,1e-12       ,inf         ,"Maximum impact-ionization current value")

//  Gate current parameters
`MPRcc(GCO            ,0.0        ,""         ,-10.0       ,10.0        ,"Gate tunnelling energy adjustment")
`MPRcz(IGINV          ,0.0        ,"A"                                  ,"Gate channel current pre-factor")
`MPRcz(IGOV           ,0.0        ,"A"                                  ,"Gate overlap current pre-factor")
`MPRcz(IGOVD          ,0.0        ,"A"                                  ,"Gate overlap current pre-factor for drain side")
`MPRnb(STIG           ,2.0        ,""                                   ,"Temperature dependence of IGINV and IGOV")
`MPRcc(GC2            ,0.375      ,""         ,0.0         ,10.0        ,"Gate current slope factor")
`MPRcc(GC3            ,0.063      ,""         ,-2.0        ,2.0         ,"Gate current curvature factor")
`MPRcc(GC2OV          ,0.375      ,""         ,0.0         ,10.0        ,"Gate overlap current slope factor")
`MPRcc(GC3OV          ,0.063      ,""         ,-2.0        ,2.0         ,"Gate overlap current curvature factor")
`MPRcc(GC2OVD         ,0.375      ,""         ,0.0         ,10.0        ,"Gate overlap current slope factor for drain side")
`MPRcc(GC3OVD         ,0.063      ,""         ,-2.0        ,2.0         ,"Gate overlap current curvature factor for drain side")
`MPRco(CHIB           ,3.1        ,"V"        ,1.0         ,inf         ,"Tunnelling barrier height")

//  Gate induced drain/source leakage parameters
`MPRcz(AGIDL          ,0.0        ,"A/V^3"                              ,"GIDL pre-factor")
`MPRcz(AGIDLD         ,0.0        ,"A/V^3"                              ,"GIDL pre-factor for drain side")
`MPRcz(BGIDL          ,41.0       ,"V"                                  ,"GIDL probability factor at TR")
`MPRcz(BGIDLD         ,41.0       ,"V"                                  ,"GIDL probability factor at TR for drain side")
`MPRnb(STBGIDL        ,0.0        ,"V/K"                                ,"Temperature dependence of BGIDL")
`MPRnb(STBGIDLD       ,0.0        ,"V/K"                                ,"Temperature dependence of BGIDLD")
`MPRnb(CGIDL          ,0.0        ,""                                   ,"Bulk voltage dependence of GIDL")
`MPRnb(CGIDLD         ,0.0        ,""                                   ,"Bulk voltage of GIDL for drain side")

//  Charge model parameters
`MPRcz(COX            ,1.0e-14    ,"F"                                  ,"Oxide capacitance for the intrinsic channel")
`MPRnb(DELVTAC        ,0.0        ,"V"                                  ,"PHIB offset in separate charge calculation (SWDELVTAC=1)")
`MPRcz(FACNEFFAC      ,1.0        ,""                                   ,"Pre-factor for effective substrate doping in separate charge calculation (SWDELVTAC=1)")
`MPRcz(THESATAC       ,0.1        ,"V^-1"                               ,"Velocity saturation parameter at TR of the charge model when SWQSAT=1")
`MPRco(AXAC           ,8.0        ,""         ,2.0         ,inf         ,"Linear/saturation transition factor of the charge model when SWQSAT=1")
`MPRnb(ALPAC          ,0.0        ,""                                   ,"CLM pre-factor of the charge model")
`MPRcz(ALP1AC         ,0.0        ,"V"                                  ,"CLM enhancement factor above threshold of the charge model")
`MPRcz(CGOV           ,1.0e-15    ,"F"                                  ,"Oxide capacitance for gate-drain/source overlap")
`MPRcz(CGOVD          ,1.0e-15    ,"F"                                  ,"Oxide capacitance for gate-drain overlap")
`MPRcc(FCGOVACC       ,0.5        ,""         ,0.0         ,1.0         ,"Factor for overlap capacitances in accumulation regime")
`MPRcc(FCGOVACCD      ,0.5        ,""         ,0.0         ,1.0         ,"Factor for overlap capacitances in accumulation regime for drain side")
`MPRcc(CGOVACCG       ,1.0        ,""         ,0.1         ,1.0         ,"Gate voltage dependence parameter of overlap capacitances in accumulation regime")
`MPRcz(CGBOV          ,1.0e-15    ,"F"                                  ,"Oxide capacitance for gate-bulk overlap")
`MPRcz(CINR           ,5.0e-16    ,"F"                                  ,"Inner fringe capacitance")
`MPRcz(CINRD          ,5.0e-16    ,"F"                                  ,"Inner fringe capacitance for drain side")
`MPRnb(DVFBINR        ,0.0        ,"V"                                  ,"Flat-band voltage offset of inner fringe capacitances")
`MPRcc(FCINRDEP       ,0.3        ,""         ,0.0         ,1.0         ,"Bias dependence parameter of inner fringe capacitances in depletion regime")
`MPRcz(FCINRACC       ,0.5        ,""                                   ,"Bias dependence parameter of inner fringe capacitances in accumulation regime")
`MPRcc(AXINR          ,0.4        ,""         ,0.1         ,4.0         ,"Accumulation/depletion transition factor of inner fringe capacitances")
`MPRcz(CFR            ,1.0e-15    ,"F"                                  ,"Outer fringe capacitance")
`MPRcz(CFRD           ,1.0e-15    ,"F"                                  ,"Outer fringe capacitance for drain side")

//  Noise parameters
`MPRcz(FNT            ,1.0        ,""                                   ,"Thermal noise coefficient")
`MPRcz(FNTEXC         ,0.0        ,""                                   ,"Excess noise coefficient")
`MPRcz(NFA            ,8.0e22     ,"V^-1/m^4"                           ,"First coefficient of flicker noise")
`MPRcz(NFB            ,3.0e07     ,"V^-1/m^2"                           ,"Second coefficient of flicker noise")
`MPRcz(NFC            ,0.0        ,"V^-1"                               ,"Third coefficient of flicker noise")
`MPRcz(EF             ,1.0        ,""                                   ,"Flicker noise frequency exponent")

//  Edge transistors parameters
`MPRnb(VFBEDGE        ,-1.0       ,"V"                                  ,"Flat-band voltage of edge transistors at TR")
`MPRnb(STVFBEDGE      ,5.0e-04    ,"V/K"                                ,"Temperature dependence of VFBEDGE")
`MPRnb(DPHIBEDGE      ,0.0        ,"V"                                  ,"Offset parameter for PHIB of edge transistors")
`MPRcc(NEFFEDGE       ,5.0e23     ,"m^-3"     ,1.0e20      ,1.0e26      ,"Effective substrate doping of edge transistors")
`MPRcz(CTEDGE         ,0.0        ,""                                   ,"Interface states factor of edge transistors")
`MPRcz(BETNEDGE       ,6.0e-04    ,"m^2/V/s"                            ,"Product of channel aspect ratio and zero-field mobility of edge transistors at TR")
`MPRnb(STBETEDGE      ,1.0        ,""                                   ,"Temperature dependence of BETNEDGE")
`MPRcz(PSCEEDGE       ,0.0        ,""                                   ,"Subthreshold slope coefficient for short channel edge transistors")
`MPRcc(PSCEBEDGE      ,0.0        ,"V^-1"     ,0.0         ,1.0         ,"Bulk voltage dependence parameter of subthreshold slope coefficient for short channel edge transistors")
`MPRcz(PSCEDEDGE      ,0.0        ,"V^-1"                               ,"Drain voltage dependence parameter of subthreshold slope coefficient for short channel edge transistors")
`MPRcz(CFEDGE         ,0.0        ,""                                   ,"DIBL parameter of edge transistors")
`MPRcc(CFBEDGE        ,0.0        ,"V^-1"     ,0.0         ,1.0         ,"Bulk voltage dependence parameter of DIBL-parameter of edge transistors")
`MPRcz(CFDEDGE        ,0.0        ,"V^-1"                               ,"Drain voltage dependence parameter of DIBL-parameter of edge transistors")
`MPRcz(FNTEDGE        ,1.0        ,""                                   ,"Thermal noise coefficient of edge transistors")
`MPRcz(NFAEDGE        ,4.0e24     ,"V^-1/m^4"                           ,"First coefficient of flicker noise of edge transistors")
`MPRcz(NFBEDGE        ,1.5e09     ,"V^-1/m^2"                           ,"Second coefficient of flicker noise of edge transistors")
`MPRcz(NFCEDGE        ,0.0        ,"V^-1"                               ,"Third coefficient of flicker noise of edge transistors")
`MPRcz(EFEDGE         ,1.0        ,""                                   ,"Flicker noise frequency exponent of edge transistors")

//  Parasitic resistance parameters
`MPRcz(RG             ,0.0        ,"Ohm"                                ,"Gate resistance")
`MPRcz(RSE            ,0.0        ,"Ohm"                                ,"External source resistance")
`MPRcz(RDE            ,0.0        ,"Ohm"                                ,"External drain resistance")
`MPRcz(RBULK          ,0.0        ,"Ohm"                                ,"Bulk resistance between node BP and BI")
`MPRcz(RWELL          ,0.0        ,"Ohm"                                ,"Well resistance between node BI and B")
`MPRcz(RJUNS          ,0.0        ,"Ohm"                                ,"Source-side bulk resistance between node BI and BS")
`MPRcz(RJUND          ,0.0        ,"Ohm"                                ,"Drain-side bulk resistance between node BI and BD")

//  Self heating effect parameters
`ifdef SelfHeating
`MPRcz(RTH            ,0.0        ,"K/W"                                ,"Thermal resistance")
`MPRcz(CTH            ,0.0        ,"J/K"                                ,"Thermal capacitance")
`MPRnb(STRTH          ,0.0        ,""                                   ,"Temperature dependence of RTH")
`endif // SelfHeating

//  NQS parameters
`ifdef NQSmodel
`MPRcz(MUNQS          ,1.0        ,""                                   ,"Relative mobility for NQS modelling")
`endif // NQSmodel

//  --------------------------------------------------------------------------------------------------------------
//  PSP global model parameters
//  --------------------------------------------------------------------------------------------------------------

//  Electrical geometry parameters
`MPRnb(LVARO          ,0.0        ,"m"                                  ,"Geometry independent difference between actual and programmed poly-silicon gate length")
`MPRnb(LVARL          ,0.0        ,""                                   ,"Length dependence of LPS")
`MPRnb(LVARW          ,0.0        ,""                                   ,"Width dependence of LPS")
`MPRnb(LAP            ,0.0        ,"m"                                  ,"Effective channel length reduction per side due to lateral diffusion of source/drain dopant ions")
`MPRnb(WVARO          ,0.0        ,"m"                                  ,"Geometry independent difference between actual and programmed field-oxide opening")
`MPRnb(WVARL          ,0.0        ,""                                   ,"Length dependence of WOD")
`MPRnb(WVARW          ,0.0        ,""                                   ,"Width dependence of WOD")
`MPRnb(WOT            ,0.0        ,"m"                                  ,"Effective reduction of channel width per side due to lateral diffusion of channel-stop dopant ions")
`MPRnb(DLQ            ,0.0        ,"m"                                  ,"Effective channel length reduction for CV")
`MPRnb(DWQ            ,0.0        ,"m"                                  ,"Effective channel width reduction for CV")

//  Flat-band voltage parameters
`MPRnb(VFBO           ,-1.0       ,"V"                                  ,"Geometry-independent part of flat-band voltage at TR")
`MPRnb(VFBL           ,0.0        ,"V"                                  ,"Length dependence of flat-band voltage at TR")
`MPRnb(VFBLEXP        ,1.0        ,""                                   ,"Exponent for length dependence of flat-band voltage at TR")
`MPRnb(VFBW           ,0.0        ,"V"                                  ,"Width dependence of flat-band voltage at TR")
`MPRnb(VFBLW          ,0.0        ,"V"                                  ,"Area dependence of flat-band voltage at TR")
`MPRnb(STVFBO         ,5.0e-04    ,"V/K"                                ,"Geometry-independent part of temperature dependence of VFB")
`MPRnb(STVFBL         ,0.0        ,"V/K"                                ,"Length dependence of temperature dependence of VFB")
`MPRnb(STVFBW         ,0.0        ,"V/K"                                ,"Width dependence of temperature dependence of VFB")
`MPRnb(STVFBLW        ,0.0        ,"V/K"                                ,"Area dependence of temperature dependence of VFB")
`MPRnb(ST2VFBO        ,0.0        ,"K^-1"                               ,"Quadratic temperature dependence of VFB")

//  Process parameters
`MPRco(TOXO           ,2.0e-09    ,"m"        ,1.0e-10     ,inf         ,"Gate oxide thickness")
`MPRco(EPSROXO        ,3.9        ,""         ,1.0         ,inf         ,"Relative permittivity of gate dielectric")
`MPRco(NSUBO          ,4.0e23     ,"m^-3"     ,1.0e20      ,inf         ,"Geometry independent part of effective substrate doping")
`MPRnb(NSUBW          ,0.0        ,""                                   ,"Width dependence of effective substrate doping due to segregation")
`MPRco(WSEG           ,1.0e-08    ,"m"        ,1.0e-10     ,inf         ,"Characteristic length for segregation of substrate doping")
`MPRcz(NPCK           ,1.0e24     ,"m^-3"                               ,"Pocket doping level")
`MPRnb(NPCKW          ,0.0        ,""                                   ,"Width dependence of pocket doping NPCK due to segregation")
`MPRco(WSEGP          ,1.0e-08    ,"m"        ,1.0e-10     ,inf         ,"Characteristic length for segregation of pocket doping")
`MPRco(LPCK           ,1.0e-08    ,"m"        ,1.0e-10     ,inf         ,"Characteristic length of lateral doping profile")
`MPRnb(LPCKW          ,0.0        ,""                                   ,"Width dependence of LPCK due to segregation")
`MPRnb(FOL1           ,0.0        ,""                                   ,"First order length dependence of short channel body effect")
`MPRnb(FOL2           ,0.0        ,""                                   ,"Second order length dependence of short channel body effect")
`MPRnb(GFACNUDO       ,1.0        ,""                                   ,"Geometry independent part of body-factor change due to NUD-effect")
`MPRnb(GFACNUDL       ,0.0        ,""                                   ,"Length dependence of body-factor change due to NUD-effect")
`MPRnb(GFACNUDLEXP    ,1.0        ,""                                   ,"Exponent for length dependence of body-factor change due to NUD-effect")
`MPRnb(GFACNUDW       ,0.0        ,""                                   ,"Width dependence of body-factor change due to NUD-effect")
`MPRnb(GFACNUDLW      ,0.0        ,""                                   ,"Area dependence of body-factor change due to NUD-effect")
`MPRcz(VSBNUDO        ,0.0        ,"V"                                  ,"Lower Vsb value for NUD-effect")
`MPRco(DVSBNUDO       ,1.0        ,"V"        ,0.1         ,inf         ,"Vsb range for NUD-effect")
`MPRnb(DPHIBO         ,0.0        ,"V"                                  ,"Geometry independent part of offset voltage of PHIB")
`MPRnb(DPHIBL         ,0.0        ,"V"                                  ,"Length dependence offset of offset voltage of PHIB")
`MPRnb(DPHIBLEXP      ,1.0        ,""                                   ,"Exponent for length dependence of offset of offset voltage of PHIB")
`MPRnb(DPHIBW         ,0.0        ,"V"                                  ,"Width dependence of offset of offset voltage of PHIB")
`MPRnb(DPHIBLW        ,0.0        ,"V"                                  ,"Area dependence of offset of offset voltage of PHIB")
`MPRnb(NPO            ,1.0e26     ,"m^-3"                               ,"Geometry-independent part of gate poly-silicon doping")
`MPRnb(NPL            ,0.0        ,""                                   ,"Length dependence of gate poly-silicon doping")
`MPRco(TOXOVO         ,2.0e-09    ,"m"        ,1.0e-10     ,inf         ,"Overlap oxide thickness")
`MPRco(TOXOVDO        ,2.0e-09    ,"m"        ,1.0e-10     ,inf         ,"Overlap oxide thickness for drain side")
`MPRcz(LOV            ,1.0e-08    ,"m"                                  ,"Overlap length for gate/drain and gate/source overlap capacitance")
`MPRcz(LOVD           ,1.0e-08    ,"m"                                  ,"Overlap length for gate/drain overlap capacitance")
`MPRcc(NOVO           ,5.0e25     ,"m^-3"     ,1.0e23      ,1.0e27      ,"Effective doping of overlap region")
`MPRcc(NOVDO          ,5.0e25     ,"m^-3"     ,1.0e23      ,1.0e27      ,"Effective doping of overlap region for drain side")

//  Interface states parameters
`MPRnb(CTO            ,0.0        ,""                                   ,"Geometry-independent part of interface states factor")
`MPRnb(CTL            ,0.0        ,""                                   ,"Length dependence of interface states factor")
`MPRnb(CTLEXP         ,1.0        ,""                                   ,"Exponent for length dependence of interface states factor")
`MPRnb(CTW            ,0.0        ,""                                   ,"Width dependence of interface states factor")
`MPRnb(CTLW           ,0.0        ,""                                   ,"Area dependence of interface states factor")
`MPRcc(CTBO           ,0.0        ,""         ,0.0         ,0.5         ,"Bulk voltage dependence of interface states factor")
`MPRcc(CTGO           ,0.0        ,""         ,0.0         ,1.0         ,"Gate voltage dependence of interface states factor")
`MPRnb(STCTO          ,1.0        ,""                                   ,"Temperature dependence of CT")

//  DIBL parameters
`MPRnb(CFL            ,0.0        ,""                                   ,"Length dependence of DIBL-parameter")
`MPRnb(CFLEXP         ,2.0        ,""                                   ,"Exponent for length dependence of DIBL-parameter")
`MPRnb(CFW            ,0.0        ,""                                   ,"Width dependence of DIBL-parameter")
`MPRcc(CFBO           ,0.0        ,"V^-1"     ,0.0         ,1.0         ,"Bulk voltage dependence of DIBL")
`MPRcz(CFDO           ,0.0        ,"V^-1"                               ,"Drain voltage dependence of DIBL")

//  Subthreshold slope parameters of short channel transistor
`MPRnb(PSCEL          ,0.0        ,""                                   ,"Length dependence of subthreshold slope coefficient for short channel transistor")
`MPRnb(PSCELEXP       ,2.0        ,""                                   ,"Exponent for length dependence of subthreshold slope coefficient for short channel transistor")
`MPRnb(PSCEW          ,0.0        ,""                                   ,"Width dependence of subthreshold slope coefficient for short channel transistor")
`MPRcc(PSCEBO         ,0.0        ,"V^-1"     ,0.0         ,1.0         ,"Bulk voltage dependence parameter of subthreshold slope coefficient for short channel transistor")
`MPRcz(PSCEDO         ,0.0        ,"V^-1"                               ,"Drain voltage dependence parameter of subthreshold slope coefficient for short channel transistor")

//  Mobility parameters
`MPRcz(UO             ,3.0e-02    ,"m^2/V/s"                            ,"Zero-field mobility at TR")
`MPRnb(FBET1          ,0.0        ,""                                   ,"Relative mobility decrease due to first lateral profile")
`MPRnb(FBET1W         ,0.0        ,""                                   ,"Width dependence of relative mobility decrease due to first lateral profile")
`MPRco(LP1            ,1.0e-08    ,"m"        ,1.0e-10     ,inf         ,"Mobility-related characteristic length of first lateral profile")
`MPRnb(LP1W           ,0.0        ,""                                   ,"Width dependence of mobility-related characteristic length of first lateral profile")
`MPRnb(FBET2          ,0.0        ,""                                   ,"Relative mobility decrease due to second lateral profile")
`MPRco(LP2            ,1.0e-08    ,"m"        ,1.0e-10     ,inf         ,"Mobility-related characteristic length of second lateral profile")
`MPRnb(BETW1          ,0.0        ,""                                   ,"First order width scaling coefficient of BETN")
`MPRnb(BETW2          ,0.0        ,""                                   ,"Second order width scaling coefficient of BETN")
`MPRco(WBET           ,1.0e-09    ,"m"        ,1.0e-10     ,inf         ,"Characteristic width for width scaling of BETN")
`MPRnb(STBETO         ,1.0        ,""                                   ,"Geometry independent part of temperature dependence of BETN")
`MPRnb(STBETL         ,0.0        ,""                                   ,"Length dependence of temperature dependence of BETN")
`MPRnb(STBETW         ,0.0        ,""                                   ,"Width dependence of temperature dependence of BETN")
`MPRnb(STBETLW        ,0.0        ,""                                   ,"Area dependence of temperature dependence of BETN")
`MPRnb(MUEO           ,0.5        ,"m/V"                                ,"Geometry independent part of high field mobility reduction coefficient at TR")
`MPRnb(MUEW           ,0.0        ,""                                   ,"Width dependence of high field mobility reduction coefficient at TR")
`MPRnb(STMUEO         ,0.0        ,""                                   ,"Temperature dependence of MUE")
`MPRcz(THEMUO         ,1.5        ,""                                   ,"High field mobility reduction exponent at TR")
`MPRnb(STTHEMUO       ,1.5        ,""                                   ,"Temperature dependence of THEMU")
`MPRnb(CSO            ,0.0        ,""                                   ,"Geometry independent part of Coulomb scattering parameter at TR")
`MPRnb(CSL            ,0.0        ,""                                   ,"Length dependence of Coulomb scattering parameter at TR")
`MPRnb(CSLEXP         ,1.0        ,""                                   ,"Exponent for length dependence of Coulomb scattering parameter at TR")
`MPRnb(CSW            ,0.0        ,""                                   ,"Width dependence of Coulomb scattering parameter at TR")
`MPRnb(CSLW           ,0.0        ,""                                   ,"Area dependence of Coulomb scattering parameter at TR")
`MPRnb(STCSO          ,0.0        ,""                                   ,"Temperature dependence of CS")
`MPRcz(THECSO         ,2.0        ,""                                   ,"Coulomb scattering exponent at TR")
`MPRnb(STTHECSO       ,0.0        ,""                                   ,"Temperature dependence of THECS")
`MPRnb(XCORO          ,0.0        ,"V^-1"                               ,"Geometry independent part of non-universality parameter")
`MPRnb(XCORL          ,0.0        ,""                                   ,"Length dependence of non-universality parameter")
`MPRnb(XCORW          ,0.0        ,""                                   ,"Width dependence of non-universality parameter")
`MPRnb(XCORLW         ,0.0        ,""                                   ,"Area dependence of non-universality parameter")
`MPRnb(STXCORO        ,0.0        ,""                                   ,"Temperature dependence of XCOR")
`MPRcz(FETAO          ,1.0        ,""                                   ,"Effective field parameter")

//  Intrinsic series-resistance parameters
`MPRnb(RSW1           ,50.0       ,"Ohm"                                ,"First order width dependence of source/drain series resistance at TR")
`MPRnb(RSW2           ,0.0        ,""                                   ,"Second order width dependence of source/drain series resistance at TR")
`MPRnb(STRSO          ,1.0        ,""                                   ,"Temperature dependence of RS")
`MPRcc(RSBO           ,0.0        ,"V^-1"     ,-0.5        ,1.0         ,"Bulk voltage dependence of series resistance")
`MPRco(RSGO           ,0.0        ,"V^-1"     ,-0.5        ,inf         ,"Gate voltage dependence of series resistance")

//  Velocity saturation parameters
`MPRnb(THESATO        ,0.0        ,"V^-1"                               ,"Geometry independent part of velocity saturation parameter at TR")
`MPRnb(THESATL        ,0.3        ,"V^-1"                               ,"Length dependence of velocity saturation parameter at TR")
`MPRnb(THESATLEXP     ,1.0        ,""                                   ,"Exponent for length dependence of velocity saturation parameter at TR")
`MPRnb(THESATW        ,0.0        ,""                                   ,"Width dependence of velocity saturation parameter at TR")
`MPRnb(THESATLW       ,0.0        ,""                                   ,"Area dependence of velocity saturation parameter at TR")
`MPRnb(STTHESATO      ,1.0        ,""                                   ,"Geometry independent part of temperature dependence of THESAT")
`MPRnb(STTHESATL      ,0.0        ,""                                   ,"Length dependence of temperature dependence of THESAT")
`MPRnb(STTHESATW      ,0.0        ,""                                   ,"Width dependence of temperature dependence of THESAT")
`MPRnb(STTHESATLW     ,0.0        ,""                                   ,"Area dependence of temperature dependence of THESAT")
`MPRcc(THESATBO       ,0.0        ,"V^-1"     ,-0.5        ,1.0         ,"Bulk voltage dependence of velocity saturation")
`MPRco(THESATGO       ,0.0        ,"V^-1"     ,-0.5        ,inf         ,"Gate voltage dependence of velocity saturation")
`MPRco(THESATTO       ,1.0        ,""         ,0.01        ,inf         ,"Threshold parameter of gate voltage dependence of velocity saturation")

//  Linear to saturation transition parameters
`MPRnb(AXO            ,16.0       ,""                                   ,"Geometry independent part of linear/saturation transition factor")
`MPRcz(AXL            ,1.0        ,""                                   ,"Length dependence of linear/saturation transition factor")

//  Channel length modulation parameters
`MPRnb(ALPL           ,1.0e-02    ,""                                   ,"Length dependence of CLM pre-factor")
`MPRnb(ALPLEXP        ,1.0        ,""                                   ,"Exponent for length dependence of CLM pre-factor")
`MPRnb(ALPW           ,0.0        ,""                                   ,"Width dependence of CLM pre-factor")
`MPRnb(ALP1L1         ,0.0        ,"V"                                  ,"First order Length dependence of CLM enhancement factor above threshold")
`MPRnb(ALP1LEXP       ,0.5        ,""                                   ,"Exponent for length dependence of CLM enhancement factor above threshold")
`MPRcz(ALP1L2         ,0.0        ,""                                   ,"Second order length dependence of CLM enhancement factor above threshold")
`MPRnb(ALP1W          ,0.0        ,""                                   ,"Width dependence of CLM enhancement factor above threshold")
`MPRnb(ALP2L1         ,0.0        ,"V^-1"                               ,"First order length dependence of CLM enhancement factor below threshold")
`MPRnb(ALP2LEXP       ,0.5        ,""                                   ,"Exponent for length dependence of CLM enhancement factor below threshold")
`MPRcz(ALP2L2         ,0.0        ,""                                   ,"Second order length dependence of CLM enhancement factor below threshold")
`MPRnb(ALP2W          ,0.0        ,""                                   ,"Width dependence of CLM enhancement factor below threshold")
`MPRco(VPO            ,0.05       ,"V"        ,1.0e-10     ,inf         ,"CLM logarithmic dependence parameter")

//  Weak-avalanche parameters
`MPRnb(A1O            ,1.0        ,""                                   ,"Geometry independent part of impact-ionization pre-factor")
`MPRnb(A1L            ,0.0        ,""                                   ,"Length dependence of impact-ionization pre-factor")
`MPRnb(A1W            ,0.0        ,""                                   ,"Width dependence of impact-ionization pre-factor")
`MPRcz(A2O            ,10.0       ,"V"                                  ,"Impact-ionization exponent at TR")
`MPRnb(STA2O          ,0.0        ,"V"                                  ,"Temperature dependence of A2")
`MPRnb(A3O            ,1.0        ,""                                   ,"Geometry independent part of saturation-voltage dependence of impact-ionization")
`MPRnb(A3L            ,0.0        ,""                                   ,"Length dependence of saturation-voltage dependence of impact-ionization")
`MPRnb(A3W            ,0.0        ,""                                   ,"Width dependence of saturation-voltage dependence of impact-ionization")
`MPRnb(A4O            ,0.0        ,"V^-0.5"                             ,"Geometry independent part of bulk voltage dependence of impact-ionization")
`MPRnb(A4L            ,0.0        ,""                                   ,"Length dependence of bulk voltage dependence of impact-ionization")
`MPRnb(A4W            ,0.0        ,""                                   ,"Width dependence of bulk voltage dependence of impact-ionization")
`MPRco(IMAXIIO        ,10.0       ,"A"        ,1e-12       ,inf         ,"Maximum impact-ionization current value")

//  Gate current parameters
`MPRcc(GCOO           ,0.0        ,""         ,-10.0       ,10.0        ,"Gate tunnelling energy adjustment")
`MPRcz(IGINVLW        ,0.0        ,"A"                                  ,"Area dependence of gate channel current pre-factor")
`MPRcz(IGOVW          ,0.0        ,"A"                                  ,"Width dependence of overlap current pre-factor")
`MPRcz(IGOVDW         ,0.0        ,"A"                                  ,"Width dependence of overlap current pre-factor for drain side")
`MPRnb(STIGO          ,2.0        ,""                                   ,"Temperature dependence of IGINV and IGOV")
`MPRcc(GC2O           ,0.375      ,""         ,0.0         ,10.0        ,"Gate current slope factor")
`MPRcc(GC3O           ,0.063      ,""         ,-2.0        ,2.0         ,"Gate current curvature factor")
`MPRcc(GC2OVO         ,0.375      ,""         ,0.0         ,10.0        ,"Gate overlap current slope factor")
`MPRcc(GC3OVO         ,0.063      ,""         ,-2.0        ,2.0         ,"Gate overlap current curvature factor")
`MPRcc(GC2OVDO        ,0.375      ,""         ,0.0         ,10.0        ,"Gate overlap current slope factor for drain side")
`MPRcc(GC3OVDO        ,0.063      ,""         ,-2.0        ,2.0         ,"Gate overlap current curvature factor for drain side")
`MPRco(CHIBO          ,3.1        ,"V"        ,1.0         ,inf         ,"Tunnelling barrier height")

//  Gate induced drain/source leakage parameters
`MPRcz(AGIDLW         ,0.0        ,"A/V^3"                              ,"Width dependence of GIDL pre-factor")
`MPRcz(AGIDLDW        ,0.0        ,"A/V^3"                              ,"Width dependence of GIDL pre-factor for drain side")
`MPRcz(BGIDLO         ,41.0       ,"V"                                  ,"GIDL probability factor at TR")
`MPRcz(BGIDLDO        ,41.0       ,"V"                                  ,"GIDL probability factor at TR for drain side")
`MPRnb(STBGIDLO       ,0.0        ,"V/K"                                ,"Temperature dependence of BGIDL")
`MPRnb(STBGIDLDO      ,0.0        ,"V/K"                                ,"Temperature dependence of BGIDLD")
`MPRnb(CGIDLO         ,0.0        ,""                                   ,"Bulk voltage dependence of GIDL")
`MPRnb(CGIDLDO        ,0.0        ,""                                   ,"Bulk voltage dependence of GIDL for drain side")

//  Charge model parameters
`MPRnb(DELVTACO       ,0.0        ,"V"                                  ,"Geometry independent part of PHIB offset in separate charge calculation (SWDELVTAC=1)")
`MPRnb(DELVTACL       ,0.0        ,"V"                                  ,"Length dependence of PHIB offset in separate charge calculation (SWDELVTAC=1)")
`MPRnb(DELVTACLEXP    ,1.0        ,""                                   ,"Exponent for length dependence of PHIB offset in separate charge calculation (SWDELVTAC=1)")
`MPRnb(DELVTACW       ,0.0        ,"V"                                  ,"Width dependence of PHIB offset in separate charge calculation (SWDELVTAC=1)")
`MPRnb(DELVTACLW      ,0.0        ,"V"                                  ,"Area dependence of PHIB offset in separate charge calculation (SWDELVTAC=1)")
`MPRnb(FACNEFFACO     ,1.0        ,""                                   ,"Geometry independent part of pre-factor for effective substrate doping in separate charge calculation (SWDELVTAC=1)")
`MPRnb(FACNEFFACL     ,0.0        ,""                                   ,"Length dependence of pre-factor for effective substrate doping in separate charge calculation (SWDELVTAC=1)")
`MPRnb(FACNEFFACW     ,0.0        ,""                                   ,"Width dependence of pre-factor for effective substrate doping in separate charge calculation (SWDELVTAC=1)")
`MPRnb(FACNEFFACLW    ,0.0        ,""                                   ,"Area dependence of pre-factor for effective substrate doping in separate charge calculation (SWDELVTAC=1)")
`MPRnb(THESATACO      ,0.0        ,"V^-1"                               ,"Geometry independent velocity saturation parameter at TR of charge model when SWQSAT=1")
`MPRnb(THESATACL      ,0.1        ,"V^-1"                               ,"Length dependence of velocity saturation parameter at TR of the charge model when SWQSAT=1")
`MPRnb(THESATACLEXP   ,1.0        ,""                                   ,"Exponent for length dependence of velocity saturation parameter at TR of the charge model when SWQSAT=1")
`MPRnb(THESATACW      ,0.0        ,""                                   ,"Width dependence of velocity saturation parameter at TR of the charge model when SWQSAT=1")
`MPRnb(THESATACLW     ,0.0        ,""                                   ,"Area dependence of velocity saturation parameter at TR of the charge model when SWQSAT=1")
`MPRnb(AXACO          ,16.0       ,""                                   ,"Geometry independent linear/saturation transition factor of charge model when SWQSAT=1")
`MPRcz(AXACL          ,1.0        ,""                                   ,"Length dependence of linear/saturation transition factor of the charge model when SWQSAT=1")
`MPRnb(ALPACL         ,0.0        ,""                                   ,"Length dependence of CLM pre-factor of the charge model when SWQSAT=1")
`MPRnb(ALPACLEXP      ,1.0        ,""                                   ,"Exponent for length dependence of linear/saturation transition factor of the charge model when SWQSAT=1")
`MPRnb(ALPACW         ,0.0        ,""                                   ,"Width dependence of linear/saturation transition factor of the charge model when SWQSAT=1")
`MPRnb(ALP1ACL1       ,0.0        ,"V"                                  ,"Length dependence of CLM pre-factor of the charge model")
`MPRnb(ALP1ACLEXP     ,0.5        ,""                                   ,"Exponent for length dependence of CLM pre-factor of the charge model")
`MPRcz(ALP1ACL2       ,0.0        ,""                                   ,"Second_order length dependence of CLM pre-factor of the charge model")
`MPRnb(ALP1ACW        ,0.0        ,""                                   ,"Width dependence of CLM pre-factor of the charge model")
`MPRcc(FCGOVACCO      ,0.5        ,""         ,0.0         ,1.0         ,"Factor for overlap capacitances in accumulation regime")
`MPRcc(FCGOVACCDO     ,0.5        ,""         ,0.0         ,1.0         ,"Factor for overlap capacitances in accumulation regime for drain side")
`MPRcc(CGOVACCGO      ,1.0        ,""         ,0.1         ,1.0         ,"Gate voltage dependence parameter of overlap capacitances in accumulation regime")
`MPRcz(CGBOVL         ,1.0e-15    ,"F"                                  ,"Length dependence of oxide capacitance for gate-bulk overlap")
`MPRcz(CINRW          ,5.0e-16    ,"F"                                  ,"Width dependence of inner fringe capacitance")
`MPRcz(CINRDW         ,5.0e-16    ,"F"                                  ,"Width dependence of inner fringe capacitance for drain side")
`MPRnb(DVFBINRO       ,0.0        ,"V"                                  ,"Flat-band voltage offset of inner fringe capacitances")
`MPRcc(FCINRDEPO      ,0.3        ,""         ,0.0         ,1.0         ,"Bias dependence parameter of inner fringe capacitances in depletion regime")
`MPRcz(FCINRACCO      ,0.5        ,""                                   ,"Bias dependence parameter of inner fringe capacitances in accumulation regime")
`MPRcc(AXINRO         ,0.4        ,""         ,0.1         ,4.0         ,"Accumulation/depletion transition factor of inner fringe capacitances")
`MPRcz(CFRW           ,1.0e-15    ,"F"                                  ,"Width dependence of outer fringe capacitance")
`MPRcz(CFRDW          ,1.0e-15    ,"F"                                  ,"Width dependence of outer fringe capacitance for drain side")

//  Noise model parameters
`MPRcz(FNTO           ,1.0        ,""                                   ,"Thermal noise coefficient")
`MPRcz(FNTEXCL        ,0.0        ,""                                   ,"Length dependence of excess noise coefficient")
`MPRcz(NFALW          ,8.0e22     ,"V^-1/m^4"                           ,"Area dependence of first coefficient of flicker noise")
`MPRcz(NFBLW          ,3.0e07     ,"V^-1/m^2"                           ,"Area dependence of second coefficient of flicker noise")
`MPRcz(NFCLW          ,0.0        ,"V^-1"                               ,"Area dependence of third coefficient of flicker noise")
`MPRcz(EFO            ,1.0        ,""                                   ,"Flicker noise frequency exponent")
`MPRnb(LINTNOI        ,0.0        ,"m"                                  ,"Length offset for flicker noise")
`MPRnb(ALPNOI         ,2.0        ,""                                   ,"Exponent for length offset for flicker noise")

//  Edge transistor parameters
`MPRcz(WEDGE          ,1.0e-08    ,"m"                                  ,"Electrical width of edge transistor per side")
`MPRcz(WEDGEW         ,0.0        ,""                                   ,"Width dependence of edge WEDGE")
`MPRnb(VFBEDGEO       ,-1.0       ,"V"                                  ,"Flat-band voltage of edge transistors at TR")
`MPRnb(STVFBEDGEO     ,5.0e-04    ,"V/K"                                ,"Geometry-independent part of temperature dependence of VFBEDGE")
`MPRnb(STVFBEDGEL     ,0.0        ,"V/K"                                ,"Length dependence of temperature dependence of VFBEDGE")
`MPRnb(STVFBEDGEW     ,0.0        ,"V/K"                                ,"Width dependence of temperature dependence of VFBEDGE")
`MPRnb(STVFBEDGELW    ,0.0        ,"V/K"                                ,"Area dependence of temperature dependence of VFBEDGE")
`MPRnb(DPHIBEDGEO     ,0.0        ,"V"                                  ,"Geometry independent part of PHIB offset for edge transistors")
`MPRnb(DPHIBEDGEL     ,0.0        ,"V"                                  ,"Length dependence of PHIB offset for edge transistors")
`MPRnb(DPHIBEDGELEXP  ,1.0        ,""                                   ,"Exponent for length dependence of PHIB offset for edge transistors")
`MPRnb(DPHIBEDGEW     ,0.0        ,"V"                                  ,"Width dependence of PHIB offset for edge transistors")
`MPRnb(DPHIBEDGELW    ,0.0        ,"V"                                  ,"Area dependence of PHIB offset for edge transistors")
`MPRco(NSUBEDGEO      ,5.0e23     ,"m^-3"     ,1.0e20      ,inf         ,"Geometry independent part of effective substrate doping of edge transistors")
`MPRnb(NSUBEDGEL      ,0.0        ,""                                   ,"Length dependence of effective substrate doping of edge transistors")
`MPRnb(NSUBEDGELEXP   ,1.0        ,""                                   ,"Exponent for length dependence of effective substrate doping of edge transistors")
`MPRnb(NSUBEDGEW      ,0.0        ,""                                   ,"Width dependence of effective substrate doping of edge transistors")
`MPRnb(NSUBEDGELW     ,0.0        ,""                                   ,"Area dependence of effective substrate doping of edge transistors")
`MPRnb(CTEDGEO        ,0.0        ,""                                   ,"Geometry independent part of interface states factor of edge transistors")
`MPRnb(CTEDGEL        ,0.0        ,""                                   ,"Length dependence of interface states factor of edge transistors")
`MPRnb(CTEDGELEXP     ,1.0        ,""                                   ,"Exponent for length dependence of interface states factor of edge transistors")
`MPRnb(FBETEDGE       ,0.0        ,""                                   ,"Length dependence of edge transistors mobility")
`MPRco(LPEDGE         ,1.0e-08    ,"m"        ,1.0e-10     ,inf         ,"Exponent for length dependence of edge transistors mobility")
`MPRnb(BETEDGEW       ,0.0        ,""                                   ,"Width scaling coefficient of edge transistors mobility")
`MPRnb(STBETEDGEO     ,1.0        ,""                                   ,"Geometry independent part of temperature dependence of BETNEDGE")
`MPRnb(STBETEDGEL     ,0.0        ,""                                   ,"Length dependence of temperature dependence of BETNEDGE")
`MPRnb(STBETEDGEW     ,0.0        ,""                                   ,"Width dependence of temperature dependence of BETNEDGE")
`MPRnb(STBETEDGELW    ,0.0        ,""                                   ,"Area dependence of temperature dependence of BETNEDGE")
`MPRnb(PSCEEDGEL      ,0.0        ,""                                   ,"Length dependence of subthreshold slope coefficient for short channel edge transistors")
`MPRnb(PSCEEDGELEXP   ,2.0        ,""                                   ,"Exponent for length dependence of subthreshold slope coefficient for short channel edge transistors")
`MPRnb(PSCEEDGEW      ,0.0        ,""                                   ,"Exponent for length dependence of subthreshold slope coefficient for short channel edge transistor")
`MPRcc(PSCEBEDGEO     ,0.0        ,"V^-1"     ,0.0         ,1.0         ,"Bulk voltage dependence parameter of subthreshold slope coefficient for short channel edge transistors")
`MPRcz(PSCEDEDGEO     ,0.0        ,"V^-1"                               ,"Drain voltage dependence parameter of subthreshold slope coefficient for short channel edge transistors")
`MPRnb(CFEDGEL        ,0.0        ,""                                   ,"Length dependence of DIBL of edge transistors")
`MPRnb(CFEDGELEXP     ,2.0        ,""                                   ,"Exponent for length dependence of DIBL of edge transistors")
`MPRnb(CFEDGEW        ,0.0        ,""                                   ,"Width dependence of DIBL of edge transistors")
`MPRcc(CFBEDGEO       ,0.0        ,"V^-1"     ,0.0         ,1.0         ,"Bulk voltage dependence parameter of DIBL of edge transistors")
`MPRcz(CFDEDGEO       ,0.0        ,"V^-1"                               ,"Drain voltage dependence parameter of DIBL of edge transistors")
`MPRcz(FNTEDGEO       ,1.0        ,""                                   ,"Thermal noise coefficient of edge transistors")
`MPRcz(NFAEDGELW      ,8.0e22     ,"V^-1/m^4"                           ,"Area dependence of first coefficient of flicker noise of edge transistors")
`MPRcz(NFBEDGELW      ,3.0e07     ,"V^-1/m^2"                           ,"Area dependence of second coefficient of flicker noise of edge transistors")
`MPRcz(NFCEDGELW      ,0.0        ,"V^-1"                               ,"Area dependence of third coefficient of flicker noise of edge transistors")
`MPRcz(EFEDGEO        ,1.0        ,""                                   ,"Flicker noise frequency exponent of edge transistors")

//  Parasitic resistance parameters
`MPRnb(RGO            ,0.0        ,"Ohm"                                ,"Gate resistance")
`MPRcz(RINT           ,0.0        ,"Ohm m^2"                            ,"Contact resistance between silicide and poly")
`MPRcz(RVPOLY         ,0.0        ,"Ohm m^2"                            ,"Vertical poly resistance")
`MPRcz(RSHG           ,0.0        ,"Ohm/sq"                             ,"Gate electrode diffusion sheet resistance")
`MPRnb(DLSIL          ,0.0        ,"m"                                  ,"Silicide extension over the physical gate length")
`MPRcz(RSH            ,0.0        ,"Ohm/sq"                             ,"Sheet resistance of source diffusion")
`MPRcz(RSHD           ,0.0        ,"Ohm/sq"                             ,"Sheet resistance of drain diffusion")
`MPRcz(RBULKO         ,0.0        ,"Ohm"                                ,"Bulk resistance between node BP and BI")
`MPRcz(RWELLO         ,0.0        ,"Ohm"                                ,"Well resistance between node BI and B")
`MPRcz(RJUNSO         ,0.0        ,"Ohm"                                ,"Source-side bulk resistance between node BI and BS")
`MPRcz(RJUNDO         ,0.0        ,"Ohm"                                ,"Drain-side bulk resistance between node BI and BD")

//  Self heating effect parameters
`ifdef SelfHeating
`MPRnb(RTHO           ,0.0        ,"K/W"                                ,"Geometry independent part of thermal resistance")
`MPRnb(RTHW1          ,0.0        ,"K/W"                                ,"Width dependence of thermal resistance")
`MPRnb(RTHW2          ,0.0        ,""                                   ,"Offset in width dependence of thermal resistance")
`MPRnb(RTHLW          ,0.0        ,""                                   ,"Length-correction to width dependence of thermal resistance")
`MPRnb(CTHO           ,0.0        ,"J/K"                                ,"Geometry independent part of thermal capacitance")
`MPRnb(CTHW1          ,0.0        ,"J/K"                                ,"Width dependence of thermal capacitance")
`MPRnb(CTHW2          ,0.0        ,""                                   ,"Offset in width dependence of thermal capacitance")
`MPRnb(CTHLW          ,0.0        ,""                                   ,"Length-correction to width dependence of thermal capacitance")
`MPRnb(STRTHO         ,0.0        ,""                                   ,"Temperature sensitivity of RTH")
`endif // SelfHeating

//  NQS parameters
`ifdef NQSmodel
`MPRcz(MUNQSO         ,1.0        ,""                                   ,"Relative mobility for NQS modelling")
`endif // NQSmodel

//  --------------------------------------------------------------------------------------------------------------
//  Binning model parameters
//  --------------------------------------------------------------------------------------------------------------

//  Flat-band voltage parameters
`MPRnb(POVFB          ,-1.0       ,"V"                                  ,"Binning parameter of the geometry independent part of VFB")
`MPRnb(PLVFB          ,0.0        ,"V"                                  ,"Binning parameter of the length dependence of VFB")
`MPRnb(PWVFB          ,0.0        ,"V"                                  ,"Binning parameter of the width dependence of VFB")
`MPRnb(PLWVFB         ,0.0        ,"V"                                  ,"Binning parameter of the area dependence of VFB")
`MPRnb(POSTVFB        ,5.0e-04    ,"V/K"                                ,"Binning parameter of the geometry independent part of STVFB")
`MPRnb(PLSTVFB        ,0.0        ,"V/K"                                ,"Binning parameter of the length dependence of STVFB")
`MPRnb(PWSTVFB        ,0.0        ,"V/K"                                ,"Binning parameter of the width dependence of STVFB")
`MPRnb(PLWSTVFB       ,0.0        ,"V/K"                                ,"Binning parameter of the area dependence of STVFB")

//  Process parameters
`MPRnb(PONEFF         ,5.0e23     ,"m^-3"                               ,"Binning parameter of the geometry independent part of NEFF")
`MPRnb(PLNEFF         ,0.0        ,"m^-3"                               ,"Binning parameter of the length dependence of NEFF")
`MPRnb(PWNEFF         ,0.0        ,"m^-3"                               ,"Binning parameter of the width dependence of NEFF")
`MPRnb(PLWNEFF        ,0.0        ,"m^-3"                               ,"Binning parameter of the area dependence of NEFF")
`MPRnb(POGFACNUD      ,1.0        ,""                                   ,"Binning parameter of the geometry independent part of GFACNUD")
`MPRnb(PLGFACNUD      ,0.0        ,""                                   ,"Binning parameter of the length dependence of GFACNUD")
`MPRnb(PWGFACNUD      ,0.0        ,""                                   ,"Binning parameter of the width dependence of GFACNUD")
`MPRnb(PLWGFACNUD     ,0.0        ,""                                   ,"Binning parameter of the area dependence of GFACNUD")
`MPRnb(POVSBNUD       ,0.0        ,"V"                                  ,"Binning parameter of the geometry independent part of VSBNUD")
`MPRnb(PLVSBNUD       ,0.0        ,"V"                                  ,"Binning parameter of the length dependence of VSBNUD")
`MPRnb(PWVSBNUD       ,0.0        ,"V"                                  ,"Binning parameter of the width dependence of VSBNUD")
`MPRnb(PLWVSBNUD      ,0.0        ,"V"                                  ,"Binning parameter of the area dependence of VSBNUD")
`MPRnb(PODPHIB        ,0.0        ,"V"                                  ,"Binning parameter of the geometry independent part of DPHIB")
`MPRnb(PLDPHIB        ,0.0        ,"V"                                  ,"Binning parameter of the length dependence of DPHIB")
`MPRnb(PWDPHIB        ,0.0        ,"V"                                  ,"Binning parameter of the width dependence of DPHIB")
`MPRnb(PLWDPHIB       ,0.0        ,"V"                                  ,"Binning parameter of the area dependence of DPHIB")
`MPRnb(PONP           ,1.0e26     ,"m^-3"                               ,"Binning parameter of the geometry independent part of NP")
`MPRnb(PLNP           ,0.0        ,"m^-3"                               ,"Binning parameter of the length dependence of NP")
`MPRnb(PWNP           ,0.0        ,"m^-3"                               ,"Binning parameter of the width dependence of NP")
`MPRnb(PLWNP          ,0.0        ,"m^-3"                               ,"Binning parameter of the area dependence of NP")
`MPRnb(PONOV          ,5.0e25     ,"m^-3"                               ,"Binning parameter of the geometry independent part of NOV")
`MPRnb(PLNOV          ,0.0        ,"m^-3"                               ,"Binning parameter of the length dependence of NOV")
`MPRnb(PWNOV          ,0.0        ,"m^-3"                               ,"Binning parameter of the width dependence of NOV")
`MPRnb(PLWNOV         ,0.0        ,"m^-3"                               ,"Binning parameter of the area dependence of NOV")
`MPRnb(PONOVD         ,5.0e25     ,"m^-3"                               ,"Binning parameter of the geometry independent part of NOVD")
`MPRnb(PLNOVD         ,0.0        ,"m^-3"                               ,"Binning parameter of the length dependence of NOVD")
`MPRnb(PWNOVD         ,0.0        ,"m^-3"                               ,"Binning parameter of the width dependence of NOVD")
`MPRnb(PLWNOVD        ,0.0        ,"m^-3"                               ,"Binning parameter of the area dependence of NOVD")

//  Interface states parameters
`MPRnb(POCT           ,0.0        ,""                                   ,"Binning parameter of the geometry independent part of CT")
`MPRnb(PLCT           ,0.0        ,""                                   ,"Binning parameter of the length dependence of CT")
`MPRnb(PWCT           ,0.0        ,""                                   ,"Binning parameter of the width dependence of CT")
`MPRnb(PLWCT          ,0.0        ,""                                   ,"Binning parameter of the area dependence of CT")
`MPRnb(POCTB          ,0.0        ,""                                   ,"Binning parameter of the geometry independent part of CTB")
`MPRnb(PLCTB          ,0.0        ,""                                   ,"Binning parameter of the length dependence of CTB")
`MPRnb(PWCTB          ,0.0        ,""                                   ,"Binning parameter of the width dependence of CTB")
`MPRnb(PLWCTB         ,0.0        ,""                                   ,"Binning parameter of the area dependence of CTB")
`MPRnb(POCTG          ,0.0        ,""                                   ,"Binning parameter of the geometry independent part of CTG")
`MPRnb(PLCTG          ,0.0        ,""                                   ,"Binning parameter of the length dependence of CTG")
`MPRnb(PWCTG          ,0.0        ,""                                   ,"Binning parameter of the width dependence of CTG")
`MPRnb(PLWCTG         ,0.0        ,""                                   ,"Binning parameter of the area dependence of CTG")
`MPRnb(POSTCT         ,1.0        ,""                                   ,"Binning parameter of the geometry independent part of STCT")
`MPRnb(PLSTCT         ,0.0        ,""                                   ,"Binning parameter of the length dependence of STCT")
`MPRnb(PWSTCT         ,0.0        ,""                                   ,"Binning parameter of the width dependence of STCT")
`MPRnb(PLWSTCT        ,0.0        ,""                                   ,"Binning parameter of the area dependence of STCT")

//  DIBL parameters
`MPRnb(POCF           ,0.0        ,""                                   ,"Binning parameter of the geometry independent part of CF")
`MPRnb(PLCF           ,0.0        ,""                                   ,"Binning parameter of the length dependence of CF")
`MPRnb(PWCF           ,0.0        ,""                                   ,"Binning parameter of the width dependence of CF")
`MPRnb(PLWCF          ,0.0        ,""                                   ,"Binning parameter of the area dependence of CF")
`MPRnb(POCFB          ,0.0        ,"V^-1"                               ,"Binning parameter of the geometry independent part of CFB")
`MPRnb(PLCFB          ,0.0        ,"V^-1"                               ,"Binning parameter of the length dependence of CFB")
`MPRnb(PWCFB          ,0.0        ,"V^-1"                               ,"Binning parameter of the width dependence of CFB")
`MPRnb(PLWCFB         ,0.0        ,"V^-1"                               ,"Binning parameter of the area dependence of CFB")
`MPRnb(POCFD          ,0.0        ,"V^-1"                               ,"Binning parameter of the geometry independent part of CFD")
`MPRnb(PLCFD          ,0.0        ,"V^-1"                               ,"Binning parameter of the length dependence of CFD")
`MPRnb(PWCFD          ,0.0        ,"V^-1"                               ,"Binning parameter of the width dependence of CFD")
`MPRnb(PLWCFD         ,0.0        ,"V^-1"                               ,"Binning parameter of the area dependence of CFD")

//  Subthreshold slope parameters of short channel transistor
`MPRnb(POPSCE         ,0.0        ,""                                   ,"Binning parameter of the geometry independent part of PSCE")
`MPRnb(PLPSCE         ,0.0        ,""                                   ,"Binning parameter of the length dependence of PSCE")
`MPRnb(PWPSCE         ,0.0        ,""                                   ,"Binning parameter of the width dependence of PSCE")
`MPRnb(PLWPSCE        ,0.0        ,""                                   ,"Binning parameter of the area dependence of PSCE")
`MPRnb(POPSCEB        ,0.0        ,"V^-1"                               ,"Binning parameter of the geometry independent part of PSCEB")
`MPRnb(PLPSCEB        ,0.0        ,"V^-1"                               ,"Binning parameter of the length dependence of PSCEB")
`MPRnb(PWPSCEB        ,0.0        ,"V^-1"                               ,"Binning parameter of the width dependence of PSCEB")
`MPRnb(PLWPSCEB       ,0.0        ,"V^-1"                               ,"Binning parameter of the area dependence of PSCEB")
`MPRnb(POPSCED        ,0.0        ,"V^-1"                               ,"Binning parameter of the geometry independent part of PSCED")
`MPRnb(PLPSCED        ,0.0        ,"V^-1"                               ,"Binning parameter of the length dependence of PSCED")
`MPRnb(PWPSCED        ,0.0        ,"V^-1"                               ,"Binning parameter of the width dependence of PSCED")
`MPRnb(PLWPSCED       ,0.0        ,"V^-1"                               ,"Binning parameter of the area dependence of PSCED")

//  Mobility parameters
`MPRnb(POBETN         ,3.0e-02    ,"m^2/V/s"                            ,"Binning parameter of the geometry independent part of BETN")
`MPRnb(PLBETN         ,0.0        ,"m^2/V/s"                            ,"Binning parameter of the length dependence of BETN")
`MPRnb(PWBETN         ,0.0        ,"m^2/V/s"                            ,"Binning parameter of the width dependence of BETN")
`MPRnb(PLWBETN        ,0.0        ,"m^2/V/s"                            ,"Binning parameter of the area dependence of BETN")
`MPRnb(POSTBET        ,1.0        ,""                                   ,"Binning parameter of the geometry independent part of STBET")
`MPRnb(PLSTBET        ,0.0        ,""                                   ,"Binning parameter of the length dependence of STBET")
`MPRnb(PWSTBET        ,0.0        ,""                                   ,"Binning parameter of the width dependence of STBET")
`MPRnb(PLWSTBET       ,0.0        ,""                                   ,"Binning parameter of the area dependence of STBET")
`MPRnb(POMUE          ,0.5        ,"m/V"                                ,"Binning parameter of the geometry independent part of MUE")
`MPRnb(PLMUE          ,0.0        ,"m/V"                                ,"Binning parameter of the length dependence of MUE")
`MPRnb(PWMUE          ,0.0        ,"m/V"                                ,"Binning parameter of the width dependence of MUE")
`MPRnb(PLWMUE         ,0.0        ,"m/V"                                ,"Binning parameter of the area dependence of MUE")
`MPRnb(POTHEMU        ,1.5        ,""                                   ,"Binning parameter of the geometry independent part of THEMU")
`MPRnb(PLTHEMU        ,0.0        ,""                                   ,"Binning parameter of the length dependence of THEMU")
`MPRnb(PWTHEMU        ,0.0        ,""                                   ,"Binning parameter of the width dependence of THEMU")
`MPRnb(PLWTHEMU       ,0.0        ,""                                   ,"Binning parameter of the area dependence of THEMU")
`MPRnb(POCS           ,0.0        ,""                                   ,"Binning parameter of the geometry independent part of CS")
`MPRnb(PLCS           ,0.0        ,""                                   ,"Binning parameter of the length dependence of CS")
`MPRnb(PWCS           ,0.0        ,""                                   ,"Binning parameter of the width dependence of CS")
`MPRnb(PLWCS          ,0.0        ,""                                   ,"Binning parameter of the area dependence of CS")
`MPRnb(POTHECS        ,2.0        ,""                                   ,"Binning parameter of the geometry independent part of THECS")
`MPRnb(PLTHECS        ,0.0        ,""                                   ,"Binning parameter of the length dependence of THECS")
`MPRnb(PWTHECS        ,0.0        ,""                                   ,"Binning parameter of the width dependence of THECS")
`MPRnb(PLWTHECS       ,0.0        ,""                                   ,"Binning parameter of the area dependence of THECS")
`MPRnb(POXCOR         ,0.0        ,"V^-1"                               ,"Binning parameter of the geometry independent part of XCOR")
`MPRnb(PLXCOR         ,0.0        ,"V^-1"                               ,"Binning parameter of the length dependence of XCOR")
`MPRnb(PWXCOR         ,0.0        ,"V^-1"                               ,"Binning parameter of the width dependence of XCOR")
`MPRnb(PLWXCOR        ,0.0        ,"V^-1"                               ,"Binning parameter of the area dependence of XCOR")

//  Intrinsic series resistance parameters
`MPRnb(PORS           ,50.0       ,"Ohm"                                ,"Binning parameter of the geometry independent part of RS")
`MPRnb(PLRS           ,0.0        ,"Ohm"                                ,"Binning parameter of the length dependence of RS")
`MPRnb(PWRS           ,0.0        ,"Ohm"                                ,"Binning parameter of the width dependence of RS")
`MPRnb(PLWRS          ,0.0        ,"Ohm"                                ,"Binning parameter of the area dependence of RS")
`MPRnb(POSTRS         ,1.0        ,""                                   ,"Binning parameter of the geometry independent part of STRS")
`MPRnb(PLSTRS         ,0.0        ,""                                   ,"Binning parameter of the length dependence of STRS")
`MPRnb(PWSTRS         ,0.0        ,""                                   ,"Binning parameter of the width dependence of STRS")
`MPRnb(PLWSTRS        ,0.0        ,""                                   ,"Binning parameter of the area dependence of STRS")
`MPRnb(PORSB          ,0.0        ,"V^-1"                               ,"Binning parameter of the geometry independent part of RSB")
`MPRnb(PLRSB          ,0.0        ,"V^-1"                               ,"Binning parameter of the length dependence of RSB")
`MPRnb(PWRSB          ,0.0        ,"V^-1"                               ,"Binning parameter of the width dependence of RSB")
`MPRnb(PLWRSB         ,0.0        ,"V^-1"                               ,"Binning parameter of the area dependence of RSB")
`MPRnb(PORSG          ,0.0        ,"V^-1"                               ,"Binning parameter of the geometry independent part of RSG")
`MPRnb(PLRSG          ,0.0        ,"V^-1"                               ,"Binning parameter of the length dependence of RSG")
`MPRnb(PWRSG          ,0.0        ,"V^-1"                               ,"Binning parameter of the width dependence of RSG")
`MPRnb(PLWRSG         ,0.0        ,"V^-1"                               ,"Binning parameter of the area dependence of RSG")

//  Velocity saturation parameters
`MPRnb(POTHESAT       ,0.3        ,"V^-1"                               ,"Binning parameter of the geometry independent part of THESAT")
`MPRnb(PLTHESAT       ,0.0        ,"V^-1"                               ,"Binning parameter of the length dependence of THESAT")
`MPRnb(PWTHESAT       ,0.0        ,"V^-1"                               ,"Binning parameter of the width dependence of THESAT")
`MPRnb(PLWTHESAT      ,0.0        ,"V^-1"                               ,"Binning parameter of the area dependence of THESAT")
`MPRnb(POSTTHESAT     ,1.0        ,""                                   ,"Binning parameter of the geometry independent part of STTHESAT")
`MPRnb(PLSTTHESAT     ,0.0        ,""                                   ,"Binning parameter of the length dependence of STTHESAT")
`MPRnb(PWSTTHESAT     ,0.0        ,""                                   ,"Binning parameter of the width dependence of STTHESAT")
`MPRnb(PLWSTTHESAT    ,0.0        ,""                                   ,"Binning parameter of the area dependence of STTHESAT")
`MPRnb(POTHESATB      ,0.0        ,"V^-1"                               ,"Binning parameter of the geometry independent part of THESATB")
`MPRnb(PLTHESATB      ,0.0        ,"V^-1"                               ,"Binning parameter of the length dependence of THESATB")
`MPRnb(PWTHESATB      ,0.0        ,"V^-1"                               ,"Binning parameter of the width dependence of THESATB")
`MPRnb(PLWTHESATB     ,0.0        ,"V^-1"                               ,"Binning parameter of the area dependence of THESATB")
`MPRnb(POTHESATG      ,0.0        ,"V^-1"                               ,"Binning parameter of the geometry independent part of THESATG")
`MPRnb(PLTHESATG      ,0.0        ,"V^-1"                               ,"Binning parameter of the length dependence of THESATG")
`MPRnb(PWTHESATG      ,0.0        ,"V^-1"                               ,"Binning parameter of the width dependence of THESATG")
`MPRnb(PLWTHESATG     ,0.0        ,"V^-1"                               ,"Binning parameter of the area dependence of THESATG")

//  Linear to saturation transition parameters
`MPRnb(POAX           ,8.0        ,""                                   ,"Binning parameter of the geometry independent part of AX")
`MPRnb(PLAX           ,0.0        ,""                                   ,"Binning parameter of the length dependence of AX")
`MPRnb(PWAX           ,0.0        ,""                                   ,"Binning parameter of the width dependence of AX")
`MPRnb(PLWAX          ,0.0        ,""                                   ,"Binning parameter of the area dependence of AX")

//  Channel length modulation parameters
`MPRnb(POALP          ,1.0e-02    ,""                                   ,"Binning parameter of the geometry independent part of ALP")
`MPRnb(PLALP          ,0.0        ,""                                   ,"Binning parameter of the length dependence of ALP")
`MPRnb(PWALP          ,0.0        ,""                                   ,"Binning parameter of the width dependence of ALP")
`MPRnb(PLWALP         ,0.0        ,""                                   ,"Binning parameter of the area dependence of ALP")
`MPRnb(POALP1         ,0.0        ,"V"                                  ,"Binning parameter of the geometry independent part of ALP1")
`MPRnb(PLALP1         ,0.0        ,"V"                                  ,"Binning parameter of the length dependence of ALP1")
`MPRnb(PWALP1         ,0.0        ,"V"                                  ,"Binning parameter of the width dependence of ALP1")
`MPRnb(PLWALP1        ,0.0        ,"V"                                  ,"Binning parameter of the area dependence of ALP1")
`MPRnb(POALP2         ,0.0        ,"V^-1"                               ,"Binning parameter of the geometry independent part of ALP2")
`MPRnb(PLALP2         ,0.0        ,"V^-1"                               ,"Binning parameter of the length dependence of ALP2")
`MPRnb(PWALP2         ,0.0        ,"V^-1"                               ,"Binning parameter of the width dependence of ALP2")
`MPRnb(PLWALP2        ,0.0        ,"V^-1"                               ,"Binning parameter of the area dependence of ALP2")

//  Impact ionization parameters
`MPRnb(POA1           ,1.0        ,""                                   ,"Binning parameter of the geometry independent part of A1")
`MPRnb(PLA1           ,0.0        ,""                                   ,"Binning parameter of the length dependence of A1")
`MPRnb(PWA1           ,0.0        ,""                                   ,"Binning parameter of the width dependence of A1")
`MPRnb(PLWA1          ,0.0        ,""                                   ,"Binning parameter of the area dependence of A1")
`MPRnb(POSTA2         ,0.0        ,""                                   ,"Binning parameter of the geometry independent part of STA2")
`MPRnb(PLSTA2         ,0.0        ,""                                   ,"Binning parameter of the length dependence of STA2")
`MPRnb(PWSTA2         ,0.0        ,""                                   ,"Binning parameter of the width dependence of STA2")
`MPRnb(PLWSTA2        ,0.0        ,""                                   ,"Binning parameter of the area dependence of STA2")
`MPRnb(POA3           ,1.0        ,""                                   ,"Binning parameter of the geometry independent part of A3")
`MPRnb(PLA3           ,0.0        ,""                                   ,"Binning parameter of the length dependence of A3")
`MPRnb(PWA3           ,0.0        ,""                                   ,"Binning parameter of the width dependence of A3")
`MPRnb(PLWA3          ,0.0        ,""                                   ,"Binning parameter of the area dependence of A3")
`MPRnb(POA4           ,0.0        ,"V^-0.5"                             ,"Binning parameter of the geometry independent part of A4")
`MPRnb(PLA4           ,0.0        ,"V^-0.5"                             ,"Binning parameter of the length dependence of A4")
`MPRnb(PWA4           ,0.0        ,"V^-0.5"                             ,"Binning parameter of the width dependence of A4")
`MPRnb(PLWA4          ,0.0        ,"V^-0.5"                             ,"Binning parameter of the area dependence of A4")

//  Gate current parameters
`MPRnb(POIGINV        ,0.0        ,"A"                                  ,"Binning parameter of the geometry independent part of IGINV")
`MPRnb(PLIGINV        ,0.0        ,"A"                                  ,"Binning parameter of the length dependence of IGINV")
`MPRnb(PWIGINV        ,0.0        ,"A"                                  ,"Binning parameter of the width dependence of IGINV")
`MPRnb(PLWIGINV       ,0.0        ,"A"                                  ,"Binning parameter of the area dependence of IGINV")
`MPRnb(POIGOV         ,0.0        ,"A"                                  ,"Binning parameter of the geometry independent part of IGOV")
`MPRnb(PLIGOV         ,0.0        ,"A"                                  ,"Binning parameter of the length dependence of IGOV")
`MPRnb(PWIGOV         ,0.0        ,"A"                                  ,"Binning parameter of the width dependence of IGOV")
`MPRnb(PLWIGOV        ,0.0        ,"A"                                  ,"Binning parameter of the area dependence of IGOV")
`MPRnb(POIGOVD        ,0.0        ,"A"                                  ,"Binning parameter of the geometry independent part of IGOVD")
`MPRnb(PLIGOVD        ,0.0        ,"A"                                  ,"Binning parameter of the length dependence of IGOVD")
`MPRnb(PWIGOVD        ,0.0        ,"A"                                  ,"Binning parameter of the width dependence of IGOVD")
`MPRnb(PLWIGOVD       ,0.0        ,"A"                                  ,"Binning parameter of the area dependence of IGOVD")
`MPRnb(POSTIG         ,2.0        ,""                                  ,"Binning parameter of the geometry independent part of STIG")
`MPRnb(PLSTIG         ,0.0        ,""                                  ,"Binning parameter of the length dependence of STIG")
`MPRnb(PWSTIG         ,0.0        ,""                                  ,"Binning parameter of the width dependence of STIG")
`MPRnb(PLWSTIG        ,0.0        ,""                                  ,"Binning parameter of the area dependence of STIG")

//  Gate-induced drain leakage parameters
`MPRnb(POAGIDL        ,0.0        ,"A/V^3"                              ,"Binning parameter of the geometry independent part of AGIDL")
`MPRnb(PLAGIDL        ,0.0        ,"A/V^3"                              ,"Binning parameter of the length dependence of AGIDL")
`MPRnb(PWAGIDL        ,0.0        ,"A/V^3"                              ,"Binning parameter of the width dependence of AGIDL")
`MPRnb(PLWAGIDL       ,0.0        ,"A/V^3"                              ,"Binning parameter of the area dependence of AGIDL")
`MPRnb(POAGIDLD       ,0.0        ,"A/V^3"                              ,"Binning parameter of the geometry independent part of AGIDLD")
`MPRnb(PLAGIDLD       ,0.0        ,"A/V^3"                              ,"Binning parameter of the length dependence of AGIDLD")
`MPRnb(PWAGIDLD       ,0.0        ,"A/V^3"                              ,"Binning parameter of the width dependence of AGIDLD")
`MPRnb(PLWAGIDLD      ,0.0        ,"A/V^3"                              ,"Binning parameter of the area dependence of AGIDLD")
`MPRnb(POSTBGIDL      ,0.0        ,"V/K"                                ,"Binning parameter of the geometry independent part of STBGIDL")
`MPRnb(PLSTBGIDL      ,0.0        ,"V/K"                                ,"Binning parameter of the length dependence of STBGIDL")
`MPRnb(PWSTBGIDL      ,0.0        ,"V/K"                                ,"Binning parameter of the width dependence of STBGIDL")
`MPRnb(PLWSTBGIDL     ,0.0        ,"V/K"                                ,"Binning parameter of the area dependence of STBGIDL")
`MPRnb(POSTBGIDLD     ,0.0        ,"V/K"                                ,"Binning parameter of the geometry independent part of STBGIDLD")
`MPRnb(PLSTBGIDLD     ,0.0        ,"V/K"                                ,"Binning parameter of the length dependence of STBGIDLD")
`MPRnb(PWSTBGIDLD     ,0.0        ,"V/K"                                ,"Binning parameter of the width dependence of STBGIDLD")
`MPRnb(PLWSTBGIDLD    ,0.0        ,"V/K"                                ,"Binning parameter of the area dependence of STBGIDLD")

//  Charge model parameters
`MPRnb(POCOX          ,1.0e-14    ,"F"                                  ,"Binning parameter of the geometry independent part of COX")
`MPRnb(PLCOX          ,0.0        ,"F"                                  ,"Binning parameter of the length dependence of COX")
`MPRnb(PWCOX          ,0.0        ,"F"                                  ,"Binning parameter of the width dependence of COX")
`MPRnb(PLWCOX         ,0.0        ,"F"                                  ,"Binning parameter of the area dependence of COX")
`MPRnb(PODELVTAC      ,0.0        ,"V"                                  ,"Binning parameter of the geometry independent part of DELVTAC")
`MPRnb(PLDELVTAC      ,0.0        ,"V"                                  ,"Binning parameter of the length dependence of DELVTAC")
`MPRnb(PWDELVTAC      ,0.0        ,"V"                                  ,"Binning parameter of the width dependence of DELVTAC")
`MPRnb(PLWDELVTAC     ,0.0        ,"V"                                  ,"Binning parameter of the area dependence of DELVTAC")
`MPRnb(POFACNEFFAC    ,1.0        ,""                                   ,"Binning parameter of the geometry independent part of NEFFAC")
`MPRnb(PLFACNEFFAC    ,0.0        ,""                                   ,"Binning parameter of the length dependence of NEFFAC")
`MPRnb(PWFACNEFFAC    ,0.0        ,""                                   ,"Binning parameter of the width dependence of NEFFAC")
`MPRnb(PLWFACNEFFAC   ,0.0        ,""                                   ,"Binning parameter of the area dependence of NEFFAC")
`MPRnb(POTHESATAC     ,0.1        ,"V^-1"                               ,"Binning parameter of the geometry independent part of THESATAC")
`MPRnb(PLTHESATAC     ,0.0        ,"V^-1"                               ,"Binning parameter of the length dependence of THESATAC")
`MPRnb(PWTHESATAC     ,0.0        ,"V^-1"                               ,"Binning parameter of the width dependence of THESATAC")
`MPRnb(PLWTHESATAC    ,0.0        ,"V^-1"                               ,"Binning parameter of the area dependence of THESATAC")
`MPRnb(POAXAC         ,8.0        ,""                                   ,"Binning parameter of the geometry independent part of AXAC")
`MPRnb(PLAXAC         ,0.0        ,""                                   ,"Binning parameter of the length dependence of AXAC")
`MPRnb(PWAXAC         ,0.0        ,""                                   ,"Binning parameter of the width dependence of AXAC")
`MPRnb(PLWAXAC        ,0.0        ,""                                   ,"Binning parameter of the area dependence of AXAC")
`MPRnb(POALPAC        ,0.0        ,""                                   ,"Binning parameter of the geometry independent part of ALPAC")
`MPRnb(PLALPAC        ,0.0        ,""                                   ,"Binning parameter of the length dependence of ALPAC")
`MPRnb(PWALPAC        ,0.0        ,""                                   ,"Binning parameter of the width dependence of ALPAC")
`MPRnb(PLWALPAC       ,0.0        ,""                                   ,"Binning parameter of the area dependence of ALPAC")
`MPRnb(POALP1AC       ,0.0        ,"V"                                  ,"Binning parameter of the geometry independent part of ALP1AC")
`MPRnb(PLALP1AC       ,0.0        ,"V"                                  ,"Binning parameter of the length dependence of ALP1AC")
`MPRnb(PWALP1AC       ,0.0        ,"V"                                  ,"Binning parameter of the width dependence of ALP1AC")
`MPRnb(PLWALP1AC      ,0.0        ,"V"                                  ,"Binning parameter of the area dependence of ALP1AC")
`MPRnb(POCGOV         ,1.0e-15    ,"F"                                  ,"Binning parameter of the geometry independent part of CGOV")
`MPRnb(PLCGOV         ,0.0        ,"F"                                  ,"Binning parameter of the length dependence of CGOV")
`MPRnb(PWCGOV         ,0.0        ,"F"                                  ,"Binning parameter of the width dependence of CGOV")
`MPRnb(PLWCGOV        ,0.0        ,"F"                                  ,"Binning parameter of the area dependence of CGOV")
`MPRnb(POCGOVD        ,1.0e-15    ,"F"                                  ,"Binning parameter of the geometry independent part of CGOVD")
`MPRnb(PLCGOVD        ,0.0        ,"F"                                  ,"Binning parameter of the length dependence of CGOVD")
`MPRnb(PWCGOVD        ,0.0        ,"F"                                  ,"Binning parameter of the width dependence of CGOVD")
`MPRnb(PLWCGOVD       ,0.0        ,"F"                                  ,"Binning parameter of the area dependence of CGOVD")
`MPRnb(POCGBOV        ,1.0e-15    ,"F"                                  ,"Binning parameter of the geometry independent part of CGBOV")
`MPRnb(PLCGBOV        ,0.0        ,"F"                                  ,"Binning parameter of the length dependence of CGBOV")
`MPRnb(PWCGBOV        ,0.0        ,"F"                                  ,"Binning parameter of the width dependence of CGBOV")
`MPRnb(PLWCGBOV       ,0.0        ,"F"                                  ,"Binning parameter of the area dependence of CGBOV")
`MPRnb(POCINR         ,5.0e-16    ,"F"                                  ,"Binning parameter of the geometry independent part of CINR")
`MPRnb(PLCINR         ,0.0        ,"F"                                  ,"Binning parameter of the length dependence of CINR")
`MPRnb(PWCINR         ,0.0        ,"F"                                  ,"Binning parameter of the width dependence of CINR")
`MPRnb(PLWCINR        ,0.0        ,"F"                                  ,"Binning parameter of the area dependence of CINR")
`MPRnb(POCINRD        ,5.0e-16    ,"F"                                  ,"Binning parameter of the geometry independent part of CINRD")
`MPRnb(PLCINRD        ,0.0        ,"F"                                  ,"Binning parameter of the length dependence of CINRD")
`MPRnb(PWCINRD        ,0.0        ,"F"                                  ,"Binning parameter of the width dependence of CINRD")
`MPRnb(PLWCINRD       ,0.0        ,"F"                                  ,"Binning parameter of the area dependence of CINRD")
`MPRnb(POCFR          ,1.0e-15    ,"F"                                  ,"Binning parameter of the geometry independent part of CFR")
`MPRnb(PLCFR          ,0.0        ,"F"                                  ,"Binning parameter of the length dependence of CFR")
`MPRnb(PWCFR          ,0.0        ,"F"                                  ,"Binning parameter of the width dependence of CFR")
`MPRnb(PLWCFR         ,0.0        ,"F"                                  ,"Binning parameter of the area dependence of CFR")
`MPRnb(POCFRD         ,1.0e-15    ,"F"                                  ,"Binning parameter of the geometry independent part of CFRD")
`MPRnb(PLCFRD         ,0.0        ,"F"                                  ,"Binning parameter of the length dependence of CFRD")
`MPRnb(PWCFRD         ,0.0        ,"F"                                  ,"Binning parameter of the width dependence of CFRD")
`MPRnb(PLWCFRD        ,0.0        ,"F"                                  ,"Binning parameter of the area dependence of CFRD")

// Noise model parameters
`MPRnb(POFNTEXC       ,0.0        ,""                                   ,"Binning parameter of the geometry independent part of FNTEXC")
`MPRnb(PLFNTEXC       ,0.0        ,""                                   ,"Binning parameter of the length dependence of FNTEXC")
`MPRnb(PWFNTEXC       ,0.0        ,""                                   ,"Binning parameter of the width dependence of FNTEXC")
`MPRnb(PLWFNTEXC      ,0.0        ,""                                   ,"Binning parameter of the area dependence of FNTEXC")
`MPRnb(PONFA          ,8.0e22     ,"V^-1/m^4"                           ,"Binning parameter of the geometry independent part of NFA")
`MPRnb(PLNFA          ,0.0        ,"V^-1/m^4"                           ,"Binning parameter of the length dependence of NFA")
`MPRnb(PWNFA          ,0.0        ,"V^-1/m^4"                           ,"Binning parameter of the width dependence of NFA")
`MPRnb(PLWNFA         ,0.0        ,"V^-1/m^4"                           ,"Binning parameter of the area dependence of NFA")
`MPRnb(PONFB          ,3.0e07     ,"V^-1/m^2"                           ,"Binning parameter of the geometry independent part of NFB")
`MPRnb(PLNFB          ,0.0        ,"V^-1/m^2"                           ,"Binning parameter of the length dependence of NFB")
`MPRnb(PWNFB          ,0.0        ,"V^-1/m^2"                           ,"Binning parameter of the width dependence of NFB")
`MPRnb(PLWNFB         ,0.0        ,"V^-1/m^2"                           ,"Binning parameter of the area dependence of NFB")
`MPRnb(PONFC          ,0.0        ,"V^-1"                               ,"Binning parameter of the geometry independent part of NFC")
`MPRnb(PLNFC          ,0.0        ,"V^-1"                               ,"Binning parameter of the length dependence of NFC")
`MPRnb(PWNFC          ,0.0        ,"V^-1"                               ,"Binning parameter of the width dependence of NFC")
`MPRnb(PLWNFC         ,0.0        ,"V^-1"                               ,"Binning parameter of the area dependence of NFC")

//  Edge transistors parameters
`MPRnb(POVFBEDGE      ,-1.0       ,"V"                                  ,"Binning parameter of the geometry independent part of VFBEDGE")
`MPRnb(PLVFBEDGE      ,0.0        ,"V"                                  ,"Binning parameter of the length dependence of VFBEDGE")
`MPRnb(PWVFBEDGE      ,0.0        ,"V"                                  ,"Binning parameter of the width dependence of VFBEDGE")
`MPRnb(PLWVFBEDGE     ,0.0        ,"V"                                  ,"Binning parameter of the area dependence of VFBEDGE")
`MPRnb(POSTVFBEDGE    ,5.0e-04    ,"V/K"                                ,"Binning parameter of the geometry independent part of STVFBEDGE")
`MPRnb(PLSTVFBEDGE    ,0.0        ,"V/K"                                ,"Binning parameter of the length dependence of STVFBEDGE")
`MPRnb(PWSTVFBEDGE    ,0.0        ,"V/K"                                ,"Binning parameter of the width dependence of STVFBEDGE")
`MPRnb(PLWSTVFBEDGE   ,0.0        ,"V/K"                                ,"Binning parameter of the area dependence of STVFBEDGE")
`MPRnb(PODPHIBEDGE    ,0.0        ,"V"                                  ,"Binning parameter of the geometry independent part of DPHIBEDGE")
`MPRnb(PLDPHIBEDGE    ,0.0        ,"V"                                  ,"Binning parameter of the length dependence of DPHIBEDGE")
`MPRnb(PWDPHIBEDGE    ,0.0        ,"V"                                  ,"Binning parameter of the width dependence of DPHIBEDGE")
`MPRnb(PLWDPHIBEDGE   ,0.0        ,"V"                                  ,"Binning parameter of the area dependence of DPHIBEDGE")
`MPRnb(PONEFFEDGE     ,5.0e23     ,"m^-3"                               ,"Binning parameter of the geometry independent part of NEFFEDGE")
`MPRnb(PLNEFFEDGE     ,0.0        ,"m^-3"                               ,"Binning parameter of the length dependence of NEFFEDGE")
`MPRnb(PWNEFFEDGE     ,0.0        ,"m^-3"                               ,"Binning parameter of the width dependence of NEFFEDGE")
`MPRnb(PLWNEFFEDGE    ,0.0        ,"m^-3"                               ,"Binning parameter of the area dependence of NEFFEDGE")
`MPRnb(POCTEDGE       ,0.0        ,""                                   ,"Binning parameter of the geometry independent part of CTEDGE")
`MPRnb(PLCTEDGE       ,0.0        ,""                                   ,"Binning parameter of the length dependence of CTEDGE")
`MPRnb(PWCTEDGE       ,0.0        ,""                                   ,"Binning parameter of the width dependence of CTEDGE")
`MPRnb(PLWCTEDGE      ,0.0        ,""                                   ,"Binning parameter of the area dependence of CTEDGE")
`MPRnb(POBETNEDGE     ,3.0e-02    ,"m^2/V/s"                            ,"Binning parameter of the geometry independent part of BETNEDGE")
`MPRnb(PLBETNEDGE     ,0.0        ,"m^2/V/s"                            ,"Binning parameter of the length dependence of BETNEDGE")
`MPRnb(PWBETNEDGE     ,0.0        ,"m^2/V/s"                            ,"Binning parameter of the width dependence of BETNEDGE")
`MPRnb(PLWBETNEDGE    ,0.0        ,"m^2/V/s"                            ,"Binning parameter of the area dependence of BETNEDGE")
`MPRnb(POSTBETEDGE    ,1.0        ,""                                   ,"Binning parameter of the geometry independent part of STBETEDGE")
`MPRnb(PLSTBETEDGE    ,0.0        ,""                                   ,"Binning parameter of the length dependence of STBETEDGE")
`MPRnb(PWSTBETEDGE    ,0.0        ,""                                   ,"Binning parameter of the width dependence of STBETEDGE")
`MPRnb(PLWSTBETEDGE   ,0.0        ,""                                   ,"Binning parameter of the area dependence of STBETEDGE")
`MPRnb(POPSCEEDGE     ,0.0        ,""                                   ,"Binning parameter of the geometry independent part of PSCEEDGE")
`MPRnb(PLPSCEEDGE     ,0.0        ,""                                   ,"Binning parameter of the length dependence of PSCEEDGE")
`MPRnb(PWPSCEEDGE     ,0.0        ,""                                   ,"Binning parameter of the width dependence of PSCEEDGE")
`MPRnb(PLWPSCEEDGE    ,0.0        ,""                                   ,"Binning parameter of the area dependence of PSCEEDGE")
`MPRnb(POPSCEBEDGE    ,0.0        ,"V^-1"                               ,"Binning parameter of the geometry independent part of PSCEBEDGE")
`MPRnb(PLPSCEBEDGE    ,0.0        ,"V^-1"                               ,"Binning parameter of the length dependence of PSCEBEDGE")
`MPRnb(PWPSCEBEDGE    ,0.0        ,"V^-1"                               ,"Binning parameter of the width dependence of PSCEBEDGE")
`MPRnb(PLWPSCEBEDGE   ,0.0        ,"V^-1"                               ,"Binning parameter of the area dependence of PSCEBEDGE")
`MPRnb(POPSCEDEDGE    ,0.0        ,"V^-1"                               ,"Binning parameter of the geometry independent part of PSCEDEDGE")
`MPRnb(PLPSCEDEDGE    ,0.0        ,"V^-1"                               ,"Binning parameter of the length dependence of PSCEDEDGE")
`MPRnb(PWPSCEDEDGE    ,0.0        ,"V^-1"                               ,"Binning parameter of the width dependence of PSCEDEDGE")
`MPRnb(PLWPSCEDEDGE   ,0.0        ,"V^-1"                               ,"Binning parameter of the area dependence of PSCEDEDGE")
`MPRnb(POCFEDGE       ,0.0        ,""                                   ,"Binning parameter of the geometry independent part of CFEDGE")
`MPRnb(PLCFEDGE       ,0.0        ,""                                   ,"Binning parameter of the length dependence of CFEDGE")
`MPRnb(PWCFEDGE       ,0.0        ,""                                   ,"Binning parameter of the width dependence of CFEDGE")
`MPRnb(PLWCFEDGE      ,0.0        ,""                                   ,"Binning parameter of the area dependence of CFEDGE")
`MPRnb(POCFBEDGE      ,0.0        ,"V^-1"                               ,"Binning parameter of the geometry independent part of CFBEDGE")
`MPRnb(PLCFBEDGE      ,0.0        ,"V^-1"                               ,"Binning parameter of the length dependence of CFBEDGE")
`MPRnb(PWCFBEDGE      ,0.0        ,"V^-1"                               ,"Binning parameter of the width dependence of CFBEDGE")
`MPRnb(PLWCFBEDGE     ,0.0        ,"V^-1"                               ,"Binning parameter of the area dependence of CFBEDGE")
`MPRnb(POCFDEDGE      ,0.0        ,"V^-1"                               ,"Binning parameter of the geometry independent part of CFDEDGE")
`MPRnb(PLCFDEDGE      ,0.0        ,"V^-1"                               ,"Binning parameter of the length dependence of CFDEDGE")
`MPRnb(PWCFDEDGE      ,0.0        ,"V^-1"                               ,"Binning parameter of the width dependence of CFDEDGE")
`MPRnb(PLWCFDEDGE     ,0.0        ,"V^-1"                               ,"Binning parameter of the area dependence of CFDEDGE")
`MPRnb(PONFAEDGE      ,8.0e22     ,"V^-1/m^4"                           ,"Binning parameter of the geometry independent part of NFAEDGE")
`MPRnb(PLNFAEDGE      ,0.0        ,"V^-1/m^4"                           ,"Binning parameter of the length dependence of NFAEDGE")
`MPRnb(PWNFAEDGE      ,0.0        ,"V^-1/m^4"                           ,"Binning parameter of the width dependence of NFAEDGE")
`MPRnb(PLWNFAEDGE     ,0.0        ,"V^-1/m^4"                           ,"Binning parameter of the area dependence of NFAEDGE")
`MPRnb(PONFBEDGE      ,3.0e07     ,"V^-1/m^2"                           ,"Binning parameter of the geometry independent part of NFBEDGE")
`MPRnb(PLNFBEDGE      ,0.0        ,"V^-1/m^2"                           ,"Binning parameter of the length dependence of NFBEDGE")
`MPRnb(PWNFBEDGE      ,0.0        ,"V^-1/m^2"                           ,"Binning parameter of the width dependence of NFBEDGE")
`MPRnb(PLWNFBEDGE     ,0.0        ,"V^-1/m^2"                           ,"Binning parameter of the area dependence of NFBEDGE")
`MPRnb(PONFCEDGE      ,0.0        ,"V^-1"                               ,"Binning parameter of the geometry independent part of NFCEDGE")
`MPRnb(PLNFCEDGE      ,0.0        ,"V^-1"                               ,"Binning parameter of the length dependence of NFCEDGE")
`MPRnb(PWNFCEDGE      ,0.0        ,"V^-1"                               ,"Binning parameter of the width dependence of NFCEDGE")
`MPRnb(PLWNFCEDGE     ,0.0        ,"V^-1"                               ,"Binning parameter of the area dependence of NFCEDGE")

//  Self heating effect parameters
`ifdef SelfHeating
`MPRnb(PORTH          ,0.0        ,"K/W"                                ,"Binning parameter of the geometry independent part of RTH")
`MPRnb(PLRTH          ,0.0        ,"K/W"                                ,"Binning parameter of the length dependence of RTH")
`MPRnb(PWRTH          ,0.0        ,"K/W"                                ,"Binning parameter of the width dependence of RTH")
`MPRnb(PLWRTH         ,0.0        ,"K/W"                                ,"Binning parameter of the area dependence of RTH")
`MPRnb(POCTH          ,0.0        ,"J/K"                                ,"Binning parameter of the geometry independent part of CTH")
`MPRnb(PLCTH          ,0.0        ,"J/K"                                ,"Binning parameter of the length dependence of CTH")
`MPRnb(PWCTH          ,0.0        ,"J/K"                                ,"Binning parameter of the width dependence of CTH")
`MPRnb(PLWCTH         ,0.0        ,"J/K"                                ,"Binning parameter of the area dependence of CTH")
`MPRnb(POSTRTH        ,0.0        ,""                                   ,"Binning parameter of the geometry independent part of STRTH")
`MPRnb(PLSTRTH        ,0.0        ,""                                   ,"Binning parameter of the length dependence of STRTH")
`MPRnb(PWSTRTH        ,0.0        ,""                                   ,"Binning parameter of the width dependence of STRTH")
`MPRnb(PLWSTRTH       ,0.0        ,""                                   ,"Binning parameter of the area dependence of STRTH")
`endif // SelfHeating

//  NQS parameters
`ifdef NQSmodel
`MPRnb(POMUNQS        ,1.0        ,"K/W"                                ,"Binning parameter of the geometry independent part of MUNQS")
`MPRnb(PLMUNQS        ,0.0        ,"K/W"                                ,"Binning parameter of the length dependence of MUNQS")
`MPRnb(PWMUNQS        ,0.0        ,"K/W"                                ,"Binning parameter of the width dependence of MUNQS")
`MPRnb(PLWMUNQS       ,0.0        ,"K/W"                                ,"Binning parameter of the area dependence of MUNQS")
`endif // NQSmodel

//  --------------------------------------------------------------------------------------------------------------
//  Stress model parameters
//  --------------------------------------------------------------------------------------------------------------
`MPRco(SAREF          ,1.0e-06    ,"m"        ,1.0e-09     ,inf         ,"Reference distance between OD-edge and poly from one side")
`MPRco(SBREF          ,1.0e-06    ,"m"        ,1.0e-09     ,inf         ,"Reference distance between OD-edge and poly from other side")
`MPRnb(WLOD           ,0.0        ,"m"                                  ,"Width parameter")
`MPRnb(KUO            ,0.0        ,"m"                                  ,"Mobility degradation/enhancement coefficient")
`MPRcc(KVSAT          ,0.0        ,"m"        ,-1.0        ,1.0         ,"Saturation velocity degradation/enhancement coefficient")
`MPRcc(KVSATAC        ,0.0        ,"m"        ,-1.0        ,1.0         ,"Saturation velocity degradation/enhancement coefficient of charge model when SWQSAT=1")
`MPRnb(TKUO           ,0.0        ,""                                   ,"Temperature dependence of KUO")
`MPRnb(LKUO           ,0.0        ,"m^LLODKUO"                          ,"Length dependence of KUO")
`MPRnb(WKUO           ,0.0        ,"m^WLODKUO"                          ,"Width dependence of KUO")
`MPRnb(PKUO           ,0.0        ,"m^(LLODKUO+WLODKUO)"                ,"Cross-term dependence of KUO")
`MPRcz(LLODKUO        ,0.0        ,""                                   ,"Length parameter for UO stress effect")
`MPRcz(WLODKUO        ,0.0        ,""                                   ,"Width parameter for UO stress effect")
`MPRnb(KVTHO          ,0.0        ,"Vm"                                 ,"Threshold shift parameter")
`MPRnb(LKVTHO         ,0.0        ,"m^LLODVTH"                          ,"Length dependence of KVTHO")
`MPRnb(WKVTHO         ,0.0        ,"m^WLODVTH"                          ,"Width dependence of KVTHO")
`MPRnb(PKVTHO         ,0.0        ,"m^(LLODVTH+WLODVTH)"                ,"Cross-term dependence of KVTHO")
`MPRcz(LLODVTH        ,0.0        ,""                                   ,"Length parameter for VTH-stress effect")
`MPRcz(WLODVTH        ,0.0        ,""                                   ,"Width parameter for VTH-stress effect")
`MPRnb(STETAO         ,0.0        ,"m"                                  ,"Eta0 shift factor related to VTHO change")
`MPRcz(LODETAO        ,1.0        ,""                                   ,"Eta0 shift modification factor for stress effect")

//  --------------------------------------------------------------------------------------------------------------
//  Well proximity effect parameters
//  --------------------------------------------------------------------------------------------------------------
`MPRoz(SCREF          ,1.0e-06    ,"m"                                  ,"Distance between OD-edge and well edge of a reference device")
`MPRnb(WEB            ,0.0        ,""                                   ,"Coefficient for SCB")
`MPRnb(WEC            ,0.0        ,""                                   ,"Coefficient for SCC")
`MPRnb(KVTHOWEO       ,0.0        ,""                                   ,"Geometrical independent threshold shift parameter")
`MPRnb(KVTHOWEL       ,0.0        ,""                                   ,"Length dependent threshold shift parameter")
`MPRnb(KVTHOWEW       ,0.0        ,""                                   ,"Width dependent threshold shift parameter")
`MPRnb(KVTHOWELW      ,0.0        ,""                                   ,"Area dependent threshold shift parameter")
`MPRnb(KUOWEO         ,0.0        ,""                                   ,"Geometrical independent mobility degradation factor")
`MPRnb(KUOWEL         ,0.0        ,""                                   ,"Length dependent mobility degradation factor")
`MPRnb(KUOWEW         ,0.0        ,""                                   ,"Width dependent mobility degradation factor")
`MPRnb(KUOWELW        ,0.0        ,""                                   ,"Area dependent mobility degradation factor")
// ---- end `include "PSP104_parlist.include" ----

//  --------------------------------------------------------------------------------------------------------------
//  JUNCAP Model Parameters
//  --------------------------------------------------------------------------------------------------------------
// ---- begin `include "JUNCAP200_parlist.include" ----
//======================================================================================
//======================================================================================
// Filename: JUNCAP200_parlist.include
//======================================================================================
//======================================================================================
//
//  (c) Copyright notice
//
//  Since 2015 until today, PSP has been co-developed by NXP Semiconductors and
//  CEA-Leti. For this part of the model, each claim undivided ownership and copyrights
//  Since 2012 until 2015, PSP has been co-developed by NXP Semiconductors and
//  Delft University of Technology. For this part of the model, each claim undivided
//  ownership and copyrights
//  Until and including 2011, PSP has been co-developed by NXP Semiconductors and
//  Arizona State University. For this part of the model, NXP Semiconductors claims
//  undivided ownership and copyrights.
//
//
//  Version: 200.7.0, March 2026
//
//======================================================================================
//======================================================================================
//
// Further information can be found in the file releasenotesPSP104.txt
//

//  --------------------------------------------------------------------------------------------------------------
//  JUNCAP2 - Common model parameters
//  --------------------------------------------------------------------------------------------------------------

`MPRco(IMAX           ,1000.0     ,"A"        ,`IMAX_cliplow     ,inf              ,"Maximum current up to which forward current behaves exponentially")
`MPRco(TRJ            ,21.0       ,"C"        ,`TRJ_cliplow      ,inf              ,"Reference temperature")
`MPRcc(FREV           ,1.0e3      ,""         ,`FREV_cliplow     ,`FREV_cliphigh   ,"Coefficient for reverse breakdown current limitation")

// Parameters for source-bulk junction
`ifdef JUNCAP_StandAlone
    aliasparam TREF = TRJ;
    `MPRco(CJORBOT        ,1.0e-3     ,"Fm^-2"    ,`CJORBOT_cliplow  ,inf              ,"Zero-bias capacitance per unit-of-area of bottom component")
    `MPRco(CJORSTI        ,1.0e-9     ,"Fm^-1"    ,`CJORSTI_cliplow  ,inf              ,"Zero-bias capacitance per unit-of-length of STI-edge component")
    `MPRco(CJORGAT        ,1.0e-9     ,"Fm^-1"    ,`CJORGAT_cliplow  ,inf              ,"Zero-bias capacitance per unit-of-length of gate-edge component")
    `MPRco(VBIRBOT        ,1.0        ,"V"        ,`VBIR_cliplow     ,inf              ,"Built-in voltage at the reference temperature of bottom component")
    `MPRco(VBIRSTI        ,1.0        ,"V"        ,`VBIR_cliplow     ,inf              ,"Built-in voltage at the reference temperature of STI-edge component")
    `MPRco(VBIRGAT        ,1.0        ,"V"        ,`VBIR_cliplow     ,inf              ,"Built-in voltage at the reference temperature of gate-edge component")
    `MPRcc(PBOT           ,0.5        ,""         ,`P_cliplow        ,`P_cliphigh      ,"Grading coefficient of bottom component")
    `MPRcc(PSTI           ,0.5        ,""         ,`P_cliplow        ,`P_cliphigh      ,"Grading coefficient of STI-edge component")
    `MPRcc(PGAT           ,0.5        ,""         ,`P_cliplow        ,`P_cliphigh      ,"Grading coefficient of gate-edge component")
    `MPRnb(PHIGBOT        ,1.16       ,"V"                                             ,"Zero-temperature bandgap voltage of bottom component")
    `MPRnb(PHIGSTI        ,1.16       ,"V"                                             ,"Zero-temperature bandgap voltage of STI-edge component")
    `MPRnb(PHIGGAT        ,1.16       ,"V"                                             ,"Zero-temperature bandgap voltage of gate-edge component")
    `MPRco(IDSATRBOT      ,1.0e-12    ,"Am^-2"    ,`IDSATR_cliplow   ,inf              ,"Saturation current density at the reference temperature of bottom component")
    `MPRco(IDSATRSTI      ,1.0e-18    ,"Am^-1"    ,`IDSATR_cliplow   ,inf              ,"Saturation current density at the reference temperature of STI-edge component")
    `MPRco(IDSATRGAT      ,1.0e-18    ,"Am^-1"    ,`IDSATR_cliplow   ,inf              ,"Saturation current density at the reference temperature of gate-edge component")
    `MPRco(CSRHBOT        ,1.0e2      ,"Am^-3"    ,`CSRH_cliplow     ,inf              ,"Shockley-Read-Hall prefactor of bottom component")
    `MPRco(CSRHSTI        ,1.0e-4     ,"Am^-2"    ,`CSRH_cliplow     ,inf              ,"Shockley-Read-Hall prefactor of STI-edge component")
    `MPRco(CSRHGAT        ,1.0e-4     ,"Am^-2"    ,`CSRH_cliplow     ,inf              ,"Shockley-Read-Hall prefactor of gate-edge component")
    `MPRco(XJUNSTI        ,1.0e-7     ,"m"        ,`XJUN_cliplow     ,inf              ,"Junction depth of STI-edge component")
    `MPRco(XJUNGAT        ,1.0e-7     ,"m"        ,`XJUN_cliplow     ,inf              ,"Junction depth of gate-edge component")
    `MPRco(CTATBOT        ,1.0e2      ,"Am^-3"    ,`CTAT_cliplow     ,inf              ,"Trap-assisted tunneling prefactor of bottom component")
    `MPRco(CTATSTI        ,1.0e-4     ,"Am^-2"    ,`CTAT_cliplow     ,inf              ,"Trap-assisted tunneling prefactor of STI-edge component")
    `MPRco(CTATGAT        ,1.0e-4     ,"Am^-2"    ,`CTAT_cliplow     ,inf              ,"Trap-assisted tunneling prefactor of gate-edge component")
    `MPRco(MEFFTATBOT     ,0.25       ,""         ,`MEFFTAT_cliplow  ,inf              ,"Effective mass (in units of m0) for trap-assisted tunneling of bottom component")
    `MPRco(MEFFTATSTI     ,0.25       ,""         ,`MEFFTAT_cliplow  ,inf              ,"Effective mass (in units of m0) for trap-assisted tunneling of STI-edge component")
    `MPRco(MEFFTATGAT     ,0.25       ,""         ,`MEFFTAT_cliplow  ,inf              ,"Effective mass (in units of m0) for trap-assisted tunneling of gate-edge component")
    `MPRco(CBBTBOT        ,1.0e-12    ,"AV^-3"    ,`CBBT_cliplow     ,inf              ,"Band-to-band tunneling prefactor of bottom component")
    `MPRco(CBBTSTI        ,1.0e-18    ,"AV^-3m"   ,`CBBT_cliplow     ,inf              ,"Band-to-band tunneling prefactor of STI-edge component")
    `MPRco(CBBTGAT        ,1.0e-18    ,"AV^-3m"   ,`CBBT_cliplow     ,inf              ,"Band-to-band tunneling prefactor of gate-edge component")
    `MPRnb(FBBTRBOT       ,1.0e9      ,"Vm^-1"                                         ,"Normalization field at the reference temperature for band-to-band tunneling of bottom component")
    `MPRnb(FBBTRSTI       ,1.0e9      ,"Vm^-1"                                         ,"Normalization field at the reference temperature for band-to-band tunneling of STI-edge component")
    `MPRnb(FBBTRGAT       ,1.0e9      ,"Vm^-1"                                         ,"Normalization field at the reference temperature for band-to-band tunneling of gate-edge component")
    `MPRnb(STFBBTBOT      ,-1.0e-3    ,"K^-1"                                          ,"Temperature scaling parameter for band-to-band tunneling of bottom component")
    `MPRnb(STFBBTSTI      ,-1.0e-3    ,"K^-1"                                          ,"Temperature scaling parameter for band-to-band tunneling of STI-edge component")
    `MPRnb(STFBBTGAT      ,-1.0e-3    ,"K^-1"                                          ,"Temperature scaling parameter for band-to-band tunneling of gate-edge component")
    `MPRco(VBRBOT         ,10.0       ,"V"        ,`VBR_cliplow      ,inf              ,"Breakdown voltage of bottom component")
    `MPRco(VBRSTI         ,10.0       ,"V"        ,`VBR_cliplow      ,inf              ,"Breakdown voltage of STI-edge component")
    `MPRco(VBRGAT         ,10.0       ,"V"        ,`VBR_cliplow      ,inf              ,"Breakdown voltage of gate-edge component")
    `MPRco(PBRBOT         ,4.0        ,"V"        ,`PBR_cliplow      ,inf              ,"Breakdown onset tuning parameter of bottom component")
    `MPRco(PBRSTI         ,4.0        ,"V"        ,`PBR_cliplow      ,inf              ,"Breakdown onset tuning parameter of STI-edge component")
    `MPRco(PBRGAT         ,4.0        ,"V"        ,`PBR_cliplow      ,inf              ,"Breakdown onset tuning parameter of gate-edge component")
    `MPRco(FCJORGAT2      ,1.0        ,""         ,`FCJOR2_cliplow   ,inf              ,"Zero-bias capacitance per unit-of-length of gate-edge component factor, 2nd junction")
    `MPRco(FVBIRGAT2      ,1.0        ,""         ,`F2_cliplow       ,inf              ,"Built-in voltage at the reference temperature of gate-edge component factor, 2nd junction")
    `MPRco(FPGAT2         ,1.0        ,""         ,`F2_cliplow       ,inf              ,"Grading coefficient of gate-edge component factor, 2nd junction")
    `MPRco(FPHIGGAT2      ,1.0        ,""         ,`F2_cliplow       ,inf              ,"Zero-temperature bandgap voltage of gate-edge component factor, 2nd junction")
    `MPRcc(VTRGAT         ,-1.0       ,"V"        ,`VTRGAT_cliplow   ,`VTRGAT_cliphigh ,"Transition voltage of gate-edge component factor, 2nd junction")
    `MPRcc(ANUGAT         ,0.1        ,"V"        ,`ANUGAT_cliplow   ,`ANUGAT_cliphigh ,"Transition width coefficient of gate-edge component factor, 2nd junction")
`else // JUNCAP_StandAlone
    `MPRco(CJORBOT        ,1.0e-3     ,"Fm^-2"    ,`CJORBOT_cliplow  ,inf              ,"Zero-bias capacitance per unit-of-area of bottom component for source-bulk junction")
    `MPRco(CJORSTI        ,1.0e-9     ,"Fm^-1"    ,`CJORSTI_cliplow  ,inf              ,"Zero-bias capacitance per unit-of-length of STI-edge component for source-bulk junction")
    `MPRco(CJORGAT        ,1.0e-9     ,"Fm^-1"    ,`CJORGAT_cliplow  ,inf              ,"Zero-bias capacitance per unit-of-length of gate-edge component for source-bulk junction")
    `MPRco(VBIRBOT        ,1.0        ,"V"        ,`VBIR_cliplow     ,inf              ,"Built-in voltage at the reference temperature of bottom component for source-bulk junction")
    `MPRco(VBIRSTI        ,1.0        ,"V"        ,`VBIR_cliplow     ,inf              ,"Built-in voltage at the reference temperature of STI-edge component for source-bulk junction")
    `MPRco(VBIRGAT        ,1.0        ,"V"        ,`VBIR_cliplow     ,inf              ,"Built-in voltage at the reference temperature of gate-edge component for source-bulk junction")
    `MPRcc(PBOT           ,0.5        ,""         ,`P_cliplow        ,`P_cliphigh      ,"Grading coefficient of bottom component for source-bulk junction")
    `MPRcc(PSTI           ,0.5        ,""         ,`P_cliplow        ,`P_cliphigh      ,"Grading coefficient of STI-edge component for source-bulk junction")
    `MPRcc(PGAT           ,0.5        ,""         ,`P_cliplow        ,`P_cliphigh      ,"Grading coefficient of gate-edge component for source-bulk junction")
    `MPRnb(PHIGBOT        ,1.16       ,"V"                                             ,"Zero-temperature bandgap voltage of bottom component for source-bulk junction")
    `MPRnb(PHIGSTI        ,1.16       ,"V"                                             ,"Zero-temperature bandgap voltage of STI-edge component for source-bulk junction")
    `MPRnb(PHIGGAT        ,1.16       ,"V"                                             ,"Zero-temperature bandgap voltage of gate-edge component for source-bulk junction")
    `MPRco(IDSATRBOT      ,1.0e-12    ,"Am^-2"    ,`IDSATR_cliplow   ,inf              ,"Saturation current density at the reference temperature of bottom component for source-bulk junction")
    `MPRco(IDSATRSTI      ,1.0e-18    ,"Am^-1"    ,`IDSATR_cliplow   ,inf              ,"Saturation current density at the reference temperature of STI-edge component for source-bulk junction")
    `MPRco(IDSATRGAT      ,1.0e-18    ,"Am^-1"    ,`IDSATR_cliplow   ,inf              ,"Saturation current density at the reference temperature of gate-edge component for source-bulk junction")
    `MPRco(CSRHBOT        ,1.0e2      ,"Am^-3"    ,`CSRH_cliplow     ,inf              ,"Shockley-Read-Hall prefactor of bottom component for source-bulk junction")
    `MPRco(CSRHSTI        ,1.0e-4     ,"Am^-2"    ,`CSRH_cliplow     ,inf              ,"Shockley-Read-Hall prefactor of STI-edge component for source-bulk junction")
    `MPRco(CSRHGAT        ,1.0e-4     ,"Am^-2"    ,`CSRH_cliplow     ,inf              ,"Shockley-Read-Hall prefactor of gate-edge component for source-bulk junction")
    `MPRco(XJUNSTI        ,1.0e-7     ,"m"        ,`XJUN_cliplow     ,inf              ,"Junction depth of STI-edge component for source-bulk junction")
    `MPRco(XJUNGAT        ,1.0e-7     ,"m"        ,`XJUN_cliplow     ,inf              ,"Junction depth of gate-edge component for source-bulk junction")
    `MPRco(CTATBOT        ,1.0e2      ,"Am^-3"    ,`CTAT_cliplow     ,inf              ,"Trap-assisted tunneling prefactor of bottom component for source-bulk junction")
    `MPRco(CTATSTI        ,1.0e-4     ,"Am^-2"    ,`CTAT_cliplow     ,inf              ,"Trap-assisted tunneling prefactor of STI-edge component for source-bulk junction")
    `MPRco(CTATGAT        ,1.0e-4     ,"Am^-2"    ,`CTAT_cliplow     ,inf              ,"Trap-assisted tunneling prefactor of gate-edge component for source-bulk junction")
    `MPRco(MEFFTATBOT     ,0.25       ,""         ,`MEFFTAT_cliplow  ,inf              ,"Effective mass (in units of m0) for trap-assisted tunneling of bottom component for source-bulk junction")
    `MPRco(MEFFTATSTI     ,0.25       ,""         ,`MEFFTAT_cliplow  ,inf              ,"Effective mass (in units of m0) for trap-assisted tunneling of STI-edge component for source-bulk junction")
    `MPRco(MEFFTATGAT     ,0.25       ,""         ,`MEFFTAT_cliplow  ,inf              ,"Effective mass (in units of m0) for trap-assisted tunneling of gate-edge component for source-bulk junction")
    `MPRco(CBBTBOT        ,1.0e-12    ,"AV^-3"    ,`CBBT_cliplow     ,inf              ,"Band-to-band tunneling prefactor of bottom component for source-bulk junction")
    `MPRco(CBBTSTI        ,1.0e-18    ,"AV^-3m"   ,`CBBT_cliplow     ,inf              ,"Band-to-band tunneling prefactor of STI-edge component for source-bulk junction")
    `MPRco(CBBTGAT        ,1.0e-18    ,"AV^-3m"   ,`CBBT_cliplow     ,inf              ,"Band-to-band tunneling prefactor of gate-edge component for source-bulk junction")
    `MPRnb(FBBTRBOT       ,1.0e9      ,"Vm^-1"                                         ,"Normalization field at the reference temperature for band-to-band tunneling of bottom component for source-bulk junction")
    `MPRnb(FBBTRSTI       ,1.0e9      ,"Vm^-1"                                         ,"Normalization field at the reference temperature for band-to-band tunneling of STI-edge component for source-bulk junction")
    `MPRnb(FBBTRGAT       ,1.0e9      ,"Vm^-1"                                         ,"Normalization field at the reference temperature for band-to-band tunneling of gate-edge component for source-bulk junction")
    `MPRnb(STFBBTBOT      ,-1.0e-3    ,"K^-1"                                          ,"Temperature scaling parameter for band-to-band tunneling of bottom component for source-bulk junction")
    `MPRnb(STFBBTSTI      ,-1.0e-3    ,"K^-1"                                          ,"Temperature scaling parameter for band-to-band tunneling of STI-edge component for source-bulk junction")
    `MPRnb(STFBBTGAT      ,-1.0e-3    ,"K^-1"                                          ,"Temperature scaling parameter for band-to-band tunneling of gate-edge component for source-bulk junction")
    `MPRco(VBRBOT         ,10.0       ,"V"        ,`VBR_cliplow      ,inf              ,"Breakdown voltage of bottom component for source-bulk junction")
    `MPRco(VBRSTI         ,10.0       ,"V"        ,`VBR_cliplow      ,inf              ,"Breakdown voltage of STI-edge component for source-bulk junction")
    `MPRco(VBRGAT         ,10.0       ,"V"        ,`VBR_cliplow      ,inf              ,"Breakdown voltage of gate-edge component for source-bulk junction")
    `MPRco(PBRBOT         ,4.0        ,"V"        ,`PBR_cliplow      ,inf              ,"Breakdown onset tuning parameter of bottom component for source-bulk junction")
    `MPRco(PBRSTI         ,4.0        ,"V"        ,`PBR_cliplow      ,inf              ,"Breakdown onset tuning parameter of STI-edge component for source-bulk junction")
    `MPRco(PBRGAT         ,4.0        ,"V"        ,`PBR_cliplow      ,inf              ,"Breakdown onset tuning parameter of gate-edge component for source-bulk junction")
    `MPRco(FCJORGAT2      ,1.0        ,""         ,`FCJOR2_cliplow   ,inf              ,"Zero-bias capacitance per unit-of-length of gate-edge component factor, 2nd junction")
    `MPRco(FVBIRGAT2      ,1.0        ,""         ,`F2_cliplow       ,inf              ,"Built-in voltage at the reference temperature of gate-edge component factor, 2nd junction")
    `MPRco(FPGAT2         ,1.0        ,""         ,`F2_cliplow       ,inf              ,"Grading coefficient of gate-edge component factor, 2nd junction")
    `MPRco(FPHIGGAT2      ,1.0        ,""         ,`F2_cliplow       ,inf              ,"Zero-temperature bandgap voltage of gate-edge component factor, 2nd junction")
    `MPRcc(VTRGAT         ,-1.0       ,"V"        ,`VTRGAT_cliplow   ,`VTRGAT_cliphigh ,"Transition voltage of 2nd region gate-edge component, source-bulk junction")
    `MPRcc(ANUGAT         ,0.1        ,"V"        ,`ANUGAT_cliplow   ,`ANUGAT_cliphigh ,"Transition width coefficient of 2nd region gate-edge component, source-bulk 2nd junction")
    `MPRco(ADVBRGAT       ,0.0        ,""         ,`ADVBR_cliplow    ,inf              ,"Gate dependent breakdown voltage shift prefactor of gate-edge component for source-bulk junction")
    `MPRco(BDVBRGAT       ,0.5        ,""         ,`BDVBR_cliplow    ,inf              ,"Gate dependent breakdown voltage shift exponent of  gate-edge component for source-bulk junction")
    `MPRco(ADBBTGAT       ,0.0        ,""         ,`ADBBT_cliplow    ,inf              ,"Gate dependent band-to-band tunneling shift prefactor of gate-edge component for source-bulk junction")
    `MPRco(BDBBTGAT       ,0.5        ,""         ,`BDBBT_cliplow    ,inf              ,"Gate dependent band-to-band tunneling shift exponent  of gate-edge component for source-bulk junction")
`endif // JUNCAP_StandAlone

// Parameters for drain-bulk junction
`ifdef JUNCAP_StandAlone
    // do nothing
`else // JUNCAP_StandAlone
    `MPRco(CJORBOTD       ,1.0e-3     ,"Fm^-2"    ,`CJORBOT_cliplow  ,inf              ,"Zero-bias capacitance per unit-of-area of bottom component for drain-bulk junction")
    `MPRco(CJORSTID       ,1.0e-9     ,"Fm^-1"    ,`CJORSTI_cliplow  ,inf              ,"Zero-bias capacitance per unit-of-length of STI-edge component for drain-bulk junction")
    `MPRco(CJORGATD       ,1.0e-9     ,"Fm^-1"    ,`CJORGAT_cliplow  ,inf              ,"Zero-bias capacitance per unit-of-length of gate-edge component for drain-bulk junction")
    `MPRco(VBIRBOTD       ,1.0        ,"V"        ,`VBIR_cliplow     ,inf              ,"Built-in voltage at the reference temperature of bottom component for drain-bulk junction")
    `MPRco(VBIRSTID       ,1.0        ,"V"        ,`VBIR_cliplow     ,inf              ,"Built-in voltage at the reference temperature of STI-edge component for drain-bulk junction")
    `MPRco(VBIRGATD       ,1.0        ,"V"        ,`VBIR_cliplow     ,inf              ,"Built-in voltage at the reference temperature of gate-edge component for drain-bulk junction")
    `MPRcc(PBOTD          ,0.5        ,""         ,`P_cliplow        ,`P_cliphigh      ,"Grading coefficient of bottom component for drain-bulk junction")
    `MPRcc(PSTID          ,0.5        ,""         ,`P_cliplow        ,`P_cliphigh      ,"Grading coefficient of STI-edge component for drain-bulk junction")
    `MPRcc(PGATD          ,0.5        ,""         ,`P_cliplow        ,`P_cliphigh      ,"Grading coefficient of gate-edge component for drain-bulk junction")
    `MPRnb(PHIGBOTD       ,1.16       ,"V"                                             ,"Zero-temperature bandgap voltage of bottom component for drain-bulk junction")
    `MPRnb(PHIGSTID       ,1.16       ,"V"                                             ,"Zero-temperature bandgap voltage of STI-edge component for drain-bulk junction")
    `MPRnb(PHIGGATD       ,1.16       ,"V"                                             ,"Zero-temperature bandgap voltage of gate-edge component for drain-bulk junction")
    `MPRco(IDSATRBOTD     ,1.0e-12    ,"Am^-2"    ,`IDSATR_cliplow   ,inf              ,"Saturation current density at the reference temperature of bottom component for drain-bulk junction")
    `MPRco(IDSATRSTID     ,1.0e-18    ,"Am^-1"    ,`IDSATR_cliplow   ,inf              ,"Saturation current density at the reference temperature of STI-edge component for drain-bulk junction")
    `MPRco(IDSATRGATD     ,1.0e-18    ,"Am^-1"    ,`IDSATR_cliplow   ,inf              ,"Saturation current density at the reference temperature of gate-edge component for drain-bulk junction")
    `MPRco(CSRHBOTD       ,1.0e2      ,"Am^-3"    ,`CSRH_cliplow     ,inf              ,"Shockley-Read-Hall prefactor of bottom component for drain-bulk junction")
    `MPRco(CSRHSTID       ,1.0e-4     ,"Am^-2"    ,`CSRH_cliplow     ,inf              ,"Shockley-Read-Hall prefactor of STI-edge component for drain-bulk junction")
    `MPRco(CSRHGATD       ,1.0e-4     ,"Am^-2"    ,`CSRH_cliplow     ,inf              ,"Shockley-Read-Hall prefactor of gate-edge component for drain-bulk junction")
    `MPRco(XJUNSTID       ,1.0e-7     ,"m"        ,`XJUN_cliplow     ,inf              ,"Junction depth of STI-edge component for drain-bulk junction")
    `MPRco(XJUNGATD       ,1.0e-7     ,"m"        ,`XJUN_cliplow     ,inf              ,"Junction depth of gate-edge component for drain-bulk junction")
    `MPRco(CTATBOTD       ,1.0e2      ,"Am^-3"    ,`CTAT_cliplow     ,inf              ,"Trap-assisted tunneling prefactor of bottom component for drain-bulk junction")
    `MPRco(CTATSTID       ,1.0e-4     ,"Am^-2"    ,`CTAT_cliplow     ,inf              ,"Trap-assisted tunneling prefactor of STI-edge component for drain-bulk junction")
    `MPRco(CTATGATD       ,1.0e-4     ,"Am^-2"    ,`CTAT_cliplow     ,inf              ,"Trap-assisted tunneling prefactor of gate-edge component for drain-bulk junction")
    `MPRco(MEFFTATBOTD    ,0.25       ,""         ,`MEFFTAT_cliplow  ,inf              ,"Effective mass (in units of m0) for trap-assisted tunneling of bottom component for drain-bulk junction")
    `MPRco(MEFFTATSTID    ,0.25       ,""         ,`MEFFTAT_cliplow  ,inf              ,"Effective mass (in units of m0) for trap-assisted tunneling of STI-edge component for drain-bulk junction")
    `MPRco(MEFFTATGATD    ,0.25       ,""         ,`MEFFTAT_cliplow  ,inf              ,"Effective mass (in units of m0) for trap-assisted tunneling of gate-edge component for drain-bulk junction")
    `MPRco(CBBTBOTD       ,1.0e-12    ,"AV^-3"    ,`CBBT_cliplow     ,inf              ,"Band-to-band tunneling prefactor of bottom component for drain-bulk junction")
    `MPRco(CBBTSTID       ,1.0e-18    ,"AV^-3m"   ,`CBBT_cliplow     ,inf              ,"Band-to-band tunneling prefactor of STI-edge component for drain-bulk junction")
    `MPRco(CBBTGATD       ,1.0e-18    ,"AV^-3m"   ,`CBBT_cliplow     ,inf              ,"Band-to-band tunneling prefactor of gate-edge component for drain-bulk junction")
    `MPRnb(FBBTRBOTD      ,1.0e9      ,"Vm^-1"                                         ,"Normalization field at the reference temperature for band-to-band tunneling of bottom component for drain-bulk junction")
    `MPRnb(FBBTRSTID      ,1.0e9      ,"Vm^-1"                                         ,"Normalization field at the reference temperature for band-to-band tunneling of STI-edge component for drain-bulk junction")
    `MPRnb(FBBTRGATD      ,1.0e9      ,"Vm^-1"                                         ,"Normalization field at the reference temperature for band-to-band tunneling of gate-edge component for drain-bulk junction")
    `MPRnb(STFBBTBOTD     ,-1.0e-3    ,"K^-1"                                          ,"Temperature scaling parameter for band-to-band tunneling of bottom component for drain-bulk junction")
    `MPRnb(STFBBTSTID     ,-1.0e-3    ,"K^-1"                                          ,"Temperature scaling parameter for band-to-band tunneling of STI-edge component for drain-bulk junction")
    `MPRnb(STFBBTGATD     ,-1.0e-3    ,"K^-1"                                          ,"Temperature scaling parameter for band-to-band tunneling of gate-edge component for drain-bulk junction")
    `MPRco(VBRBOTD        ,10.0       ,"V"        ,`VBR_cliplow      ,inf              ,"Breakdown voltage of bottom component for drain-bulk junction")
    `MPRco(VBRSTID        ,10.0       ,"V"        ,`VBR_cliplow      ,inf              ,"Breakdown voltage of STI-edge component for drain-bulk junction")
    `MPRco(VBRGATD        ,10.0       ,"V"        ,`VBR_cliplow      ,inf              ,"Breakdown voltage of gate-edge component for drain-bulk junction")
    `MPRco(PBRBOTD        ,4.0        ,"V"        ,`PBR_cliplow      ,inf              ,"Breakdown onset tuning parameter of bottom component for drain-bulk junction")
    `MPRco(PBRSTID        ,4.0        ,"V"        ,`PBR_cliplow      ,inf              ,"Breakdown onset tuning parameter of STI-edge component for drain-bulk junction")
    `MPRco(PBRGATD        ,4.0        ,"V"        ,`PBR_cliplow      ,inf              ,"Breakdown onset tuning parameter of gate-edge component for drain-bulk junction")
    `MPRco(FCJORGAT2D     ,1.0        ,""         ,`FCJOR2_cliplow   ,inf              ,"Zero-bias capacitance per unit-of-length of gate-edge component factor, drain-bulk 2nd junction")
    `MPRco(FVBIRGAT2D     ,1.0        ,""         ,`F2_cliplow       ,inf              ,"Built-in voltage at the reference temperature of gate-edge component factor, drain-bulk 2nd junction")
    `MPRco(FPGAT2D        ,1.0        ,""         ,`F2_cliplow       ,inf              ,"Grading coefficient of gate-edge component factor, drain-bulk 2nd junction")
    `MPRco(FPHIGGAT2D     ,1.0        ,""         ,`F2_cliplow       ,inf              ,"Zero-temperature bandgap voltage of gate-edge component factor, drain-bulk 2nd junction")
    `MPRcc(VTRGATD        ,-1.0       ,"V"        ,`VTRGAT_cliplow   ,`VTRGAT_cliphigh ,"Transition voltage of 2nd region gate-edge component, drain-bulk junction")
    `MPRcc(ANUGATD        ,0.1        ,"V"        ,`ANUGAT_cliplow   ,`ANUGAT_cliphigh ,"Transition width coefficient of 2nd region gate-edge component, drain-bulk 2nd junction")
    `MPRco(ADVBRGATD      ,0.0        ,""         ,`ADVBR_cliplow    ,inf              ,"Gate dependent breakdown voltage shift prefactor of gate-edge component for drain-bulk junction")
    `MPRco(BDVBRGATD      ,0.5        ,""         ,`BDVBR_cliplow    ,inf              ,"Gate dependent breakdown voltage shift exponent of  gate-edge component for drain-bulk junction")
    `MPRco(ADBBTGATD      ,0.0        ,""         ,`ADBBT_cliplow    ,inf              ,"Gate dependent band-to-band tunneling shift prefactor of gate-edge component for drain-bulk junction")
    `MPRco(BDBBTGATD      ,0.5        ,""         ,`BDBBT_cliplow    ,inf              ,"Gate dependent band-to-band tunneling shift exponent  of gate-edge component for drain-bulk junction")
`endif // JUNCAP_StandAlone

// JUNCAP2-express parameters
`MPRcc(SWJUNEXP       ,0.0        ,""         ,0.0               ,1.0              ,"Flag for JUNCAP-express; 0=full model, 1=express model")
`ifdef JUNCAP_StandAlone
    `MPRco(VJUNREF        ,2.5        ,"V"        ,`VJUNREF_cliplow  ,inf              ,"Typical maximum junction voltage; usually about 2*VSUP")
    `MPRco(FJUNQ          ,0.03       ,""         ,`FJUNQ_cliplow    ,inf              ,"Fraction below which junction capacitance components are considered negligible")
`else // JUNCAP_StandAlone
    `MPRco(VJUNREF        ,2.5        ,"V"        ,`VJUNREF_cliplow  ,inf              ,"Typical maximum source-bulk junction voltage; usually about 2*VSUP")
    `MPRco(FJUNQ          ,0.03       ,""         ,`FJUNQ_cliplow    ,inf              ,"Fraction below which source-bulk junction capacitance components are considered negligible")
    `MPRco(VJUNREFD       ,2.5        ,"V"        ,`VJUNREF_cliplow  ,inf              ,"Typical maximum drain-bulk junction voltage; usually about 2*VSUP")
    `MPRco(FJUNQD         ,0.03       ,""         ,`FJUNQ_cliplow    ,inf              ,"Fraction below which drain-bulk junction capacitance components are considered negligible")
`endif // JUNCAP_StandAlone
// ---- end `include "JUNCAP200_parlist.include" ----

//  --------------------------------------------------------------------------------------------------------------
//  Variables
//  --------------------------------------------------------------------------------------------------------------

//  Variables for switch (initial_model parts)
integer CHNL_TYPE;
`ifdef NQSmodel
    integer SWNQS_i;
    real r_nqs, vnorm, vnorm_inv;
`endif // NQSmodel

//  Instance local variables
real NF_i, invNF, L_i, W_i, SA_i, SB_i, SD_i, SC_i, XGW_i, JW_i, SCA_i, SCB_i, SCC_i, NGCON_i, MULT_inst, FACTUO_i;
real DELVTO_i, FACTUOEDGE_i, DELVTOEDGE_i;

//  Instance local variables for juncap
real ABS_i, LSS_i, LGS_i, ABD_i, LSD_i, LGD_i, jwcorr, jww;

//  Variables of internal global-binning parameters of charge model
real PoParam_i, PlParam_i, PwParam_i, PlwParam_i;
real THESATACO_i, THESATACL_i, THESATACLEXP_i, THESATACW_i, THESATACLW_i, AXACO_i, AXACL_i;
real KVSATAC_i;

//  Variables of local model parameters
real VFB_p, STVFB_p, ST2VFB_p, TOX_p, EPSROX_p, NEFF_p, GFACNUD_p, VSBNUD_p, DVSBNUD_p, DPHIB_p, NP_p, CT_p, CTG_p;
real CTB_p, STCT_p, TOXOV_p, TOXOVD_p, NOV_p, NOVD_p, PSCE_p, PSCED_p, PSCEB_p, CF_p, CFD_p, CFB_p, BETN_p, STBET_p;
real MUE_p, STMUE_p, THEMU_p, STTHEMU_p, CS_p, STCS_p, THECS_p, STTHECS_p, XCOR_p, STXCOR_p, FETA_p, RS_p, STRS_p;
real RSB_p, RSG_p, THESAT_p, STTHESAT_p, THESATB_p, THESATG_p, THESATT_p, AX_p, ALP_p, ALP1_p, ALP2_p, VP_p, A1_p;
real A2_p, STA2_p, A3_p, A4_p, IMAXII_p, GCO_p, IGINV_p, IGOV_p, IGOVD_p, STIG_p, GC2_p, GC3_p, GC2OV_p, GC3OV_p, GC2OVD_p, GC3OVD_p, CHIB_p;
real AGIDL_p, AGIDLD_p, BGIDL_p, BGIDLD_p, STBGIDL_p, STBGIDLD_p, CGIDL_p, CGIDLD_p, COX_p, DELVTAC_p, FACNEFFAC_p;
real THESATAC_p, AXAC_p, ALPAC_p, ALP1AC_p, CGOV_p, CGOVD_p, FCGOVACC_p, FCGOVACCD_p, CGOVACCG_p, CGBOV_p, CINR_p;
real CINRD_p, DVFBINR_p, FCINRDEP_p, FCINRACC_p, AXINR_p, CFR_p, CFRD_p, FNT_p, FNTEXC_p, NFA_p, NFB_p, NFC_p, EF_p;
real VFBEDGE_p, STVFBEDGE_p, DPHIBEDGE_p, NEFFEDGE_p, CTEDGE_p, BETNEDGE_p, STBETEDGE_p, PSCEEDGE_p, PSCEBEDGE_p;
real PSCEDEDGE_p, CFEDGE_p, CFDEDGE_p, CFBEDGE_p, FNTEDGE_p, NFAEDGE_p, NFBEDGE_p, NFCEDGE_p, EFEDGE_p, RG_p, RSH_i;
real RSHD_i, RSE_p, RDE_p, RWELL_p, RBULK_p, RJUNS_p, RJUND_p;
`ifdef SelfHeating
    real RTH_p, CTH_p, STRTH_p;
`endif // SelfHeating
`ifdef NQSmodel
    real MUNQS_p;
`endif // NQSmodel

//  Variables of clipped local model parameters
real VFB_i, STVFB_i, ST2VFB_i, STCT_i, TOX_i, EPSROX_i, NEFF_i, GFACNUD_i, VSBNUD_i, DVSBNUD_i, DPHIB_i, NP_i, CT_i;
real CTG_i, CTB_i, TOXOV_i, TOXOVD_i, NOV_i, NOVD_i, CF_i, CFD_i, CFB_i, PSCE_i, PSCEB_i, PSCED_i, BETN_i, STBET_i;
real MUE_i, STMUE_i, THEMU_i, STTHEMU_i, CS_i, STCS_i, THECS_i, STTHECS_i, XCOR_i, STXCOR_i, FETA_i, RS_i, STRS_i;
real RSB_i, RSG_i, THESAT_i, STTHESAT_i, THESATB_i, THESATG_i, THESATT_i, AX_i, ALP_i, ALP1_i, ALP2_i, VP_i, A1_i;
real A2_i, STA2_i, A3_i, A4_i, IMAXII_i, GCO_i, IGINV_i, IGOV_i, IGOVD_i, STIG_i, GC2_i, GC3_i, GC2OV_i, GC3OV_i, GC2OVD_i, GC3OVD_i, CHIB_i;
real AGIDL_i, AGIDLD_i, BGIDL_i, BGIDLD_i, STBGIDL_i, STBGIDLD_i, CGIDL_i, CGIDLD_i, COX_i, DELVTAC_i, FACNEFFAC_i;
real THESATAC_i, AXAC_i, ALPAC_i, ALP1AC_i, CGOV_i, CGOVD_i, FCGOVACC_i, FCGOVACCD_i, CGOVACCG_i, CGBOV_i, CINR_i;
real CINRD_i, DVFBINR_i, FCINRDEP_i, FCINRACC_i, AXINR_i, CFR_i, CFRD_i, FNT_i, FNTEXC_i, NFA_i, NFB_i, NFC_i, EF_i;
real VFBEDGE_i, STVFBEDGE_i, DPHIBEDGE_i, NEFFEDGE_i, CTEDGE_i, BETNEDGE_i, STBETEDGE_i, PSCEEDGE_i, PSCEBEDGE_i;
real PSCEDEDGE_i, CFEDGE_i, CFDEDGE_i, CFBEDGE_i, FNTEDGE_i, NFAEDGE_i, NFBEDGE_i, NFCEDGE_i, EFEDGE_i, RG_i, RSE_i;
real RDE_i, RBULK_i, RJUNS_i, RJUND_i, RWELL_i;
`ifdef SelfHeating
    real RTH_i, CTH_i, STRTH_i;
`endif // SelfHeating
`ifdef NQSmodel
    real MUNQS_i;
`endif // NQSmodel

//  Variables for scaling rules
real iL, iW, delLPS, delWOD, LE, WE, iLE, iLE2, iWE, iiWE, iAE, iiAE, LEcv, WEcv, iiWEcv, Lcv, Wcv, iiLcv, iiWcv;
real L_f, L_slif, W_f, XGWE, NSUB0e, NPCKe, LPCKe, AA, BB, NSUB, FBET1e, LP1e, GPE, GWE, tmpx, Lnoi, Lred, WE_edge;
real iWE_edge, iAE_edge, GPE_edge, KVTHOWE, KUOWE;
`ifdef SelfHeating
    real deltaRth;
`endif // SelfHeating

//  Variables for general temperature scaling
real TKR, TKA, rTa, delTa, phita, inv_phita, TKD, TKD_sq, delT, rTn, ln_rTn, inv_phit, Eg, phibFac;

//  JUNCAP2 variables
// ---- begin `include "JUNCAP200_varlist.include" ----
//======================================================================================
//======================================================================================
// Filename: JUNCAP200_varlist.include
//======================================================================================
//======================================================================================
//
//  (c) Copyright notice
//
//  Since 2015 until today, PSP has been co-developed by NXP Semiconductors and
//  CEA-Leti. For this part of the model, each claim undivided ownership and copyrights
//  Since 2012 until 2015, PSP has been co-developed by NXP Semiconductors and
//  Delft University of Technology. For this part of the model, each claim undivided
//  ownership and copyrights
//  Until and including 2011, PSP has been co-developed by NXP Semiconductors and
//  Arizona State University. For this part of the model, NXP Semiconductors claims
//  undivided ownership and copyrights.
//
//
//  Version: 200.7.0, March 2026
//
//======================================================================================
//======================================================================================
//
// Further information can be found in the file releasenotesPSP104.txt
//

// declaration of variables calculated outside macro "juncapfunction", voltage-independent part
real tkr, tkd, auxt, KBOL_over_QELE, phitr, phitrinv, phitd, phitdinv;
real perfc, berfc, cerfc;
real deltaphigr, deltaphigd, pmax;

real phigrbot, phigrsti, phigrgat, phigdbot, phigdsti, phigdgat;
real ftdbot, ftdsti, ftdgat, idsatbot, idsatsti, idsatgat;
real ubibot, ubisti, ubigat, vbibot, vbisti, vbigat;
real vbibot2, vbisti2, vbigat2, pbot2, psti2, pgat2, vbibot2r, vbisti2r, vbigat2r;
real vbiinvbot, vbiinvsti, vbiinvgat;
real one_minus_PBOT, one_minus_PSTI, one_minus_PGAT;
real one_over_one_minus_PBOT, one_over_one_minus_PSTI, one_over_one_minus_PGAT;
real cjobot, cjosti, cjogat;
real qprefbot, qprefsti, qprefgat, qpref2bot, qpref2sti, qpref2gat;
real wdepnulrbot, wdepnulrsti, wdepnulrgat, wdepnulrinvbot, wdepnulrinvsti, wdepnulrinvgat;
real VBIRBOTinv, VBIRSTIinv, VBIRGATinv;
real deltaEbot, deltaEsti, deltaEgat, atatbot, atatsti, atatgat;
real btatpartbot, btatpartsti, btatpartgat;
real fbbtbot, fbbtsti, fbbtgat;
real alphaav, fstopbot, fstopsti, fstopgat, VBRinvbot, VBRinvsti, VBRinvgat;
real slopebot, slopesti, slopegat;
real vmaxbot, vmaxsti, vmaxgat;

real cjorgat2nd, vbirgat2nd, pgat2nd, phiggat2nd, phigdgat2nd, phigrgat2nd, ftdgat2nd, ubigat2nd, vbigat2nd;
real vbiinvgat2nd, one_minus_pgat2nd ,one_over_one_minus_pgat2nd, cjogat2nd, qprefgat2nd, qpref2gat2nd;
real qjungat2nd, swgat2nd;

// JUNCAP-Express variables
real SWJUNEXP_i;
real I1, I2, I3, I4, I5;
real I1_cor, I2_cor, I3_cor, I4_cor, I5_cor;
real V1, V2, V3, V4, V5;
real alphaje, m0_rev, mcor_rev;
real tt0, tt1, tt2, tm0, tm1;
real FRACNA, FRACNB, FRACI;
real zfrac;
real ijunfor1, ijunfor2, ijunrev;

`ifdef JUNCAP_StandAlone
    // do nothing
`else // JUNCAP_StandAlone
    real CJORBOTD_i, CJORSTID_i, CJORGATD_i, VBIRBOTD_i, VBIRSTID_i, VBIRGATD_i;
    real PBOTD_i, PSTID_i, PGATD_i, PHIGBOTD_i, PHIGSTID_i, PHIGGATD_i;
    real IDSATRBOTD_i, IDSATRSTID_i, IDSATRGATD_i, XJUNSTID_i, XJUNGATD_i;
    real CSRHBOTD_i, CSRHSTID_i, CSRHGATD_i, CTATBOTD_i, CTATSTID_i, CTATGATD_i;
    real MEFFTATBOTD_i, MEFFTATSTID_i, MEFFTATGATD_i;
    real CBBTBOTD_i, CBBTSTID_i, CBBTGATD_i, FBBTRBOTD_i, FBBTRSTID_i, FBBTRGATD_i;
    real STFBBTBOTD_i, STFBBTSTID_i, STFBBTGATD_i;
    real VBRBOTD_i, VBRSTID_i, VBRGATD_i, PBRBOTD_i, PBRSTID_i, PBRGATD_i;

    real FCJORGAT2D_i, FVBIRGAT2D_i, FPGAT2D_i, FPHIGGAT2D_i, VTRGATD_i, ANUGATD_i;

    real VJUNREFD_i, FJUNQD_i;

    real phigrbot_d, phigrsti_d, phigrgat_d, phigdbot_d, phigdsti_d, phigdgat_d;
    real ftdbot_d, ftdsti_d, ftdgat_d, idsatbot_d, idsatsti_d, idsatgat_d;
    real ubibot_d, ubisti_d, ubigat_d, vbibot_d, vbisti_d, vbigat_d;
    real vbiinvbot_d, vbiinvsti_d, vbiinvgat_d;
    real one_minus_PBOT_d, one_minus_PSTI_d, one_minus_PGAT_d;
    real one_over_one_minus_PBOT_d, one_over_one_minus_PSTI_d, one_over_one_minus_PGAT_d;
    real cjobot_d, cjosti_d, cjogat_d;
    real qprefbot_d, qprefsti_d, qprefgat_d, qpref2bot_d, qpref2sti_d, qpref2gat_d;
    real wdepnulrbot_d, wdepnulrsti_d, wdepnulrgat_d, wdepnulrinvbot_d, wdepnulrinvsti_d, wdepnulrinvgat_d;
    real VBIRBOTinv_d, VBIRSTIinv_d, VBIRGATinv_d;
    real deltaEbot_d, deltaEsti_d, deltaEgat_d, atatbot_d, atatsti_d, atatgat_d;
    real btatpartbot_d, btatpartsti_d, btatpartgat_d;
    real fbbtbot_d, fbbtsti_d, fbbtgat_d;
    real fstopbot_d, fstopsti_d, fstopgat_d, VBRinvbot_d, VBRinvsti_d, VBRinvgat_d;
    real slopebot_d, slopesti_d, slopegat_d;

    real cjorgat2nd_d, vbirgat2nd_d, pgat2nd_d, phiggat2nd_d, phigdgat2nd_d, phigrgat2nd_d, ftdgat2nd_d, ubigat2nd_d, vbigat2nd_d;
    real vbiinvgat2nd_d, one_minus_pgat2nd_d ,one_over_one_minus_pgat2nd_d, cjogat2nd_d, qprefgat2nd_d, qpref2gat2nd_d;
    real swgat2nd_d;

    real ADVBRGATD_i, BDVBRGATD_i, ADBBTGATD_i, BDBBTGATD_i;
    real vbrgat_var, vbrgat_var_d, dvbrgat, dvbrgat_d, dfbbtgat, dfbbtgat_d;

`endif // JUNCAP_StandAlone

//================================================================
// Variables that are different for source and drain side junction
// and have a scope larger than a single macro-call
//================================================================

`ifdef JUNCAP_StandAlone
    real AB_i, LS_i, LG_i;
    real zflagbot, zflagsti, zflaggat;
    real VMAX, exp_VMAX_over_phitd, vbimin, vch, vfmin, vbbtlim;

    // JUNCAP-express variables
    real xhighf1, expxhf1, xhighf2, expxhf2, xhighr, expxhr;

    // JUNCAP2-express intermediate parameters
    real ISATFOR1, MFOR1, ISATFOR2, MFOR2, ISATREV, MREV, m0flag;
`else // JUNCAP_StandAlone
    real ABSOURCE_i, LSSOURCE_i, LGSOURCE_i, AS_i, PS_i;
    real zflagbot_s, zflagsti_s, zflaggat_s;
    real VMAX_s, exp_VMAX_over_phitd_s, vbimin_s, vch_s, vfmin_s, vbbtlim_s;

    // JUNCAP-express variables
    real xhighf1_s, expxhf1_s, xhighf2_s, expxhf2_s, xhighr_s, expxhr_s, m0flag_s;

    // JUNCAP2-express intermediate parameters
    real ISATFOR1_s, MFOR1_s, ISATFOR2_s, MFOR2_s, ISATREV_s, MREV_s;

    real ABDRAIN_i, LSDRAIN_i, LGDRAIN_i, AD_i, PD_i;
    real zflagbot_d, zflagsti_d, zflaggat_d;
    real VMAX_d, exp_VMAX_over_phitd_d, vbimin_d, vch_d, vfmin_d, vbbtlim_d;

    // JUNCAP-express variables
    real xhighf1_d, expxhf1_d, xhighf2_d, expxhf2_d, xhighr_d, expxhr_d, m0flag_d;

    // JUNCAP2-express intermediate parameters
    real ISATFOR1_d, MFOR1_d, ISATFOR2_d, MFOR2_d, ISATREV_d, MREV_d;
`endif // JUNCAP_StandAlone
// ---- end `include "JUNCAP200_varlist.include" ----

//  Local parameters after temperature scaling and variables used in self heating effect
real VFB_T, CT_T, CTG_T, BETN_T, MUE_T, THEMU_T, CS_T, THECS_T, XCOR_T, RS_T, BGIDL_T, BGIDLD_T, A2_T, VFBEDGE_T;
real BETNEDGE_T;
`ifdef SelfHeating
    real RTH_T;
`else // SelfHeating
    // in the self heating model, these variables are declared locally in the evaluate block
    real phit, BET_i, BETEDGE_i, nt0, nt, THESAT_T, THESATAC_T, Sfl_prefac, phit0edge, Gfedge2, lnGfedge2;
    real Sfl_prefac_edge, ntedge;
`endif // SelfHeating

//  Variables for channel temperature scaling (including self heating effect)
real phib_dc, G_0_dc, kp, np, arg2max, qlim2, qb0, dphibq, sqrt_phib_dc, phix_dc, aphi_dc, bphi_dc, phix2, phix1_dc;
real alpha_b, us1, us21, phib_ac, G_0_ac, phix_ac, aphi_ac, bphi_ac, phix1_ac, tf_ct, tf_bet, tf_mue, tf_cs, tf_xcor;
real tf_ther, THER_i, tf_thesat, tf_betedge, phibedge, Gfedge, phixedge, aphiedge, bphiedge, phix2edge, phix1edge;

//  Variables used in instance initializing
real EPSSI, EPSOX, CoxPrime, tox_sq, Cox_over_q, NEFFAC_i, qq, E_eff0, eta_mu, eta_mu1, ar, arac, inv_VP, CoxovPrime;
real CoxovPrime_d, GOV_s, GOV_d, GOV2_s, GOV2_d, dxgb_ov_th, dxgb_ov_s, dxgb_ov_d, SP_OV_eps2_s, SP_OV_a_s;
real SP_OV_delta1_s, SP_OV_eps2_d, SP_OV_a_d, SP_OV_delta1_d, inv_CHIB, B_fact, BCH, BOV, BOV_d, GCQ, GCQOV, GCQOVD, tf_ig;
real AGIDLs, AGIDLDs, BGIDLs, BGIDLDs, Vinr_max, ainr, fac_exc, ggate, gsource, gdrain, gbulk, gjuns, gjund, gwell;

//  Global variables used in macros
real tme1, tme2;
real inv_GOV, SP_OV_eps, SP_OV_delta, mutau, nu;

//  Variables for bias affectation
real V_gs, V_ds, V_sb, V_db, Vgb, Vdsx, sigVds, Vjun_s, Vjun_d, VgsPrime, VsbPrime, VdbPrime, VgdPrime;

//  Currents contributions
real I_ds, Igsov, Igdov, I_gcs, I_gcd, I_gb, I_gisl, I_gidl, I_dsedge, Iimpact, ijun_s, ijun_d;

//  Charges contributions
real Qs, Qg, Qb, Qd, Qfgs, Qfgd, Qgb_ov, qjun_s, qjun_d;

//  Noise contributions
real mig, CGeff, migid, sqid, c_igid, S_fl, shot_igs, shot_igd, jnoise_s, jnoise_d, Sfledge, sqidedge, rgatenoise;
real rsourcenoise, rdrainnoise, rbulknoise, rjunsnoise, rjundnoise, rwellnoise;

//  Gmin variable
real gmin;

//  --------------------------------------------------------------------------------------------------------------
//  Variables for operating point info
//  --------------------------------------------------------------------------------------------------------------
// Standard OP-output variables
`OPVarDecl

// Local parameters output for PSP-model including self-heating effect
`ifdef SelfHeating
    `OPVarDecl_she
`endif

//  --------------------------------------------------------------------------------------------------------------
//  Analog block with all calculations and contribs
//  --------------------------------------------------------------------------------------------------------------
analog begin

    //  --------------------------------------------------------------------------------------------------------------
    //  Definition of bias/instance independent model variables
    //  --------------------------------------------------------------------------------------------------------------
    begin : initial_model

        //  Clipping and rounding of switch parameters
        if (TYPE >= 0) begin
            CHNL_TYPE    = `NMOS;
        end else begin
            CHNL_TYPE    = `PMOS;
        end
        EPSSI        = `EPSO * `EPSRSI;
        `ifdef NQSmodel
            if (SWNQS < 0.5) begin
                SWNQS_i      =  0;
            end else begin
                if (SWNQS < 1.5) begin
                    SWNQS_i      =  1;
                end else begin
                    if (SWNQS < 2.5) begin
                        SWNQS_i      =  2;
                    end else begin
                        if (SWNQS < 4.0) begin
                            SWNQS_i      =  3;
                        end else begin
                            if (SWNQS < 7.0) begin
                                SWNQS_i      =  5;
                            end else begin
                                SWNQS_i      =  9;
                            end
                        end
                    end
                end
            end
            r_nqs        =  1.0e03;
            vnorm        =  10.0;
            vnorm_inv    =  1.0 / vnorm;
        `endif // NQSmodel

        //  Reference temperature
        TKR          = `KELVINCONVERSION + TR;

        // JUNCAP2
        `JUNCAP200_InitModel_Model
        `JUNCAP200_InitModel_Model_Drain_Junction

        //  Gmin definition
        gmin         =  $simparam("gmin",0.0);

        //  Configuration of Op-output variables
        `OPConfig

    end // initial_model

    //  --------------------------------------------------------------------------------------------------------------
    //  Definition of instance dependent and bias independent variables
    //  --------------------------------------------------------------------------------------------------------------
    begin : initial_instance

        //  Declaration of local variables
        real Invsa, Invsb, Invsaref, Invsbref, Kstressu0, rhobeta, rhobetaref, Kstressvth0;
        real temp, temp0, temp00, templ, tempw, Lx, Wx, loop, tmpa, tmpb;

        //  Transistor temperature
        TKA          =  $temperature + DTA + TRISE;
        rTa          =  TKA / TKR;
        delTa        =  TKA - TKR;
        phita        =  TKA * `KBOL / `QELE;
        inv_phita    =  1.0 / phita;
        `ifdef SelfHeating
            // do nothing
        `else // SelfHeating
            TKD          =  TKA;
            `TempInitialize
        `endif // SelfHeating

        // JUNCAP2
        `JUNCAP200_InitModel_Instance
        `JUNCAP200_InitModel_Instance_Drain_Junction

        //  Instance variables
        NF_i         =  1.0;
        invNF        =  1.0;
        LE           =  0.0;
        WE           =  0.0;
        L_i          =  L;
        W_i          =  W;
        SA_i         =  SA;
        SB_i         =  SB;
        SD_i         =  SD;
        SC_i         =  SC;
        XGW_i        =  XGW;
        ABSOURCE_i   =  ABSOURCE;
        LSSOURCE_i   =  LSSOURCE;
        LGSOURCE_i   =  LGSOURCE;
        ABDRAIN_i    =  ABDRAIN;
        LSDRAIN_i    =  LSDRAIN;
        LGDRAIN_i    =  LGDRAIN;
        AS_i         =  AS;
        PS_i         =  PS;
        AD_i         =  AD;
        PD_i         =  PD;
        JW_i         =  JW;

        //  Clipping of the instance parameters
        if (SWGEO > 0) begin
            NF_i         = `CLIP_LOW(NF, 1.0);
            NF_i         =  floor(NF_i + 0.5); // round to nearest integer
            invNF        =  1.0 / NF_i;
        end
        W_i          = `CLIP_LOW(W_i * invNF, 1.0e-09);
        SCA_i        =  SCA;
        SCB_i        =  SCB;
        SCC_i        =  SCC;
        NGCON_i      =  (NGCON < 1.5) ? 1.0 : 2.0;

        //  Internal local parameters
// ---- begin `include "PSP104_scaling.include" ----
//======================================================================================
//======================================================================================
// Filename: PSP104_scaling.include
//======================================================================================
//======================================================================================
//
//  (c) Copyright notice
//
//  Since 2015 until today, PSP has been co-developed by NXP Semiconductors and
//  CEA-Leti. For this part of the model, each claim undivided ownership and copyrights
//  Since 2012 until 2015, PSP has been co-developed by NXP Semiconductors and
//  Delft University of Technology. For this part of the model, each claim undivided
//  ownership and copyrights
//  Until and including 2011, PSP has been co-developed by NXP Semiconductors and
//  Arizona State University. For this part of the model, NXP Semiconductors claims
//  undivided ownership and copyrights.
//
//
//  Version: 104.1.0 (PSP), 200.7.0 (JUNCAP), March 2026
//
//======================================================================================
//======================================================================================
//
// Further information can be found in the file releasenotesPSP104.txt
//

// ******************************* Transistor geometry *******************************
iL           = `LEN / L_i;
iW           = `WEN / W_i;
delLPS       =  LVARO * (1.0 + LVARL * iL) * (1.0 + LVARW * iW);
delWOD       =  WVARO * (1.0 + WVARL * iL) * (1.0 + WVARW * iW);
LE           = `CLIP_LOW(L_i + delLPS - 2.0 * LAP, 1.0e-09);
WE           = `CLIP_LOW(W_i + delWOD - 2.0 * WOT, 1.0e-09);
iLE          = `LEN / LE;
iLE2         =  iLE * iLE;
iWE          = `WEN / WE;
iiWE         =  1.0 / iWE;
iAE          =  iLE * iWE;
iiAE         =  1.0 / iAE;
LEcv         = `CLIP_LOW(L_i + delLPS - 2.0 * LAP + DLQ, 1.0e-09);
WEcv         = `CLIP_LOW(W_i + delWOD - 2.0 * WOT + DWQ, 1.0e-09);
iiWEcv       =  WEcv / `WEN;
Lcv          = `CLIP_LOW(L_i + delLPS + DLQ, 1.0e-09);
Wcv          = `CLIP_LOW(W_i + delWOD + DWQ, 1.0e-09);
iiLcv        =  Lcv / `LEN;
iiWcv        =  Wcv / `WEN;

// ******************************* Geometry for multi-finger devices *******************************
L_f          = `CLIP_LOW(L_i + delLPS, 1.0e-09);
L_slif       = `CLIP_LOW(L_f + DLSIL, 1.0e-09);
W_f          = `CLIP_LOW(W_i + delWOD, 1.0e-09);
XGWE         = `CLIP_LOW(XGW_i - 0.5 * delWOD, 1.0e-09);

// ******************************* Local model parameters *******************************
//  Flat-band voltage parameters
VFB_p        =  VFB;
STVFB_p      =  STVFB;
ST2VFB_p     =  ST2VFB;

//  Process parameters
TOX_p        =  TOX;
EPSROX_p     =  EPSROX;
NEFF_p       =  NEFF;
GFACNUD_p    =  GFACNUD;
VSBNUD_p     =  VSBNUD;
DVSBNUD_p    =  DVSBNUD;
DPHIB_p      =  DPHIB;
NP_p         =  NP;
TOXOV_p      =  TOXOV;
TOXOVD_p     =  TOXOVD;
NOV_p        =  NOV;
NOVD_p       =  NOVD;

//  Interface states parameters
CT_p         =  CT;
CTG_p        =  CTG;
CTB_p        =  CTB;
STCT_p       =  STCT;

//  Subthreshold slope parameters of short channel transistor
PSCE_p       =  PSCE;
PSCED_p      =  PSCED;
PSCEB_p      =  PSCEB;

//  DIBL parameters
CF_p         =  CF;
CFD_p        =  CFD;
CFB_p        =  CFB;

//  Mobility parameters
BETN_p       =  BETN;
STBET_p      =  STBET;
MUE_p        =  MUE;
STMUE_p      =  STMUE;
THEMU_p      =  THEMU;
STTHEMU_p    =  STTHEMU;
CS_p         =  CS;
STCS_p       =  STCS;
THECS_p      =  THECS;
STTHECS_p    =  STTHECS;
XCOR_p       =  XCOR;
STXCOR_p     =  STXCOR;
FETA_p       =  FETA;

//  Intrinsic series resistance parameters
RS_p         =  RS;
STRS_p       =  STRS;
RSB_p        =  RSB;
RSG_p        =  RSG;

//  Saturation voltage parameters
THESAT_p     =  THESAT;
STTHESAT_p   =  STTHESAT;
THESATB_p    =  THESATB;
THESATG_p    =  THESATG;
THESATT_p    =  THESATT;

//  Saturation voltage parameters
AX_p         =  AX;

//  Channel length modulation parameters
ALP_p        =  ALP;
ALP1_p       =  ALP1;
ALP2_p       =  ALP2;
VP_p         =  VP;

//  Impact ionization parameters
A1_p         =  A1;
A2_p         =  A2;
STA2_p       =  STA2;
A3_p         =  A3;
A4_p         =  A4;
IMAXII_p     =  IMAXII;

//  Gate current parameters
GCO_p        =  GCO;
IGINV_p      =  IGINV;
IGOV_p       =  IGOV;
IGOVD_p      =  IGOVD;
STIG_p       =  STIG;
GC2_p        =  GC2;
GC3_p        =  GC3;
GC2OV_p      =  GC2;
if ($param_given(GC2OV) == 1)
    GC2OV_p      =  GC2OV;
GC3OV_p      =  GC3;
if ($param_given(GC3OV) == 1)
    GC3OV_p      =  GC3OV;
GC2OVD_p      =  GC2OV_p;
if ($param_given(GC2OVD) == 1)
    GC2OVD_p      =  GC2OVD;
GC3OVD_p      =  GC3OV_p;
if ($param_given(GC3OVD) == 1)
    GC3OVD_p      =  GC3OVD;
CHIB_p       =  CHIB;

//  Gate-induced drain leakage parameters
AGIDL_p      =  AGIDL;
AGIDLD_p     =  AGIDLD;
BGIDL_p      =  BGIDL;
BGIDLD_p     =  BGIDLD;
STBGIDL_p    =  STBGIDL;
STBGIDLD_p   =  STBGIDLD;
CGIDL_p      =  CGIDL;
CGIDLD_p     =  CGIDLD;

//  Charge model parameters
COX_p        =  COX;
DELVTAC_p    =  DELVTAC;
FACNEFFAC_p  =  FACNEFFAC;
`DefACparam(THESATAC_p, THESAT, THESATAC)
`DefACparam(AXAC_p, AX, AXAC)
ALPAC_p      =  ALPAC;
ALP1AC_p     =  ALP1AC;
CGOV_p       =  CGOV;
CGOVD_p      =  CGOVD;
FCGOVACC_p   =  FCGOVACC;
FCGOVACCD_p  =  FCGOVACCD;
CGOVACCG_p   =  CGOVACCG;
CGBOV_p      =  CGBOV;
CINR_p       =  CINR;
CINRD_p      =  CINRD;
DVFBINR_p    =  DVFBINR;
FCINRDEP_p   =  FCINRDEP;
FCINRACC_p   =  FCINRACC;
AXINR_p      =  AXINR;
CFR_p        =  CFR;
CFRD_p       =  CFRD;

//  Noise model parameters
FNT_p        =  FNT;
FNTEXC_p     =  FNTEXC;
NFA_p        =  NFA;
NFB_p        =  NFB;
NFC_p        =  NFC;
EF_p         =  EF;

//  Edge transistor parameters
VFBEDGE_p    =  VFBEDGE;
STVFBEDGE_p  =  STVFBEDGE;
DPHIBEDGE_p  =  DPHIBEDGE;
NEFFEDGE_p   =  NEFFEDGE;
CTEDGE_p     =  CTEDGE;
BETNEDGE_p   =  BETNEDGE;
STBETEDGE_p  =  STBETEDGE;
PSCEEDGE_p   =  PSCEEDGE;
PSCEBEDGE_p  =  PSCEBEDGE;
PSCEDEDGE_p  =  PSCEDEDGE;
CFEDGE_p     =  CFEDGE;
CFDEDGE_p    =  CFDEDGE;
CFBEDGE_p    =  CFBEDGE;
FNTEDGE_p    =  FNTEDGE;
NFAEDGE_p    =  NFAEDGE;
NFBEDGE_p    =  NFBEDGE;
NFCEDGE_p    =  NFCEDGE;
EFEDGE_p     =  EFEDGE;

//  Parasitic resistance parameters
RG_p         =  RG;
RSE_p        =  RSE;
RDE_p        =  RDE;
RWELL_p      =  RWELL;
RBULK_p      =  RBULK;
RJUNS_p      =  RJUNS;
RJUND_p      =  RJUND;

//  SHE parameters
`ifdef SelfHeating
    RTH_p        =  RTH;
    CTH_p        =  CTH;
    STRTH_p      =  STRTH;
`endif // SelfHeating

//  NQS parameters
`ifdef NQSmodel
    MUNQS_p      =  MUNQS;
`endif // NQSmodel

// ******************************* Global model parameters ******************************
if (SWGEO > 0) begin

    //  Flat-band voltage parameters
    VFB_p        =  VFBO + VFBL * pow(iLE, VFBLEXP) + VFBW * iWE + VFBLW * iAE;
    STVFB_p      =  STVFBO + STVFBL * iLE + STVFBW * iWE + STVFBLW * iAE;
    ST2VFB_p     =  ST2VFBO;

    //  Process parameters
    TOX_p        =  TOXO;
    EPSROX_p     =  EPSROXO;
    NSUB0e       =  NSUBO * `MAX((1.0 + NSUBW * iWE * ln(1.0 + WE / WSEG)), 1.0e-03);
    NPCKe        =  NPCK * `MAX((1.0 + NPCKW * iWE * ln(1.0 + WE / WSEGP)), 1.0e-03);
    LPCKe        =  LPCK * `MAX((1.0 + LPCKW * iWE * ln(1.0 + WE / WSEGP)), 1.0e-03);
    if (LE > (2.0 * LPCKe)) begin
        AA           =  7.5e10;
        BB           =  sqrt(NSUB0e + 0.5 * NPCKe) - sqrt(NSUB0e);
        NSUB         =  sqrt(NSUB0e) + AA * ln(1.0 + 2.0 * LPCKe / LE * (exp(BB / AA) - 1.0));
        NSUB         =  NSUB * NSUB;
    end else begin
        if (LE >= LPCKe) begin
            NSUB         =  NSUB0e + NPCKe * LPCKe / LE;
        end else begin // LE < LPCK
            NSUB         =  NSUB0e + NPCKe * (2.0 - LE / LPCKe);
        end
    end
    NEFF_p       =  NSUB * (1.0 - FOL1 * iLE - FOL2 * iLE2);
    GFACNUD_p    =  GFACNUDO + GFACNUDL * pow(iLE, GFACNUDLEXP) + GFACNUDW * iWE + GFACNUDLW * iAE;
    VSBNUD_p     =  VSBNUDO;
    DVSBNUD_p    =  DVSBNUDO;
    DPHIB_p      =  DPHIBO + DPHIBL * pow(iLE, DPHIBLEXP) + DPHIBW * iWE + DPHIBLW * iAE;
    NP_p         =  NPO * `MAX(1.0e-06, (1.0 + NPL * iLE));
    TOXOV_p      =  TOXOVO;
    TOXOVD_p     =  TOXOVDO;
    NOV_p        =  NOVO;
    NOVD_p       =  NOVDO;

    //  Interface states parameters
    CT_p         =  (CTO + CTL * pow(iLE, CTLEXP)) * (1.0 + CTW * iWE) * (1.0 + CTLW * iAE);
    CTG_p        =  CTGO;
    CTB_p        =  CTBO;
    STCT_p       =  STCTO;

    //  DIBL parameters
    CF_p         =  CFL * pow(iLE, CFLEXP) * (1.0 + CFW * iWE);
    CFD_p        =  CFDO;
    CFB_p        =  CFBO;

    //  Subthreshold slope parameters of short channel transistor
    PSCE_p       =  PSCEL * pow(iLE, PSCELEXP) * (1.0 + PSCEW * iWE);
    PSCED_p      =  PSCEDO;
    PSCEB_p      =  PSCEBO;

    //  Mobility parameters
    FBET1e       =  FBET1 * (1.0 + FBET1W * iWE);
    LP1e         =  LP1 * `MAX(1.0 + LP1W * iWE, 1.0e-03);
    GPE          =  1.0 + FBET1e * LP1e / LE * (1.0 - exp(-LE / LP1e)) + FBET2 * LP2 / LE * (1.0 - exp(-LE / LP2));
    GPE          = `MAX(GPE, 1.0e-15);
    GWE          =  1.0 + BETW1 * iWE + BETW2 * iWE * ln(1.0 + WE / WBET);
    BETN_p       =  UO * WE / (GPE * LE) * GWE;
    STBET_p      =  STBETO + STBETL * iLE + STBETW * iWE + STBETLW * iAE;
    MUE_p        =  MUEO * (1.0 + MUEW * iWE);
    STMUE_p      =  STMUEO;
    THEMU_p      =  THEMUO;
    STTHEMU_p    =  STTHEMUO;
    CS_p         =  (CSO + CSL * pow(iLE, CSLEXP)) * (1.0 + CSW * iWE) * (1.0 + CSLW * iAE);
    STCS_p       =  STCSO;
    THECS_p      =  THECSO;
    STTHECS_p    =  STTHECSO;
    XCOR_p       =  XCORO * (1.0 + XCORL * iLE) * (1.0 + XCORW * iWE) * (1.0 + XCORLW * iAE);
    STXCOR_p     =  STXCORO;
    FETA_p       =  FETAO;

    //  Intrinsic series resistance parameters
    RS_p         =  RSW1 * iWE * (1.0 + RSW2 * iWE);
    STRS_p       =  STRSO;
    RSB_p        =  RSBO;
    RSG_p        =  RSGO;

    //  Velocity saturation parameters
    THESAT_p     =  (THESATO + THESATL * GWE / GPE * pow(iLE, THESATLEXP)) * (1.0 + THESATW * iWE) * (1.0 + THESATLW * iAE);
    STTHESAT_p   =  STTHESATO + STTHESATL * iLE + STTHESATW * iWE + STTHESATLW * iAE;
    THESATB_p    =  THESATBO;
    THESATG_p    =  THESATGO;
    THESATT_p    =  THESATTO;

    //  Saturation voltage parameters
    AX_p         =  AXO / (1.0 + AXL * iLE);

    //  Channel length modulation parameters
    ALP_p        =  ALPL * pow(iLE, ALPLEXP) * (1.0 + ALPW * iWE);
    tmpx         =  pow(iLE, ALP1LEXP);
    ALP1_p       =  ALP1L1 * tmpx * (1.0 + ALP1W * iWE) / (1.0 + ALP1L2 * iLE * tmpx);
    tmpx         =  pow(iLE, ALP2LEXP);
    ALP2_p       =  ALP2L1 * tmpx * (1.0 + ALP2W * iWE) / (1.0 + ALP2L2 * iLE * tmpx);
    VP_p         =  VPO;

    //  Impact ionization parameters
    A1_p         =  A1O * (1.0 + A1L * iLE) * (1.0 + A1W * iWE);
    A2_p         =  A2O;
    STA2_p       =  STA2O;
    A3_p         =  A3O * (1.0 + A3L * iLE) * (1.0 + A3W * iWE);
    A4_p         =  A4O * (1.0 + A4L * iLE) * (1.0 + A4W * iWE);
    IMAXII_p     =  IMAXIIO;

    //  Gate current parameters
    GCO_p        =  GCOO;
    IGINV_p      =  IGINVLW / iAE;
    IGOV_p       =  IGOVW * LOV / (`LEN * iWE);
    IGOVD_p      =  IGOVDW * LOVD / (`LEN * iWE);
    STIG_p       =  STIGO;
    GC2_p        =  GC2O;
    GC3_p        =  GC3O;
    GC2OV_p      =  GC2O;
    if ($param_given(GC2OVO) == 1)
        GC2OV_p      =  GC2OVO;
    GC3OV_p      =  GC3O;
    if ($param_given(GC3OVO) == 1)
        GC3OV_p      =  GC3OVO;
    GC2OVD_p      =  GC2OV_p;
    if ($param_given(GC2OVDO) == 1)
        GC2OVD_p      =  GC2OVDO;
    GC3OVD_p      =  GC3OV_p;
    if ($param_given(GC3OVDO) == 1)
        GC3OVD_p      =  GC3OVDO;
    CHIB_p       =  CHIBO;

    //  Gate-induced drain leakage parameters
    AGIDL_p      =  AGIDLW * LOV / (`LEN * iWE);
    AGIDLD_p     =  AGIDLDW * LOVD / (`LEN * iWE);
    BGIDL_p      =  BGIDLO;
    BGIDLD_p     =  BGIDLDO;
    STBGIDL_p    =  STBGIDLO;
    STBGIDLD_p   =  STBGIDLDO;
    CGIDL_p      =  CGIDLO;
    CGIDLD_p     =  CGIDLDO;

    //  Charge model parameters
    COX_p        = `EPSO * EPSROXO * WEcv * LEcv / TOXO;
    CGOV_p       = `EPSO * EPSROXO * WEcv * LOV / TOXOVO;
    CGOVD_p      = `EPSO * EPSROXO * WEcv * LOVD / TOXOVDO;
    DELVTAC_p    =  DELVTACO + DELVTACL * pow(iLE, DELVTACLEXP) + DELVTACW * iWE + DELVTACLW * iAE;
    FACNEFFAC_p  =  FACNEFFACO + FACNEFFACL * iLE + FACNEFFACW * iWE + FACNEFFACLW * iAE;
    `DefACparam(THESATACO_i, THESATO, THESATACO)
    `DefACparam(THESATACL_i, THESATL, THESATACL)
    `DefACparam(THESATACLEXP_i, THESATLEXP, THESATACLEXP)
    `DefACparam(THESATACW_i, THESATW, THESATACW)
    `DefACparam(THESATACLW_i, THESATLW, THESATACLW)
    THESATAC_p   =  (THESATACO_i + THESATACL_i * GWE / GPE * pow(iLE, THESATACLEXP_i)) * (1.0 + THESATACW_i * iWE) * (1.0 + THESATACLW_i * iAE);
    `DefACparam(AXACO_i, AXO, AXACO)
    `DefACparam(AXACL_i, AXL, AXACL)
    AXAC_p       =  AXACO_i / (1.0 + AXACL_i * iLE);
    ALPAC_p      =  ALPACL * pow(iLE, ALPACLEXP) * (1.0 + ALPACW * iWE);
    tmpx         =  pow(iLE, ALP1ACLEXP);
    ALP1AC_p     =  ALP1ACL1 * tmpx * (1.0 + ALP1ACW * iWE) / (1.0 + ALP1ACL2 * iLE * tmpx);
    FCGOVACC_p   =  FCGOVACCO;
    FCGOVACCD_p  =  FCGOVACCDO;
    CGOVACCG_p   =  CGOVACCGO;
    CGBOV_p      =  CGBOVL * iiLcv;
    CINR_p       =  CINRW * iiWEcv;
    CINRD_p      =  CINRDW * iiWEcv;
    DVFBINR_p    =  DVFBINRO;
    FCINRDEP_p   =  FCINRDEPO;
    FCINRACC_p   =  FCINRACCO;
    AXINR_p      =  AXINRO;
    CFR_p        =  CFRW * iiWcv;
    CFRD_p       =  CFRDW * iiWcv;

    // Noise model parameters
    temp0        =  1.0 - 2.0 * LINTNOI / LE;
    Lnoi         = `MAX(temp0, 1.0e-03);
    Lred         =  1.0 / pow(Lnoi, ALPNOI);
    FNT_p        =  FNTO;
    FNTEXC_p     =  FNTEXCL * BETN_p * BETN_p * iWE * iWE;
    NFA_p        =  Lred * iAE * NFALW;
    NFB_p        =  Lred * iAE * NFBLW;
    NFC_p        =  Lred * iAE * NFCLW;
    EF_p         =  EFO;

    //  Edge transistors parameters
    WE_edge      =  2.0 * WEDGE + WEDGEW * WE;
    iWE_edge     = `WEN / WE_edge;
    iAE_edge     =  iLE * iWE_edge;
    VFBEDGE_p    =  VFBEDGEO;
    STVFBEDGE_p  =  STVFBEDGEO + STVFBEDGEL * iLE + STVFBEDGEW * iWE + STVFBEDGELW * iAE;
    DPHIBEDGE_p  =  DPHIBEDGEO + DPHIBEDGEL * pow(iLE, DPHIBEDGELEXP) + DPHIBEDGEW * iWE + DPHIBEDGELW * iAE;
    NEFFEDGE_p   =  NSUBEDGEO * (1.0 + NSUBEDGEL * pow(iLE, NSUBEDGELEXP)) * ( 1.0 + NSUBEDGEW * iWE) * ( 1.0 + NSUBEDGELW * iAE);
    CTEDGE_p     =  CTEDGEO + CTEDGEL * pow(iLE, CTEDGELEXP);
    GPE_edge     =  1.0 + FBETEDGE * LPEDGE / LE * (1.0 - exp(-LE / LPEDGE));
    GPE_edge     = `MAX(GPE_edge, 1.0e-15);
    BETNEDGE_p   =  UO * WE_edge / (GPE_edge * LE) * (1.0 + BETEDGEW * iWE);
    STBETEDGE_p  =  STBETEDGEO + STBETEDGEL * iLE + STBETEDGEW * iWE + STBETEDGELW * iAE;
    PSCEEDGE_p   =  PSCEEDGEL * pow(iLE, PSCEEDGELEXP) * (1.0 + PSCEEDGEW * iWE);
    PSCEBEDGE_p  =  PSCEBEDGEO;
    PSCEDEDGE_p  =  PSCEDEDGEO;
    CFEDGE_p     =  CFEDGEL * pow(iLE, CFEDGELEXP) * (1.0 + CFEDGEW * iWE);
    CFDEDGE_p    =  CFDEDGEO;
    CFBEDGE_p    =  CFBEDGEO;
    FNTEDGE_p    =  FNTEDGEO;
    NFAEDGE_p    =  iAE_edge * NFAEDGELW;
    NFBEDGE_p    =  iAE_edge * NFBEDGELW;
    NFCEDGE_p    =  iAE_edge * NFCEDGELW;
    EFEDGE_p     =  EFEDGEO;

    // Well proximity effect parameters
    KVTHOWE      =  KVTHOWEO + KVTHOWEL * iLE + KVTHOWEW * iWE + KVTHOWELW * iAE;
    KUOWE        =  KUOWEO + KUOWEL * iLE + KUOWEW * iWE + KUOWELW * iAE;

    //  Parasitic resistance parameters
    RG_p         =  RSHG * (`oneThird * W_f / NGCON_i + XGWE) / (NGCON_i * L_slif) + (RINT + RVPOLY) / (W_f * L_f) + NF_i * RGO;
    RSH_i        = `CLIP_LOW(RSH, 0.0);
    RSHD_i       = `CLIP_LOW(RSHD, 0.0);
    if (SWJUNASYM == 0) begin
        RSHD_i       =  RSH_i;
    end
    RSE_p        =  NF_i * NRS * RSH_i;
    RDE_p        =  NF_i * NRD * RSHD_i;
    RWELL_p      =  NF_i * RWELLO;
    RBULK_p      =  NF_i * RBULKO;
    RJUNS_p      =  NF_i * RJUNSO;
    RJUND_p      =  NF_i * RJUNDO;

    //  Self heating effect parameters
    `ifdef SelfHeating
        deltaRth     =  RTHW2 + (1.0 + RTHLW / iLE) / iWE;
        deltaRth     = `MAX(deltaRth, 1.0e-06);
        RTH_p        =  RTHO + RTHW1 / deltaRth;
        CTH_p        =  CTHO + CTHW1 * (CTHW2 + (1.0 + CTHLW / iLE)) / iWE;
        STRTH_p      =  STRTHO;
    `endif // SelfHeating

    //  NQS parameters
    `ifdef NQSmodel
        MUNQS_p      =  MUNQSO;
    `endif // NQSmodel

    // ******************************* Binning parameters ******************************
    //  Flat-band voltage parameters
    `BinningRuleFct(VFB_p, POVFB, PLVFB, PWVFB, PLWVFB)
    `BinningRuleFct(STVFB_p, POSTVFB, PLSTVFB, PWSTVFB, PLWSTVFB)

    //  Process parameters
    `BinningRuleFct(NEFF_p, PONEFF, PLNEFF, PWNEFF, PLWNEFF)
    `BinningRuleFct(GFACNUD_p, POGFACNUD, PLGFACNUD, PWGFACNUD, PLWGFACNUD)
    `BinningRuleFct(VSBNUD_p, POVSBNUD, PLVSBNUD, PWVSBNUD, PLWVSBNUD)
    `BinningRuleFct(DPHIB_p, PODPHIB, PLDPHIB, PWDPHIB, PLWDPHIB)
    `BinningRuleFct(NP_p, PONP, PLNP, PWNP, PLWNP)
    `BinningRuleFct(NOV_p, PONOV, PLNOV, PWNOV, PLWNOV)
    `BinningRuleFct(NOVD_p, PONOVD, PLNOVD, PWNOVD, PLWNOVD)

    //  Interface states parameters
    `BinningRuleFct(CT_p, POCT, PLCT, PWCT, PLWCT)
    `BinningRuleFct(CTG_p, POCTG, PLCTG, PWCTG, PLWCTG)
    `BinningRuleFct(CTB_p, POCTB, PLCTB, PWCTB, PLWCTB)
    `BinningRuleFct(STCT_p, POSTCT, PLSTCT, PWSTCT, PLWSTCT)

    //  DIBL parameters
    `BinningRuleScalFct(CF_p, iLE2, POCF, PLCF, PWCF, PLWCF)
    `BinningRuleFct(CFD_p, POCFD, PLCFD, PWCFD, PLWCFD)
    `BinningRuleFct(CFB_p, POCFB, PLCFB, PWCFB, PLWCFB)

    //  Subthreshold slope parameters of short channel transistor
    `BinningRuleScalFct(PSCE_p, iLE2, POPSCE, PLPSCE, PWPSCE, PLWPSCE)
    `BinningRuleFct(PSCED_p, POPSCED, PLPSCED, PWPSCED, PLWPSCED)
    `BinningRuleFct(PSCEB_p, POPSCEB, PLPSCEB, PWPSCEB, PLWPSCEB)

    //  Mobility parameters
    `BinningRuleScalFct(BETN_p, WE / LE, POBETN, PLBETN, PWBETN, PLWBETN)
    `BinningRuleFct(STBET_p, POSTBET, PLSTBET, PWSTBET, PLWSTBET)
    `BinningRuleFct(MUE_p, POMUE, PLMUE, PWMUE, PLWMUE)
    `BinningRuleFct(THEMU_p, POTHEMU, PLTHEMU, PWTHEMU, PLWTHEMU)
    `BinningRuleFct(CS_p, POCS, PLCS, PWCS, PLWCS)
    `BinningRuleFct(THECS_p, POTHECS, PLTHECS, PWTHECS, PLWTHECS)
    `BinningRuleFct(XCOR_p, POXCOR, PLXCOR, PWXCOR, PLWXCOR)

    //  Intrinsic series resistance parameters
    `BinningRuleScalFct(RS_p, iWE, PORS, PLRS, PWRS, PLWRS)
    `BinningRuleFct(STRS_p, POSTRS, PLSTRS, PWSTRS, PLWSTRS)
    `BinningRuleFct(RSB_p, PORSB, PLRSB, PWRSB, PLWRSB)
    `BinningRuleFct(RSG_p, PORSG, PLRSG, PWRSG, PLWRSG)

    //  Velocity saturation parameters
    `BinningRuleScalFct(THESAT_p, iLE, POTHESAT, PLTHESAT, PWTHESAT, PLWTHESAT)
    `BinningRuleFct(STTHESAT_p, POSTTHESAT, PLSTTHESAT, PWSTTHESAT, PLWSTTHESAT)
    `BinningRuleFct(THESATB_p, POTHESATB, PLTHESATB, PWTHESATB, PLWTHESATB)
    `BinningRuleFct(THESATG_p, POTHESATG, PLTHESATG, PWTHESATG, PLWTHESATG)

    //  Saturation voltage parameters
    `BinningRuleFct(AX_p, POAX, PLAX, PWAX, PLWAX)

    //  Channel length modulation parameters
    `BinningRuleScalFct(ALP_p, iLE, POALP, PLALP, PWALP, PLWALP)
    `BinningRuleFct(ALP1_p, POALP1, PLALP1, PWALP1, PLWALP1)
    `BinningRuleFct(ALP2_p, POALP2, PLALP2, PWALP2, PLWALP2)

    //  Impact ionization parameters
    `BinningRuleFct(A1_p, POA1, PLA1, PWA1, PLWA1)
    `BinningRuleFct(STA2_p, POSTA2, PLSTA2, PWSTA2, PLWSTA2)
    `BinningRuleFct(A3_p, POA3, PLA3, PWA3, PLWA3)
    `BinningRuleFct(A4_p, POA4, PLA4, PWA4, PLWA4)

    //  Gate current parameters
    `BinningRuleScalFct(IGINV_p, iiAE, POIGINV, PLIGINV, PWIGINV, PLWIGINV)
    `BinningRuleScalFct(IGOV_p, iiWE, POIGOV, PLIGOV, PWIGOV, PLWIGOV)
    `BinningRuleScalFct(IGOVD_p, iiWE, POIGOVD, PLIGOVD, PWIGOVD, PLWIGOVD)
    `BinningRuleFct(STIG_p, POSTIG, PLSTIG, PWSTIG, PLWSTIG)

    //  Gate-induced drain leakage parameters
    `BinningRuleScalFct(AGIDL_p, iiWE, POAGIDL, PLAGIDL, PWAGIDL, PLWAGIDL)
    `BinningRuleScalFct(AGIDLD_p, iiWE, POAGIDLD, PLAGIDLD, PWAGIDLD, PLWAGIDLD)
    `BinningRuleFct(STBGIDL_p, POSTBGIDL, PLSTBGIDL, PWSTBGIDL, PLWSTBGIDL)
    `BinningRuleFct(STBGIDLD_p, POSTBGIDLD, PLSTBGIDLD, PWSTBGIDLD, PLWSTBGIDLD)

    //  Charge model parameters
    `BinningRuleScalFct(COX_p, iiWEcv * LEcv / `LEN, POCOX, PLCOX, PWCOX, PLWCOX)
    `BinningRuleFct(DELVTAC_p, PODELVTAC, PLDELVTAC, PWDELVTAC, PLWDELVTAC)
    `BinningRuleFct(FACNEFFAC_p, POFACNEFFAC, PLFACNEFFAC, PWFACNEFFAC, PLWFACNEFFAC)
    `BinningRuleScalFctAC(THESATAC_p, iLE, POTHESATAC, PLTHESATAC, PWTHESATAC, PLWTHESATAC, POTHESAT, PLTHESAT, PWTHESAT, PLWTHESAT)
    `BinningRuleScalFctAC(AXAC_p, 1.0, POAXAC, PLAXAC, PWAXAC, PLWAXAC, POAX, PLAX, PWAX, PLWAX)
    `BinningRuleScalFct(ALPAC_p, iLE, POALPAC, PLALPAC, PWALPAC, PLWALPAC)
    `BinningRuleScalFct(ALP1AC_p, iLE, POALP1AC, PLALP1AC, PWALP1AC, PLWALP1AC)
    `BinningRuleScalFct(CGOV_p, iiWEcv, POCGOV, PLCGOV, PWCGOV, PLWCGOV)
    `BinningRuleScalFct(CGOVD_p, iiWEcv, POCGOVD, PLCGOVD, PWCGOVD, PLWCGOVD)
    `BinningRuleScalFct(CGBOV_p, iiLcv, POCGBOV, PLCGBOV, PWCGBOV, PLWCGBOV)
    `BinningRuleScalFct(CINR_p, iiWEcv, POCINR, PLCINR, PWCINR, PLWCINR)
    `BinningRuleScalFct(CINRD_p, iiWEcv, POCINRD, PLCINRD, PWCINRD, PLWCINRD)
    `BinningRuleScalFct(CFR_p, iiWcv, POCFR, PLCFR, PWCFR, PLWCFR)
    `BinningRuleScalFct(CFRD_p, iiWcv, POCFRD, PLCFRD, PWCFRD, PLWCFRD)

    // Noise model parameters
    `BinningRuleScalFct(FNTEXC_p, iLE2, POFNTEXC, PLFNTEXC, PWFNTEXC, PLWFNTEXC)
    `BinningRuleScalFct(NFA_p, iAE, PONFA, PLNFA, PWNFA, PLWNFA)
    `BinningRuleScalFct(NFB_p, iAE, PONFB, PLNFB, PWNFB, PLWNFB)
    `BinningRuleScalFct(NFC_p, iAE, PONFC, PLNFC, PWNFC, PLWNFC)

    //  Edge transistors parameters
    `BinningRuleFct(VFBEDGE_p, POVFBEDGE, PLVFBEDGE, PWVFBEDGE, PLWVFBEDGE)
    `BinningRuleFct(STVFBEDGE_p, POSTVFBEDGE, PLSTVFBEDGE, PWSTVFBEDGE, PLWSTVFBEDGE)
    `BinningRuleFct(DPHIBEDGE_p, PODPHIBEDGE, PLDPHIBEDGE, PWDPHIBEDGE, PLWDPHIBEDGE)
    `BinningRuleFct(NEFFEDGE_p, PONEFFEDGE, PLNEFFEDGE, PWNEFFEDGE, PLWNEFFEDGE)
    `BinningRuleFct(CTEDGE_p, POCTEDGE, PLCTEDGE, PWCTEDGE, PLWCTEDGE)
    `BinningRuleScalFct(BETNEDGE_p, WE_edge / LE, POBETNEDGE, PLBETNEDGE, PWBETNEDGE, PLWBETNEDGE)
    `BinningRuleFct(STBETEDGE_p, POSTBETEDGE, PLSTBETEDGE, PWSTBETEDGE, PLWSTBETEDGE)
    `BinningRuleScalFct(PSCEEDGE_p, iLE2, POPSCEEDGE, PLPSCEEDGE, PWPSCEEDGE, PLWPSCEEDGE)
    `BinningRuleFct(PSCEBEDGE_p, POPSCEBEDGE, PLPSCEBEDGE, PWPSCEBEDGE, PLWPSCEBEDGE)
    `BinningRuleFct(PSCEDEDGE_p, POPSCEDEDGE, PLPSCEDEDGE, PWPSCEDEDGE, PLWPSCEDEDGE)
    `BinningRuleScalFct(CFEDGE_p, iLE2, POCFEDGE, PLCFEDGE, PWCFEDGE, PLWCFEDGE)
    `BinningRuleFct(CFDEDGE_p, POCFDEDGE, PLCFDEDGE, PWCFDEDGE, PLWCFDEDGE)
    `BinningRuleFct(CFBEDGE_p, POCFBEDGE, PLCFBEDGE, PWCFBEDGE, PLWCFBEDGE)
    `BinningRuleScalFct(NFAEDGE_p, iAE_edge, PONFAEDGE, PLNFAEDGE, PWNFAEDGE, PLWNFAEDGE)
    `BinningRuleScalFct(NFBEDGE_p, iAE_edge, PONFBEDGE, PLNFBEDGE, PWNFBEDGE, PLWNFBEDGE)
    `BinningRuleScalFct(NFCEDGE_p, iAE_edge, PONFCEDGE, PLNFCEDGE, PWNFCEDGE, PLWNFCEDGE)

    //  Self heating effect parameters
    `ifdef SelfHeating
        `BinningRuleScalFct(RTH_p, iAE, PORTH, PLRTH, PWRTH, PLWRTH)
        `BinningRuleScalFct(CTH_p, iiAE, POCTH, PLCTH, PWCTH, PLWCTH)
        `BinningRuleFct(STRTH_p, POSTRTH, PLSTRTH, PWSTRTH, PLWSTRTH)
    `endif // SelfHeating

    //  NQS parameters
    `ifdef NQSmodel
        `BinningRuleFct(MUNQS_p, POMUNQS, PLMUNQS, PWMUNQS, PLWMUNQS)
    `endif // NQSmodel

    // ******************************* Mechanical stress model ******************************
    tmpa         =  0.0;
    tmpb         =  0.0;
    loop         =  0.0;
    `DefACparam(KVSATAC_i, KVSAT, KVSATAC)
    if ((SA_i > 0.0) && (SB_i > 0.0) && ((NF_i == 1.0) || ((NF_i > 1.0) && (SD_i > 0.0)))) begin
        while (loop < (NF_i - 0.5)) begin
            tmpa         =  tmpa + 1.0 / (SA_i + 0.5 * L_i + loop * (SD_i + L_i));
            tmpb         =  tmpb + 1.0 / (SB_i + 0.5 * L_i + loop * (SD_i + L_i));
            loop         =  loop + 1.0;
        end
        Invsa        =  tmpa * invNF;
        Invsb        =  tmpb * invNF;
        Invsaref     =  1.0 / (SAREF + 0.5 * L_i);
        Invsbref     =  1.0 / (SBREF + 0.5 * L_i);
        Lx           = `MAX(L_i + delLPS, 1.0e-09);
        Wx           = `MAX(W_i + delWOD + WLOD, 1.0e-09);
        templ        =  1.0 / pow(Lx, LLODKUO);
        tempw        =  1.0 / pow(Wx, WLODKUO);
        Kstressu0    =  (1.0 + LKUO * templ + WKUO * tempw + PKUO * templ * tempw) * (1.0 + TKUO * (rTa - 1.0));
        rhobeta      =  KUO * (Invsa + Invsb) / Kstressu0;
        rhobetaref   =  KUO * (Invsaref + Invsbref) / Kstressu0;
        templ        =  1.0 / pow(Lx, LLODVTH);
        tempw        =  1.0 / pow(Wx, WLODVTH);
        Kstressvth0  =  1.0 + LKVTHO * templ + WKVTHO * tempw + PKVTHO * templ * tempw;
        temp0        =  Invsa + Invsb - Invsaref - Invsbref;
        //  Parameter adaptations
        temp00       =  (1.0 + rhobeta) / (1.0 + rhobetaref);
        BETN_p       =  BETN_p * temp00;
        THESAT_p     =  THESAT_p * temp00 * (1.0 + KVSAT * rhobetaref) / (1.0 + KVSAT * rhobeta);
        THESATAC_p   =  THESATAC_p * temp00 * (1.0 + KVSATAC_i * rhobetaref) / (1.0 + KVSATAC_i * rhobeta);
        BETNEDGE_p   =  BETNEDGE_p * temp00;
        temp00       =  KVTHO * temp0 / Kstressvth0;
        VFB_p        =  VFB_p + temp00;
        VFBEDGE_p    =  VFBEDGE_p + temp00;
        temp00       =  STETAO * temp0 / pow(Kstressvth0, LODETAO);
        CF_p         =  CF_p + temp00;
        CFEDGE_p     =  CFEDGE_p + temp00;
    end

    // ******************************* Well proximity effect ******************************
    if ((SCA_i > 0.0) || (SCB_i > 0.0) || (SCC_i > 0.0) || (SC_i > 0.0)) begin
        if ((SCA_i == 0.0) && (SCB_i == 0.0) && (SCC_i == 0.0)) begin
            temp0        =  SC_i + W_i;
            temp00       =  1.0 / SCREF;
            SCA_i        =  SCREF * SCREF / (SC_i * temp0);
            SCB_i        =  ((0.1 * SC_i + 0.01 * SCREF) * exp(-10.0 * SC_i * temp00) - (0.1 * temp0 + 0.01 * SCREF) * exp(-10.0 * temp0 * temp00)) / W_i;
            SCC_i        =  ((0.05 * SC_i + 0.0025 * SCREF) * exp(-20.0 * SC_i * temp00) - (0.05 * temp0 + 0.0025 * SCREF) * exp(-20.0 * temp0 * temp00)) / W_i;
        end
        //  Parameter adaptations
        temp0        =  SCA_i + WEB * SCB_i + WEC * SCC_i;
        VFB_p        =  VFB_p + KVTHOWE * temp0;
        BETN_p       =  BETN_p * (1.0 + KUOWE * temp0);
        VFBEDGE_p    =  VFBEDGE_p + KVTHOWE * temp0;
        BETNEDGE_p   =  BETNEDGE_p * (1.0 + KUOWE * temp0);
    end
end

// ******************************* Internal parameters (including temperature scaling) *******************************
VFB_i        =  VFB_p;
STVFB_i      =  STVFB_p;
ST2VFB_i     =  ST2VFB_p;
TOX_i        =  TOX_p;
EPSROX_i     =  EPSROX_p;
NEFF_i       = `CLIP_BOTH(NEFF_p, 1.0e20, 1.0e26);
GFACNUD_i    = `CLIP_LOW(GFACNUD_p, 0.01);
VSBNUD_i     = `CLIP_LOW(VSBNUD_p, 0.0);
DVSBNUD_i    =  DVSBNUD_p;
DPHIB_i      =  DPHIB_p;
NP_i         = `CLIP_LOW(NP_p, 0.0);
TOXOV_i      =  TOXOV_p;
TOXOVD_i     =  TOXOVD_p;
NOV_i        = `CLIP_BOTH(NOV_p, 1.0e23, 1.0e27);
NOVD_i       = `CLIP_BOTH(NOVD_p, 1.0e23, 1.0e27);
CT_i         = `CLIP_LOW(CT_p, 0.0);
CTB_i        = `CLIP_BOTH(CTB_p, 0.0, 0.5);
CTG_i        = `CLIP_BOTH(CTG_p, 0.0, 1.0);
STCT_i       =  STCT_p;
CF_i         = `CLIP_LOW(CF_p, 0.0);
CFB_i        = `CLIP_BOTH(CFB_p, 0.0, 1.0);
CFD_i        = `CLIP_LOW(CFD_p, 0.0);
PSCE_i       = `CLIP_LOW(PSCE_p, 0.0);
PSCEB_i      = `CLIP_BOTH(PSCEB_p, 0.0, 1.0);
PSCED_i      = `CLIP_LOW(PSCED_p, 0.0);
BETN_i       = `CLIP_LOW(BETN_p, 0.0);
STBET_i      =  STBET_p;
MUE_i        = `CLIP_LOW(MUE_p, 0.0);
STMUE_i      =  STMUE_p;
THEMU_i      = `CLIP_LOW(THEMU_p, 0.0);
STTHEMU_i    =  STTHEMU_p;
CS_i         = `CLIP_LOW(CS_p,  0.0);
STCS_i       =  STCS_p;
THECS_i      = `CLIP_LOW(THECS_p, 0.0);
STTHECS_i    =  STTHECS_p;
XCOR_i       = `CLIP_LOW(XCOR_p, 0.0);
STXCOR_i     =  STXCOR_p;
FETA_i       =  FETA_p;
RS_i         = `CLIP_LOW(RS_p, 0.0);
STRS_i       =  STRS_p;
RSB_i        = `CLIP_BOTH(RSB_p, -0.5, 1.0);
RSG_i        = `CLIP_LOW(RSG_p, -0.5);
THESAT_i     = `CLIP_LOW(THESAT_p, 0.0);
STTHESAT_i   =  STTHESAT_p;
THESATB_i    = `CLIP_BOTH(THESATB_p, -0.5, 1.0);
THESATG_i    = `CLIP_LOW(THESATG_p, -0.5);
THESATT_i    = `CLIP_LOW(THESATT_p, 0.01);
AX_i         = `CLIP_LOW(AX_p, 2.0);
ALP_i        = `CLIP_LOW(ALP_p, 0.0);
ALP1_i       = `CLIP_LOW(ALP1_p, 0.0);
ALP2_i       = `CLIP_LOW(ALP2_p, 0.0);
VP_i         =  VP_p;
A1_i         = `CLIP_LOW(A1_p, 0.0);
A2_i         =  A2_p;
STA2_i       =  STA2_p;
A3_i         = `CLIP_LOW(A3_p, 0.0);
A4_i         = `CLIP_LOW(A4_p, 0.0);
IMAXII_i     = `CLIP_LOW(IMAXII_p, 1e-12);
GCO_i        =  GCO_p;
IGINV_i      = `CLIP_LOW(IGINV_p, 0.0);
IGOV_i       = `CLIP_LOW(IGOV_p, 0.0);
IGOVD_i      = `CLIP_LOW(IGOVD_p, 0.0);
STIG_i       =  STIG_p;
GC2_i        =  GC2_p;
GC3_i        =  GC3_p;
GC2OV_i      =  GC2OV_p;
GC3OV_i      =  GC3OV_p;
GC2OVD_i     =  GC2OVD_p;
GC3OVD_i     =  GC3OVD_p;
CHIB_i       =  CHIB_p;
AGIDL_i      = `CLIP_LOW(AGIDL_p, 0.0);
AGIDLD_i     = `CLIP_LOW(AGIDLD_p, 0.0);
BGIDL_i      =  BGIDL_p;
BGIDLD_i     =  BGIDLD_p;
STBGIDL_i    =  STBGIDL_p;
STBGIDLD_i   =  STBGIDLD_p;
CGIDL_i      =  CGIDL_p;
CGIDLD_i     =  CGIDLD_p;
COX_i        = `CLIP_LOW(COX_p, 0.0);
DELVTAC_i    =  DELVTAC_p;
FACNEFFAC_i  = `CLIP_LOW(FACNEFFAC_p, 0.0);
THESATAC_i   = `CLIP_LOW(THESATAC_p, 0.0);
AXAC_i       = `CLIP_LOW(AXAC_p, 2.0);
ALPAC_i      =  ALPAC_p;
ALP1AC_i     = `CLIP_LOW(ALP1AC_p, 0.0);
CGOV_i       = `CLIP_LOW(CGOV_p, 0.0);
CGOVD_i      = `CLIP_LOW(CGOVD_p, 0.0);
FCGOVACC_i   =  FCGOVACC_p;
FCGOVACCD_i  =  FCGOVACCD_p;
CGOVACCG_i   =  CGOVACCG_p;
CGBOV_i      = `CLIP_LOW(CGBOV_p, 0.0);
CINR_i       = `CLIP_LOW(CINR_p, 0.0);
CINRD_i      = `CLIP_LOW(CINRD_p, 0.0);
DVFBINR_i    =  DVFBINR_p;
FCINRDEP_i   =  FCINRDEP_p;
FCINRACC_i   =  FCINRACC_p;
AXINR_i      =  AXINR_p;
CFR_i        = `CLIP_LOW(CFR_p, 0.0);
CFRD_i       = `CLIP_LOW(CFRD_p, 0.0);
FNT_i        =  FNT_p;
FNTEXC_i     = `CLIP_LOW(FNTEXC_p, 0.0);
NFA_i        = `CLIP_LOW(NFA_p, 0.0);
NFB_i        = `CLIP_LOW(NFB_p, 0.0);
NFC_i        = `CLIP_LOW(NFC_p, 0.0);
EF_i         =  EF_p;
VFBEDGE_i    =  VFBEDGE_p;
STVFBEDGE_i  =  STVFBEDGE_p;
DPHIBEDGE_i  =  DPHIBEDGE_p;
NEFFEDGE_i   = `CLIP_BOTH(NEFFEDGE_p, 1.0e20, 1.0e26);
CTEDGE_i     = `CLIP_LOW(CTEDGE_p, 0.0);
BETNEDGE_i   = `CLIP_LOW(BETNEDGE_p, 0.0);
STBETEDGE_i  =  STBETEDGE_p;
PSCEEDGE_i   = `CLIP_LOW(PSCEEDGE_p, 0.0);
PSCEBEDGE_i  = `CLIP_BOTH(PSCEBEDGE_p, 0.0, 1.0);
PSCEDEDGE_i  = `CLIP_LOW(PSCEDEDGE_p, 0.0);
CFEDGE_i     = `CLIP_LOW(CFEDGE_p, 0.0);
CFBEDGE_i    = `CLIP_BOTH(CFBEDGE_p, 0.0, 1.0);
CFDEDGE_i    = `CLIP_LOW(CFDEDGE_p, 0.0);
FNTEDGE_i    =  FNTEDGE_p;
NFAEDGE_i    = `CLIP_LOW(NFAEDGE_p, 0.0);
NFBEDGE_i    = `CLIP_LOW(NFBEDGE_p, 0.0);
NFCEDGE_i    = `CLIP_LOW(NFCEDGE_p, 0.0);
EFEDGE_i     =  EFEDGE_p;
RG_i         = `CLIP_LOW(RG_p, 0.0);
RSE_i        =  RSE_p;
RDE_i        =  RDE_p;
RBULK_i      =  RBULK_p;
RJUNS_i      =  RJUNS_p;
RJUND_i      =  RJUND_p;
RWELL_i      =  RWELL_p;
`ifdef SelfHeating
    RTH_i        = `CLIP_LOW(RTH_p, 1.0e-04);
    CTH_i        = `CLIP_LOW(CTH_p, 0.0);
    STRTH_i      =  STRTH_p;
`endif // SelfHeating
MULT_inst    = `CLIP_LOW(MULT * NF_i, 0.0); // Note: NF_i is set to 1 for local model
FACTUO_i     =  FACTUO;
DELVTO_i     =  DELVTO;
FACTUOEDGE_i =  FACTUOEDGE;
DELVTOEDGE_i =  DELVTOEDGE;
`ifdef NQSmodel
    MUNQS_i      = `CLIP_LOW(MUNQS_p, 0.0);
`endif // NQSmodel

// Ignore drain-side values in case of symmetric junctions
if (SWJUNASYM == 0) begin
    TOXOVD_i      =  TOXOV_i;
    NOVD_i        =  NOV_i;
    AGIDLD_i      =  AGIDL_i;
    BGIDLD_i      =  BGIDL_i;
    STBGIDLD_i    =  STBGIDL_i;
    CGIDLD_i      =  CGIDL_i;
    IGOVD_i       =  IGOV_i;
    GC2OVD_i      =  GC2OV_i;
    GC3OVD_i      =  GC3OV_i;
    CGOVD_i       =  CGOV_i;
    FCGOVACCD_i   =  FCGOVACC_i;
    CINRD_i       =  CINR_i;
    CFRD_i        =  CFR_i;
end
// ---- end `include "PSP104_scaling.include" ----

        //  Local process variables
        EPSOX        = `EPSO * EPSROX_i;
        CoxPrime     =  EPSOX / TOX_i;
        tox_sq       =  TOX_i * TOX_i;
        Cox_over_q   =  CoxPrime / `QELE;
        NEFFAC_i     =  FACNEFFAC_i * NEFF_i;
        NEFFAC_i     = `CLIP_BOTH(NEFFAC_i, 1.0e20, 1.0e26);

        //  QM corrections
        qq           =  0.0;
        if (QMC > 0.0) begin
            qq           =  0.4 * `QMN * QMC * pow(CoxPrime, `twoThirds);
            if (CHNL_TYPE==`PMOS) begin
                qq           = `QMP / `QMN * qq;
            end
        end

        //  Electrical field variables
        E_eff0       =  1.0e-08 * CoxPrime / EPSSI;
        eta_mu       =  0.5 * FETA_i;
        eta_mu1      =  0.5;
        if (CHNL_TYPE == `PMOS) begin
            eta_mu       = `oneThird * FETA_i;
            eta_mu1      = `oneThird;
        end

        //  Linear-saturation transition variable
        temp         =  pow(2.0, (-2.0 / AX_i + 1.0)) - 1.0;
        ar           =  (temp - 1.0) * (temp - 1.0) / `MAX(4.0 * temp, 1.0e-04);
        temp         =  pow(2.0, (-2.0 / AXAC_i + 1.0)) - 1.0;
        arac         =  (temp - 1.0) * (temp - 1.0) / `MAX(4.0 * temp, 1.0e-04);

        //  CLM variable
        inv_VP       =  1.0 / VP_i;

        //  Gate overlap variables
        CoxovPrime   =  EPSOX / TOXOV_i;
        CoxovPrime_d =  EPSOX / TOXOVD_i;
        GOV_s        =  sqrt(2.0 * `QELE * NOV_i * EPSSI * inv_phita) / CoxovPrime;
        GOV_d        =  sqrt(2.0 * `QELE * NOVD_i * EPSSI * inv_phita) / CoxovPrime_d;
        GOV2_s       =  GOV_s * GOV_s;
        GOV2_d       =  GOV_d * GOV_d;
        dxgb_ov_th   =  ln(exp(CGOVACCG_i * 0.005 * inv_phita) - 1.0) / CGOVACCG_i - ln(exp(0.005 * inv_phita) - 1.0);
        dxgb_ov_s    =  ln(0.5 * GOV_s) + dxgb_ov_th;
        dxgb_ov_d    =  ln(0.5 * GOV_d) + dxgb_ov_th;
        `sp_ovInit(GOV_s, GOV2_s, SP_OV_eps2_s, SP_OV_a_s, SP_OV_delta1_s)
        `sp_ovInit(GOV_d, GOV2_d, SP_OV_eps2_d, SP_OV_a_d, SP_OV_delta1_d)

        //  Temperature scaling variables
        `ifdef SelfHeating
            // do nothing
        `else // SelfHeating
            `TempScaling
        `endif // SelfHeating

        //  Gate to channel leakage variables
        inv_CHIB     =  1.0 / CHIB_i;
        B_fact       =  4.0 * `oneThird * sqrt(2.0 * `QELE * `MELE * CHIB_i) / `HBAR;
        BCH          =  B_fact * TOX_i;
        BOV          =  B_fact * TOXOV_i;
        BOV_d        =  B_fact * TOXOVD_i;
        GCQ          =  0.0;
        if (GC3_i < 0.0) begin
            GCQ          = -0.495 * GC2_i / GC3_i;
        end
        GCQOV        =  0.0;
        if (GC3OV_i < 0.0) begin
            GCQOV          = -0.495 * GC2OV_i / GC3OV_i;
        end
        if (GC3OVD_i < 0.0) begin
            GCQOVD          = -0.495 * GC2OVD_i / GC3OVD_i;
        end
        tf_ig        =  pow(rTa, STIG_i);
        IGINV_i      =  IGINV_i * tf_ig;
        IGOV_i       =  IGOV_i * tf_ig;
        IGOVD_i      =  IGOVD_i * tf_ig;

        //  GIDL variables
        AGIDLs       =  AGIDL_i * 4.0e-18 / (TOXOV_i * TOXOV_i);
        AGIDLDs      =  AGIDLD_i * 4.0e-18 / (TOXOVD_i * TOXOVD_i);
        B_fact       = `MAX(1.0 + STBGIDL_i * delTa, 0.0);
        BGIDL_T      =  BGIDL_i * B_fact;
        BGIDLs       =  BGIDL_T * TOXOV_i * 5.0e08;
        B_fact       = `MAX(1.0 + STBGIDLD_i * delTa, 0.0);
        BGIDLD_T     =  BGIDLD_i * B_fact;
        BGIDLDs      =  BGIDLD_T * TOXOVD_i * 5.0e8;

        //  Inner fringe charge variables
        Vinr_max     =  0.0;
        if (FCINRACC_i > 1.0e-10) begin
            Vinr_max     =  0.75 / FCINRACC_i;
        end
        ainr         =  AXINR_i * AXINR_i;

        //  Self Heating variables
        `ifdef SelfHeating
            RTH_T        =  RTH_i * pow(rTa, STRTH_i);
        `endif // SelfHeating

        //  Noise model variables
        fac_exc      = `MELE * 1.0e09 * FNTEXC_i;

        //  Conductance of parasitic resistances
        if (RG_i > 0.0) begin
            ggate        =  1.0 / RG_i;
        end else begin
            ggate        =  0.0;
        end
        if (RSE_i > 0.0) begin
            gsource      =  1.0 / RSE_i;
        end else begin
            gsource      =  0.0;
        end
        if (RDE_i > 0.0) begin
            gdrain       =  1.0 / RDE_i;
        end else begin
            gdrain       =  0.0;
        end
        if (RBULK_i > 0.0) begin
            gbulk        =  1.0 / RBULK_i;
        end else begin
            gbulk        =  0.0;
        end
        if (RJUNS_i > 0.0) begin
            gjuns        =  1.0 / RJUNS_i;
        end else begin
            gjuns        =  0.0;
        end
        if (RJUND_i > 0.0) begin
            gjund        =  1.0 / RJUND_i;
        end else begin
            gjund        =  0.0;
        end
        if (RWELL_i > 0.0) begin
            gwell        =  1.0 / RWELL_i;
        end else begin
            gwell        =  0.0;
        end

        //  JUNCAP instance variables
        ABS_i        =  ABSOURCE_i * invNF;
        LSS_i        =  LSSOURCE_i * invNF;
        LGS_i        =  LGSOURCE_i * invNF;
        ABD_i        =  ABDRAIN_i * invNF;
        LSD_i        =  LSDRAIN_i * invNF;
        LGD_i        =  LGDRAIN_i * invNF;
        jwcorr       =  0.0;
        if (SWJUNCAP == 3) begin
            jwcorr       =  1.0;
        end
        jww          =  WE;
        if (SWGEO == 0) begin
            jww          = `CLIP_LOW(JW_i, `LG_cliplow);
        end
        if ((SWJUNCAP == 2) || (SWJUNCAP == 3)) begin
            ABS_i        =  AS_i * invNF;
            LSS_i        =  PS_i * invNF - jwcorr * jww;
            LGS_i        =  jww;
            ABD_i        =  AD_i * invNF;
            LSD_i        =  PD_i * invNF - jwcorr * jww;
            LGD_i        =  jww;
        end
        if ((SWJUNCAP == 1) || (SWJUNCAP == 2) || (SWJUNCAP == 3)) begin
            ABSOURCE_i   = `CLIP_LOW(ABS_i, `AB_cliplow);
            LSSOURCE_i   = `CLIP_LOW(LSS_i, `LS_cliplow);
            LGSOURCE_i   = `CLIP_LOW(LGS_i, `LG_cliplow);
            ABDRAIN_i    = `CLIP_LOW(ABD_i, `AB_cliplow);
            LSDRAIN_i    = `CLIP_LOW(LSD_i, `LS_cliplow);
            LGDRAIN_i    = `CLIP_LOW(LGD_i, `LG_cliplow);
        end else begin
            ABSOURCE_i   =  0.0;
            LSSOURCE_i   =  0.0;
            LGSOURCE_i   =  0.0;
            ABDRAIN_i    =  0.0;
            LSDRAIN_i    =  0.0;
            LGDRAIN_i    =  0.0;
        end

        //  Initialization of JUNCAP (global) variables; required for some verilog-A compilers
        vbimin_s     =  0.0;
        vbimin_d     =  0.0;
        vfmin_s      =  0.0;
        vfmin_d      =  0.0;
        vch_s        =  0.0;
        vch_d        =  0.0;
        vbbtlim_s    =  0.0;
        vbbtlim_d    =  0.0;
        VMAX_s       =  0.0;
        VMAX_d       =  0.0;
        exp_VMAX_over_phitd_s =  0.0;
        exp_VMAX_over_phitd_d =  0.0;
        ISATFOR1_s   =  0.0;
        ISATFOR1_d   =  0.0;
        MFOR1_s      =  1.0;
        MFOR1_d      =  1.0;
        ISATFOR2_s   =  0.0;
        ISATFOR2_d   =  0.0;
        MFOR2_s      =  1.0;
        MFOR2_d      =  1.0;
        ISATREV_s    =  0.0;
        ISATREV_d    =  0.0;
        MREV_s       =  1.0;
        MREV_d       =  1.0;
        m0flag_s     =  0.0;
        m0flag_d     =  0.0;
        xhighf1_s    =  0.0;
        xhighf1_d    =  0.0;
        expxhf1_s    =  0.0;
        expxhf1_d    =  0.0;
        xhighf2_s    =  0.0;
        xhighf2_d    =  0.0;
        expxhf2_s    =  0.0;
        expxhf2_d    =  0.0;
        xhighr_s     =  0.0;
        xhighr_d     =  0.0;
        expxhr_s     =  0.0;
        expxhr_d     =  0.0;
        zflagbot_s   =  1.0;
        zflagbot_d   =  1.0;
        zflagsti_s   =  1.0;
        zflagsti_d   =  1.0;
        zflaggat_s   =  1.0;
        zflaggat_d   =  1.0;
        m0_rev       =  0.0;
        mcor_rev     =  0.0;
        I1_cor       =  0.0;
        I2_cor       =  0.0;
        I3_cor       =  0.0;
        I4_cor       =  0.0;
        I5_cor       =  0.0;
        tt0          =  0.0;
        tt1          =  0.0;
        tt2          =  0.0;
        zfrac        =  0.0;
        alphaje      =  0.0;

        if (SWJUNCAP > 0) begin
            `JuncapInitInstance(ABSOURCE_i, LSSOURCE_i, LGSOURCE_i, idsatbot,   idsatsti,   idsatgat,   vbibot,   vbisti,   vbigat,   PBOT,  PSTI,  PGAT,  VBIRBOT,  VBIRSTI, VBIRGAT,  VMAX_s, exp_VMAX_over_phitd_s, vbimin_s, vch_s, vfmin_s, vbbtlim_s)
            `JuncapInitInstance(ABDRAIN_i,  LSDRAIN_i,  LGDRAIN_i,  idsatbot_d, idsatsti_d, idsatgat_d, vbibot_d, vbisti_d, vbigat_d, PBOTD_i, PSTID_i, PGATD_i, VBIRBOTD_i, VBIRSTID_i, VBIRGATD_i, VMAX_d, exp_VMAX_over_phitd_d, vbimin_d, vch_d, vfmin_d, vbbtlim_d)

            if (SWJUNEXP_i == 1) begin : JUNCAPexpressInit
                // Local variable declaration
                `LocalGlobalVars

                real ijunbot, ijunsti, ijungat;

                //  Initialization of (local) variables; required for some verilog-A compilers
                `JuncapLocalVarInit

                //  Computation of JUNCAP-express internal variables for source side
                `JuncapExpressInit1(ABSOURCE_i, LSSOURCE_i, LGSOURCE_i, VJUNREF, one_minus_PBOT, idsatbot, CSRHBOT, CTATBOT, vbibot, wdepnulrbot, VBIRBOTinv, PBOT, ftdbot, btatpartbot, atatbot, one_over_one_minus_PBOT, CBBTBOT, VBIRBOT, wdepnulrinvbot, fbbtbot, VBRBOT, VBRinvbot, PBRBOT, fstopbot, slopebot, one_minus_PSTI, idsatsti, CSRHSTI, CTATSTI, vbisti, wdepnulrsti, VBIRSTIinv, PSTI, ftdsti, btatpartsti, atatsti, one_over_one_minus_PSTI, CBBTSTI, VBIRSTI, wdepnulrinvsti, fbbtsti, VBRSTI, VBRinvsti, PBRSTI, fstopsti, slopesti, one_minus_PGAT, idsatgat, CSRHGAT, CTATGAT, vbigat, wdepnulrgat, VBIRGATinv, PGAT, ftdgat, btatpartgat, atatgat, one_over_one_minus_PGAT, CBBTGAT, VBIRGAT, wdepnulrinvgat, fbbtgat, VBRGAT, VBRinvgat, PBRGAT, fstopgat, slopegat, VMAX_s, exp_VMAX_over_phitd_s, vbimin_s, vch_s, vfmin_s, vbbtlim_s)
                `JuncapExpressInit2(ABSOURCE_i, LSSOURCE_i, LGSOURCE_i, one_minus_PBOT, idsatbot, CSRHBOT, CTATBOT, vbibot, wdepnulrbot, VBIRBOTinv, PBOT, ftdbot, btatpartbot, atatbot, one_over_one_minus_PBOT, CBBTBOT, VBIRBOT, wdepnulrinvbot, fbbtbot, VBRBOT, VBRinvbot, PBRBOT, fstopbot, slopebot, one_minus_PSTI, idsatsti, CSRHSTI, CTATSTI, vbisti, wdepnulrsti, VBIRSTIinv, PSTI, ftdsti, btatpartsti, atatsti, one_over_one_minus_PSTI, CBBTSTI, VBIRSTI, wdepnulrinvsti, fbbtsti, VBRSTI, VBRinvsti, PBRSTI, fstopsti, slopesti, one_minus_PGAT, idsatgat, CSRHGAT, CTATGAT, vbigat, wdepnulrgat, VBIRGATinv, PGAT, ftdgat, btatpartgat, atatgat, one_over_one_minus_PGAT, CBBTGAT, VBIRGAT, wdepnulrinvgat, fbbtgat, VBRGAT, VBRinvgat, PBRGAT, fstopgat, slopegat, VMAX_s, exp_VMAX_over_phitd_s, vbimin_s, vch_s, vfmin_s, vbbtlim_s)
                `JuncapExpressInit3(ABSOURCE_i, LSSOURCE_i, LGSOURCE_i, idsatbot, idsatsti, idsatgat, ISATFOR1_s, MFOR1_s, ISATFOR2_s, MFOR2_s, ISATREV_s, MREV_s, m0flag_s)
                `JuncapExpressInit4(ABSOURCE_i, LSSOURCE_i, LGSOURCE_i, FJUNQ, cjobot, cjosti, cjogat, zflagbot_s, zflagsti_s, zflaggat_s)
                `JuncapExpressInit5(ABSOURCE_i, LSSOURCE_i, LGSOURCE_i, ISATFOR1_s, ISATFOR2_s, ISATREV_s, xhighf1_s, expxhf1_s, xhighf2_s, expxhf2_s, xhighr_s, expxhr_s)

                //  Computation of JUNCAP-express internal variables for drain side
                `JuncapExpressInit1(ABDRAIN_i, LSDRAIN_i, LGDRAIN_i, VJUNREFD_i, one_minus_PBOT_d, idsatbot_d, CSRHBOTD_i, CTATBOTD_i, vbibot_d, wdepnulrbot_d, VBIRBOTinv_d, PBOTD_i, ftdbot_d, btatpartbot_d, atatbot_d, one_over_one_minus_PBOT_d, CBBTBOTD_i, VBIRBOTD_i, wdepnulrinvbot_d, fbbtbot_d, VBRBOTD_i, VBRinvbot_d, PBRBOTD_i, fstopbot_d, slopebot_d, one_minus_PSTI_d, idsatsti_d, CSRHSTID_i, CTATSTID_i, vbisti_d, wdepnulrsti_d, VBIRSTIinv_d, PSTID_i, ftdsti_d, btatpartsti_d, atatsti_d, one_over_one_minus_PSTI_d, CBBTSTID_i, VBIRSTID_i, wdepnulrinvsti_d, fbbtsti_d, VBRSTID_i, VBRinvsti_d, PBRSTID_i, fstopsti_d, slopesti_d, one_minus_PGAT_d, idsatgat_d, CSRHGATD_i, CTATGATD_i, vbigat_d, wdepnulrgat_d, VBIRGATinv_d, PGATD_i, ftdgat_d, btatpartgat_d, atatgat_d, one_over_one_minus_PGAT_d, CBBTGATD_i, VBIRGATD_i, wdepnulrinvgat_d, fbbtgat_d, VBRGATD_i, VBRinvgat_d, PBRGATD_i, fstopgat_d, slopegat_d, VMAX_d, exp_VMAX_over_phitd_d, vbimin_d, vch_d, vfmin_d, vbbtlim_d)
                `JuncapExpressInit2(ABDRAIN_i, LSDRAIN_i, LGDRAIN_i, one_minus_PBOT_d, idsatbot_d, CSRHBOTD_i, CTATBOTD_i, vbibot_d, wdepnulrbot_d, VBIRBOTinv_d, PBOTD_i, ftdbot_d, btatpartbot_d, atatbot_d, one_over_one_minus_PBOT_d, CBBTBOTD_i, VBIRBOTD_i, wdepnulrinvbot_d, fbbtbot_d, VBRBOTD_i, VBRinvbot_d, PBRBOTD_i, fstopbot_d, slopebot_d, one_minus_PSTI_d, idsatsti_d, CSRHSTID_i, CTATSTID_i, vbisti_d, wdepnulrsti_d, VBIRSTIinv_d, PSTID_i, ftdsti_d, btatpartsti_d, atatsti_d, one_over_one_minus_PSTI_d, CBBTSTID_i, VBIRSTID_i, wdepnulrinvsti_d, fbbtsti_d, VBRSTID_i, VBRinvsti_d, PBRSTID_i, fstopsti_d, slopesti_d, one_minus_PGAT_d, idsatgat_d, CSRHGATD_i, CTATGATD_i, vbigat_d, wdepnulrgat_d, VBIRGATinv_d, PGATD_i, ftdgat_d, btatpartgat_d, atatgat_d, one_over_one_minus_PGAT_d, CBBTGATD_i, VBIRGATD_i, wdepnulrinvgat_d, fbbtgat_d, VBRGATD_i, VBRinvgat_d, PBRGATD_i, fstopgat_d, slopegat_d, VMAX_d, exp_VMAX_over_phitd_d, vbimin_d, vch_d, vfmin_d, vbbtlim_d)
                `JuncapExpressInit3(ABDRAIN_i, LSDRAIN_i, LGDRAIN_i, idsatbot_d, idsatsti_d, idsatgat_d, ISATFOR1_d, MFOR1_d, ISATFOR2_d, MFOR2_d, ISATREV_d, MREV_d, m0flag_d)
                `JuncapExpressInit4(ABDRAIN_i, LSDRAIN_i, LGDRAIN_i, FJUNQD_i, cjobot_d, cjosti_d, cjogat_d, zflagbot_d, zflagsti_d, zflaggat_d)
                `JuncapExpressInit5(ABDRAIN_i, LSDRAIN_i, LGDRAIN_i, ISATFOR1_d, ISATFOR2_d, ISATREV_d, xhighf1_d, expxhf1_d, xhighf2_d, expxhf2_d, xhighr_d, expxhr_d)
            end // JUNCAPexpressInit

        end

    end // initial_instance

    begin : evaluateblock

        // Declaration of variables
        real xgs_ov, xgd_ov, xgb_ov, V_xb_dc_tmp, Vsbstar_dc_tmp, Vgb1_dc, Vsbx_dc, phit1_dc, inv_phit1_dc, Gf_dc, Gf2_dc, inv_Gf2_dc;
        real xg_dc, xno_s_dc, xn_s_dc, xi_dc, margin_dc, inv_xi_dc, SP_S_x1_dc, delta_ns_dc, x_s_dc, xi1s_dc;
        real xi2s_dc, delta_1s_dc, Es_dc, Ps_dc, Ds_dc, sqs_dc, alphas_dc, Rxcor_dc, xgs_dc, qis_dc, qbs_dc, rhob_dc, rhog_dc;
        real Gmobs_dc, xitsb_dc, factheta_dc, Vdsat_lim_dc, Vdsat_dc, Vdse_dc, Udse_dc, x_ds_dc, dps_dc, qbd_dc, x_m_dc, eta_p_dc;
        real alpha_dc, qim_dc, qim1_dc, qbm_dc, qeff1_dc, Gmob_dc, thesateff_dc, s1_dc, Voxm_dc, GdL_dc, Gmob_dL_dc, thesat1_dc, Gvsatinv_dc, H_dc;
        real Vovs, Vovd, xgedge, qdseffedge, qmeffedge, dsqredge;
        real alphabmedge, mavl, Vsbstar_ac, Vgb1_ac, phit1_ac, Gf_ac, xg_ac, xno_s_ac, qbs_ac, dps_ac, qbd_ac, eta_p_ac, alpha_ac, qim_ac, qim1_ac, qeff1_ac;
        real Gmob_ac, s1_ac, thesateff_ac, Voxm_ac, COX_qm, GdL_ac, Gmob_dL_ac, thesat1_ac, Gvsat_ac, H_ac, Qgs_ov, Qgd_ov;
        real ijunbot_s, ijunsti_s, ijungat_s, ijunbot_d, ijunsti_d, ijungat_d, qjunbot_s, qjunsti_s, qjungat_s, qjunbot_d;
        real qjunsti_d, qjungat_d, shot_igcsx, shot_igcdx, shot_igsov, shot_igdov, shot_iavl, jnoisex_s, jnoisex_d;
        `ifdef NQSmodel
            real xgm_dc, inv_phit1_ac, margin_ac, x_m_ac, xgm_ac, ym, pd, Gp, Gp2, a_factrp, marginp;
            real Qp1_0, Qp2_0, Qp3_0, Qp4_0, Qp5_0, Qp6_0, Qp7_0, Qp8_0, Qp9_0, fk1, fk2, fk3, fk4, fk5, fk6, fk7, fk8, fk9;
            real phi_p1, phi_p2, phi_p3, phi_p4, phi_p5, phi_p6, phi_p7, phi_p8, phi_p9, Qp1, Qp2, Qp3, Qp4, Qp5, Qp6, Qp7;
            real Qp8, Qp9, Qp0, QpN, QG_NQS, QS_NQS, QD_NQS, x_sp, x_dp, zsat_nqs, dfQi, fQi, dQis, dQis_1, d2Qis, dQbs, dQy;
            real d2Qy, dpsy2, Tnorm, Qb_tmp, QbSIGN, NQS_xg1, NQS_yg, NQS_z, NQS_eta, NQS_a, NQS_c, NQS_tau, NQS_D0, NQS_xi;
            real NQS_p, NQS_q, NQS_temp, NQS_A_fac, NQS_xbar, NQS_w, NQS_x0, NQS_u, NQS_y0, xphi, fk0, thesat2, Fvsat, temp3;
            real temp4, temp5, temp6, temp7, temp8, temp9;
        `endif // NQSmodel
        `ifdef SelfHeating
            real Pdiss, phit, BET_i, BETEDGE_i, nt0, nt, THESAT_T, THESATAC_T, Sfl_prefac, phit0edge, Gfedge2, lnGfedge2;
            real Sfl_prefac_edge, ntedge;
        `endif // SelfHeating
        real temp, temp1, temp2;

        //  --------------------------------------------------------------------------------------------------------------
        //  DC bias dependent quantities (calculations for current contribs)
        //  --------------------------------------------------------------------------------------------------------------
        begin : evaluateStatic

            //  Declaration of local variables
            real Vsbstar_dc, dVbstar_dc, Vmb, us, usnew, Vmbnew, dL, s2, zsat, Gvsat, alpha1, SP_OV_xg, xs_ov, xd_ov, zg, TP;
            real Fs1, Fs2, Fs3, Fs, Vm, Dch, arg2mina, psi_t, arg1, Dsi, Dgate, Igc0, u0, x, u0_div_H, Bg, Ag, xsq, igc, igcd_h;
            real inv_x, ex, inv_ex, Sg, Igc, Vtovd, Vtovs, Vsbstaredge, Vsbxedge, dphit1edge, phit1edge, inv_phit1edge, Vdspedge;
            real delVgedge, xbedge, dxthedge, xnedge_s, qseffedge, xnedge_d, qdeffedge, delVsat;
            real Q_EDGE_xsth, Q_EDGE_xth0, Q_EDGE_xth, Q_EDGE_n, Q_EDGE_n_inv, Q_EDGE_xgt, Q_EDGE_xgt0, Q_EDGE_xgt0e;
            real Q_EDGE_qi0si, Q_EDGE_qi0, Q_EDGE_exp_x, Q_EDGE_d0, Q_EDGE_d0p, Q_EDGE_sqerr, Q_EDGE_errq;

            //  Initialize temporary variables
            temp         =  0.0;
            temp1        =  0.0;
            temp2        =  0.0;

            //  Initialization of variables for SHE effect
            `ifdef SelfHeating
                TKD          =  TKA + Temp(br_rth);
                `TempInitialize
                `TempScaling
            `endif // SelfHeating

            //  Initialization of variables for NQS model
            `ifdef NQSmodel
                pd           =  1.0;
                ym           =  0.0;
            `endif // NQSmodel

            //  Voltage affectations
            if (CHNL_TYPE == `NMOS) begin
                V_gs         =  V(gp, si);
                V_ds         =  V(di, si);
                V_sb         =  V(si, bp);
                Vjun_s       = -V(si, bs);
                Vjun_d       = -V(di, bd);
            end else begin
                V_gs         = -V(gp, si);
                V_ds         = -V(di, si);
                V_sb         = -V(si, bp);
                Vjun_s       =  V(si, bs);
                Vjun_d       =  V(di, bd);
            end
            Vgb          =  V_gs + V_sb;

            //  Voltages NOT subject to S/D-interchange
            VgsPrime     =  V_gs;
            VsbPrime     =  V_sb;
            VdbPrime     =  V_ds + V_sb;
            VgdPrime     =  V_gs - V_ds;

            //  Voltages for overlaps
            xgs_ov       = -VgsPrime * inv_phita;
            xgd_ov       = -VgdPrime * inv_phita;
            xgb_ov       = -(Vgb - VFB_T) * inv_phita;

            //  Source-drain interchange
            sigVds       =  1.0;
            if (V_ds < 0.0) begin
                sigVds       = -1.0;
                V_gs         =  V_gs - V_ds;
                V_sb         =  V_sb + V_ds;
                V_ds         = -V_ds;
            end
            V_db         =  V_ds + V_sb;
            Vdsx         =  V_ds * V_ds / (sqrt(V_ds * V_ds + 0.01) + 0.1);

            //  Core's model calculation for DC
            begin : SPcalc_dc

                //  Local variable declaration
                `SPcalcLocalVarDecl

                //  Conditioning of terminal voltages
                V_xb         = `MINA(V_db, V_sb, bphi_dc) + phix_dc;
                V_xb_dc_tmp  =  V_xb;
                Vsbstar_dc   =  V_sb - `MINA(V_xb, 0, aphi_dc) + phix1_dc;
                Vsbstar_dc_tmp = Vsbstar_dc;
                dVbstar_dc   =  0.0;

                //  Adapt Vsb for NUD-effect
                if ((SWNUD != 0) && (GFACNUD_i != 1.0)) begin
                    Vmb          =  Vsbstar_dc + 0.5 * (V_ds - Vdsx);
                    us           =  sqrt(Vmb + phib_dc) - sqrt_phib_dc;
                    temp         =  2.0 * (us - us1) / us21 - 1.0;
                    usnew        =  us - 0.25 * (1.0 - GFACNUD_i) * us21 * (temp + sqrt(temp * temp + 0.4804530139182));
                    Vmbnew       =  usnew * usnew + (2.0 * sqrt_phib_dc) * usnew;
                    Vsbstar_dc   =  Vmbnew - 0.5 * (V_ds - Vdsx);
                    dVbstar_dc   =  Vsbstar_dc_tmp - Vsbstar_dc;
                end

                //  Set variables needed in PSP_core macro
                phib         =  phib_dc;
                aphi         =  aphi_dc;
                G_0          =  G_0_dc;
                Vsbstar      =  Vsbstar_dc;
                dVbstar      =  dVbstar_dc;
                thesatloc    =  THESAT_T;
                arloc        =  ar;

                //  Calculation of PSP model's core
                `SPCalculation_s
                Vgb1_dc      =  Vgb1;
                Vsbx_dc      =  Vsbx;
                phit1_dc     =  phit1;
                inv_phit1_dc =  inv_phit1;
                Gf_dc        =  Gf;
                Gf2_dc       =  Gf2;
                inv_Gf2_dc   =  inv_Gf2;
                xg_dc        =  xg;
                xno_s_dc     =  xno_s;
                xn_s_dc      =  xn_s;
                xi_dc        =  xi;
                margin_dc    =  margin;
                inv_xi_dc    =  inv_xi;
                SP_S_x1_dc   =  SP_S_x1;
                delta_ns_dc  =  delta_ns;
                x_s_dc       =  x_s;
                xi1s_dc      =  xi1s;
                xi2s_dc      =  xi2s;
                delta_1s_dc  =  delta_1s;
                Es_dc        =  Es;
                Ps_dc        =  Ps;
                Ds_dc        =  Ds;
                sqs_dc       =  sqs;
                alphas_dc    =  alphas;
                Rxcor_dc     =  Rxcor;
                xgs_dc       =  xgs;
                qis_dc       =  qis;
                qbs_dc       =  qbs;
                rhob_dc      =  rhob;
                rhog_dc      =  rhog;
                Gmobs_dc     =  Gmobs;
                xitsb_dc     =  xitsb;
                factheta_dc  =  factheta;

                `SPCalculation_d
                Vdsat_lim_dc =  Vdsat_lim;
                Vdsat_dc     =  V_dsat;
                Vdse_dc      =  Vdse;
                Udse_dc      =  Udse;
                x_ds_dc      =  x_ds;
                dps_dc       =  dps;
                x_m_dc       =  x_m;
                qbd_dc       =  qbd;
                eta_p_dc     =  eta_p;
                alpha_dc     =  alpha;
                qim_dc       =  qim;
                qim1_dc      =  qim1;
                qbm_dc       =  qbm;
                qeff1_dc     =  qeff1;
                Gmob_dc      =  Gmob;
                s1_dc        =  s1;
                thesateff_dc =  thesateff;
                Voxm_dc      =  Voxm;
                `ifdef NQSmodel
                    xgm_dc       =  xgm;
                `endif // NQSmodel

                //  Threshold voltage calculation for .OP
                `OPVThvarCalc
                vtho_i       =  vtho_op;
                vth_i        =  vth_op;

            end // SPcalc_dc

            GdL_dc       =  1.0;
            Gmob_dL_dc   =  1.0;
            Gvsatinv_dc  =  1.0;
            H_dc         =  1.0;
            I_ds         =  0.0;
            if (xg_dc > 0.0) begin
                // Channel length modulation
                s2           =  ln(1.0 + Vdsx * inv_VP);
                temp         =  phit1_dc * alpha_dc / qim1_dc;
                dL           =  (ALP_i + ALP1_i / qim1_dc) * qim_dc / qim1_dc * s1_dc + ALP2_i * qbm_dc * temp * temp * s2;
                GdL_dc       =  1.0 / (1.0 + dL + dL * dL);
                // Velocity saturation
                Gmob_dL_dc   =  Gmob_dc * GdL_dc;
                thesat1_dc   =  thesateff_dc / Gmob_dL_dc;
                zsat         =  thesat1_dc * thesat1_dc * dps_dc * dps_dc;
                if (CHNL_TYPE == `PMOS) begin
                    zsat         =  zsat / (1.0 + thesat1_dc * dps_dc);
                end
                Gvsat        =  0.5 * (Gmob_dL_dc * (1.0 + sqrt(1.0 + 2.0 * zsat)));
                Gvsatinv_dc  =  1.0 / Gvsat;
                // Variables for calculation of gate to channel current and thermal channel noise
                temp         =  Gmob_dL_dc * Gvsatinv_dc;
                alpha1       =  alpha_dc * (1.0 + 0.5 * (zsat * temp * temp));
                H_dc         =  temp * qim1_dc / alpha1;
                //  Drain-source current
                I_ds         =  BET_i * qim1_dc * dps_dc * Gvsatinv_dc;
            end

            //  Surface potential in gate overlap regions
            xs_ov        =  0.0;
            xd_ov        =  0.0;
            Vovs         =  0.0;
            Vovd         =  0.0;
            if (((SWIGATE != 0) && ((IGOV_i > 0.0) || (IGOVD_i > 0.0))) || ((SWGIDL != 0) && ((AGIDL_i > 0.0) || (AGIDLD_i > 0.0))) || (CGOV_i > 0.0) || (CGOVD_i > 0.0)) begin
                SP_OV_xg     = 0.5 * (xgs_ov + sqrt(xgs_ov * xgs_ov + SP_OV_eps2_s));
                xs_ov        = -SP_OV_xg - GOV2_s * 0.5 + GOV_s * sqrt(SP_OV_xg + GOV2_s * 0.25 + SP_OV_a_s) + SP_OV_delta1_s;
                SP_OV_xg     = 0.5 * (xgd_ov + sqrt(xgd_ov * xgd_ov + SP_OV_eps2_d));
                xd_ov        = -SP_OV_xg - GOV2_d * 0.5 + GOV_d * sqrt(SP_OV_xg + GOV2_d * 0.25 + SP_OV_a_d) + SP_OV_delta1_d;
                Vovs         = -phita * (xgs_ov + xs_ov);
                Vovd         = -phita * (xgd_ov + xd_ov);
            end

            //  Gate current
            Igsov        =  0.0;
            Igdov        =  0.0;
            Igc          =  0.0;
            I_gb         =  0.0;
            I_gcs        =  0.0;
            I_gcd        =  0.0;
            if (SWIGATE != 0) begin
                if (IGOV_i > 0.0) begin
                    //  Gate-source overlap component of gate current
                    zg           =  sqrt(Vovs * Vovs + 1.0e-06) * inv_CHIB;
                    if (GC3OV_i < 0.0) begin
                        zg           = `MINA(zg, GCQOV, 1.0e-06);
                    end
                    temp         =  BOV * (-1.5 + zg * (GC2OV_i + GC3OV_i * zg));
                    if (temp > 0.0) begin
                        TP           = `P3(temp);
                    end else begin
                        `expl_low(temp, TP)
                    end
                    Fs1          =  3.0 + xs_ov;
                    Fs2          = -3.0 - GCO_i;
                    Fs3          =  30.0 * VgsPrime;
                    `MNE(Fs1, Fs3, 0.9, temp)
                    `MXE(Fs2, temp, 0.3, Fs)
                    Igsov        =  IGOV_i * (TP * Fs);
                end

                if (IGOVD_i > 0.0) begin
                    //  Gate-drain overlap component of gate current
                    zg           =  sqrt(Vovd * Vovd + 1.0e-06) * inv_CHIB;
                    if (GC3OVD_i < 0.0) begin
                        zg           = `MINA(zg, GCQOVD, 1.0e-06);
                    end
                    temp         =  BOV_d * (-1.5 + zg * (GC2OVD_i + GC3OVD_i * zg));
                    if (temp > 0.0) begin
                        TP           = `P3(temp);
                    end else begin
                        `expl_low(temp, TP)
                    end
                    Fs1          =  3.0 + xd_ov;
                    Fs2          = -3.0 - GCO_i;
                    Fs3          =  30.0 * VgdPrime;
                    `MNE(Fs1, Fs3, 0.9, temp)
                    `MXE(Fs2, temp, 0.3, Fs)
                    Igdov        =  IGOVD_i * (TP * Fs);
                end

                //  Gate-channel component of gate current
                if (IGINV_i > 0.0) begin
                    if (xg_dc <= 0.0) begin
                        temp         =  1.0 + ar;
                        temp1        =  sqrt(temp) * V_ds / Vdsat_lim_dc;
                        temp2        =  temp1 * temp1 + temp;
                        temp         =  2.0 * temp1;
                        Udse_dc      =  Vdsat_lim_dc * inv_phit1_dc * temp / (sqrt(temp2 - temp) + sqrt(temp2 + temp));
                    end
                    `expl_low(x_ds_dc - Udse_dc, temp)
                    Vm           =  Vsbstar_dc + phit1_dc * (0.5 * x_ds_dc - ln(0.5 * (1.0 + temp)));
                    Dch          =  GCO_i * phit1_dc;
                    arg2mina     =  Voxm_dc + Dch;
                    psi_t        = `MINA(0.0, arg2mina, 0.01);
                    zg           =  sqrt(Voxm_dc * Voxm_dc + 1.0e-06) * inv_CHIB;
                    if (GC3_i < 0.0) begin
                        zg           = `MINA(zg, GCQ, 1.0e-06);
                    end
                    arg1         =  (x_m_dc + (psi_t - alpha_b - Vm) * inv_phit1_dc);
                    `expl(arg1,Dsi)
                    arg1         = -(V_gs + Vsbstar_dc - Vm) * inv_phit1_dc;
                    `expl(arg1,temp)
                    Dgate        =  Dsi * temp;
                    temp         =  BCH * (-1.5 + zg * (GC2_i + GC3_i * zg));
                    if (temp > 0.0) begin
                        TP           = `P3(temp);
                    end else begin
                        `expl_low(temp, TP)
                    end
                    Igc0         =  IGINV_i * (TP * ln((1.0 + Dsi) / (1.0 + Dgate)));

                    //  Source/drain partitioning of gate-channel current
                    if ((xg_dc <= 0.0) || ((GC2_i == 0.0) && (GC3_i == 0.0))) begin
                        igc          =  1.0;
                        igcd_h       =  0.5;
                    end else begin
                        temp         =  GC2_i + 2.0 * GC3_i * zg;
                        u0           =  CHIB_i / (temp * BCH);
                        x            =  0.5 * (dps_dc / u0);
                        u0_div_H     =  u0 / H_dc;
                        Bg           =  u0_div_H * (1.0 - u0_div_H) * 0.5;
                        Ag           =  0.5 - 3.0 * Bg;
                        if (x < 1.0e-3) begin
                            xsq          =  x * x;
                            igc          =  1.0 + xsq * (`oneSixth + u0_div_H * `oneThird + `oneSixth * (xsq * (0.05 + 0.2 * u0_div_H)));
                            igcd_h       =  0.5 * igc - `oneSixth * (x * (1.0 + xsq * (0.4 * (Bg + 0.25) + 0.0285714285714 * (xsq * (0.125 + Bg)))));
                        end else begin
                            inv_x        =  1.0 / x;
                            `expl(x, ex)
                            inv_ex       =  1.0 / ex;
                            temp         =  ex - inv_ex;
                            temp2        =  ex + inv_ex;
                            igc          =  0.5 * ((1.0 - u0_div_H) * temp * inv_x + u0_div_H * temp2);
                            igcd_h       =  0.5 * (igc - temp * (Bg - Ag * inv_x * inv_x) - Ag * temp2 * inv_x);
                        end
                    end
                    Sg           =  0.5 * (1.0 + xg_dc / sqrt(xg_dc * xg_dc + 1.0e-06));
                    Igc          =  Igc0 * igc * Sg;
                    I_gcd        =  Igc0 * igcd_h * Sg;
                    I_gcs        =  Igc - I_gcd;
                    I_gb         =  Igc0 * igc * (1.0 - Sg);
                end // (IGINV >0.0)
            end // (SWIGATE != 0)

            //  GIDL/GISL currents
            I_gidl       =  0.0;
            I_gisl       =  0.0;
            if (SWGIDL != 0) begin
                //  GIDL current computation
                if ((AGIDLD_i > 0.0) && (Vovd < 0.0)) begin
                    Vtovd        =  sqrt(Vovd * Vovd + CGIDLD_i * CGIDLD_i * (VdbPrime * VdbPrime) + 1.0e-6);
                    temp         = -BGIDLDs / Vtovd;
                    `expl_low(temp, temp2)
                    I_gidl       = -AGIDLDs * (VdbPrime * Vovd * Vtovd * temp2);
                end

                //  GISL current computation
                if ((AGIDL_i > 0.0) && (Vovs < 0.0)) begin
                    Vtovs        =  sqrt(Vovs * Vovs + CGIDL_i * CGIDL_i * (VsbPrime * VsbPrime) + 1.0e-06);
                    temp         = -BGIDLs / Vtovs;
                    `expl_low(temp, temp2)
                    I_gisl       = -AGIDLs * (VsbPrime * Vovs * Vtovs * temp2);
                end
            end // (SWGIDL != 0)

            //  Drain current of edge transistors
            phit1edge    =  phit;
            xgedge       =  0.0;
            qdseffedge   =  0.0;
            qmeffedge    =  0.0;
            dsqredge     =  1.0e-40;
            alphabmedge  =  1.0;
            I_dsedge     =  0.0;
            if ((SWEDGE != 0) && (BETNEDGE_i > 0.0)) begin
                temp         = `MINA(V_db, V_sb, bphiedge) + phixedge;
                Vsbstaredge  =  V_sb - `MINA(temp, 0.0, aphiedge) + phix1edge;
                Vsbxedge     =  Vsbstaredge + 0.5 * (V_ds - Vdsx);
                dphit1edge   =  PSCEEDGE_i * (1.0 + PSCEDEDGE_i * Vdsx)* (1.0 + PSCEBEDGE_i * Vsbxedge); // SCE on subthreshold slope
                phit1edge    =  phit0edge * (1.0 + dphit1edge);
                inv_phit1edge =  1.0 / phit1edge;
                Vdspedge     =  2.0 * Vdsx / (1.0 + sqrt(1.0 + CFDEDGE_i * Vdsx));
                delVgedge    =  CFEDGE_i * Vdspedge * (1.0 + CFBEDGE_i * Vsbxedge); // DIBL effect
                xgedge       =  inv_phit1edge * (Vgb + delVgedge - VFBEDGE_T);
                xbedge       =  inv_phit1edge * phibedge;
                dxthedge     =  2.0 * ln(xbedge / Gfedge + sqrt(xbedge));
                xnedge_s     =  inv_phit1edge * Vsbstaredge;
                `qi_edge(qseffedge,xgedge,xnedge_s)
                xnedge_d     =  inv_phit1edge * (Vdse_dc + Vsbstaredge);
                if ((qseffedge < 1.0e-03) && (Vdse_dc < 1.0e-06)) begin
                    `expl_low((-xnedge_d + xnedge_s), temp)
                    qdseffedge   =  qseffedge * (temp - 1.0);
                    qdeffedge    =  qdseffedge + qseffedge;
                end else begin
                    `qi_edge(qdeffedge,xgedge,xnedge_d)
                    qdseffedge   =  qdeffedge - qseffedge;
                end
                qmeffedge    =  0.5 * (qdeffedge + qseffedge);
                dsqredge     = `MAX(xgedge - qmeffedge, 1.0e-40);
                alphabmedge  =  1.0 - 0.5 * Gfedge / sqrt(dsqredge + 0.25 * Gfedge2);
                I_dsedge     = -BETEDGE_i * phit1edge * phit1edge * (alphabmedge * qmeffedge  + 1.0) * qdseffedge / Gmob_dc;
            end

            //  Impact-Ionization current
            mavl         =  0.0;
            Iimpact      =  0.0;
            if ((xg_dc > 0.0) && (SWIMPACT != 0)) begin
                delVsat      =  V_ds - A3_i * dps_dc;
                if (delVsat > 0.0) begin
                    temp2        =  A2_T * ((1.0 + A4_i * (sqrt(phib_dc + Vsbstar_dc) - sqrt_phib_dc)) / (delVsat + 1.0e-30));
                    `expl(-temp2, temp)
                    mavl         =  A1_i * (delVsat * temp);
                    Iimpact      =  mavl * (I_ds + I_dsedge);
                    if (Iimpact > 0.5 * IMAXII_i) begin
                        temp = 2.0 * Iimpact / IMAXII_i - 1.0;
                        Iimpact = 0.5 * IMAXII_i * (1.0 + temp / sqrt(1.0 + temp * temp));
                    end
                end
            end

        end // evaluateStatic

        //  --------------------------------------------------------------------------------------------------------------
        //  AC bias dependent quantities (calculations for charge contribs)
        //  --------------------------------------------------------------------------------------------------------------
        begin : evaluateDynamic

            //  Declaration of local variables
            real dL, zsat, alpha1, Fj, Fj2, QG, QCLM, QD, QI, QB, Vginr, Vginreff, fqinr, dVinracc, finracc, xginrdep;
            real finrdep, dVinrdep, finr, dVinr, Vgsinr, Vsginr, Vgdinr, Vdginr, Qginr, Qsinr, Qdinr, yb_ov_s, xgbeff_ov_s;
            real Qg_ov_s, yb_ov_d, xgbeff_ov_d, Qg_ov_d, Qg_ov;

            //  Core's model calculation for AC
            begin : SPcalc_ac

                //  Local variable declaration
                `SPcalcLocalVarDecl

                //  SP calculations
                if ((SWNUD == 1) || (SWDELVTAC > 0) || (SWQSAT > 0)) begin
                    // New calculation of the surface potential at the source side
                    if ((SWNUD > 0) || (SWDELVTAC > 0)) begin
                        phib         =  phib_dc;
                        aphi         =  aphi_dc;
                        G_0          =  G_0_dc;
                        V_xb         =  V_xb_dc_tmp;
                        Vsbstar      =  Vsbstar_dc_tmp;
                        dVbstar      =  0.0;
                        if (SWDELVTAC > 0) begin
                            //  Conditioning of terminal voltages
                            V_xb         = `MINA(V_db, V_sb, bphi_ac) + phix_ac;
                            Vsbstar_ac   =  V_sb - `MINA(V_xb, 0.0, aphi_ac) + phix1_ac;
                            Vsbstar      =  Vsbstar_ac;
                            phib         =  phib_ac;
                            aphi         =  aphi_ac;
                            G_0          =  G_0_ac;
                        end
                        `SPCalculation_s
                        //  Threshold voltage calculation for .OP
                        `OPVThvarCalc
                        vthac_i      =  vth_op;
                    end else begin
                        Vgb1         =  Vgb1_dc;
                        Vsbx         =  Vsbx_dc;
                        phit1        =  phit1_dc;
                        inv_phit1    =  inv_phit1_dc;
                        Gf           =  Gf_dc;
                        Gf2          =  Gf2_dc;
                        inv_Gf2      =  inv_Gf2_dc;
                        xg           =  xg_dc;
                        xno_s        =  xno_s_dc;
                        xn_s         =  xn_s_dc;
                        xi           =  xi_dc;
                        margin       =  margin_dc;
                        inv_xi       =  inv_xi_dc;
                        SP_S_x1      =  SP_S_x1_dc;
                        delta_ns     =  delta_ns_dc;
                        x_s          =  x_s_dc;
                        xi1s         =  xi1s_dc;
                        xi2s         =  xi2s_dc;
                        delta_1s     =  delta_1s_dc;
                        Es           =  Es_dc;
                        Ps           =  Ps_dc;
                        Ds           =  Ds_dc;
                        sqs          =  sqs_dc;
                        alphas       =  alphas_dc;
                        Rxcor        =  Rxcor_dc;
                        xgs          =  xgs_dc;
                        qis          =  qis_dc;
                        qbs          =  qbs_dc;
                        rhob         =  rhob_dc;
                        rhog         =  rhog_dc;
                        Gmobs        =  Gmobs_dc;
                        xitsb        =  xitsb_dc;
                        factheta     =  factheta_dc;
                        //  Threshold voltage calculation for .OP
                        vthac_i      =  vth_i;
                    end

                    // New calculation of the surface potential at the drain side
                    thesatloc    =  THESAT_T;
                    arloc        =  ar;
                    if (SWQSAT != 0) begin
                        thesatloc    =  THESATAC_T;
                        arloc        =  arac;
                    end
                    `SPCalculation_d
                    Vgb1_ac      =  Vgb1;
                    phit1_ac     =  phit1;
                    Gf_ac        =  Gf;
                    xg_ac        =  xg;
                    xno_s_ac     =  xno_s;
                    qbs_ac       =  qbs;
                    dps_ac       =  dps;
                    qbd_ac       =  qbd;
                    eta_p_ac     =  eta_p;
                    alpha_ac     =  alpha;
                    qim_ac       =  qim;
                    qim1_ac      =  qim1;
                    qeff1_ac     =  qeff1;
                    Gmob_ac      =  Gmob;
                    s1_ac        =  s1;
                    thesateff_ac =  thesateff;
                    Voxm_ac      =  Voxm;
                    `ifdef NQSmodel
                        inv_phit1_ac =  inv_phit1;
                        margin_ac    =  margin;
                        x_m_ac       =  x_m;
                        xgm_ac       =  xgm;
                    `endif // NQSmodel
                end else begin
                    phib_ac      =  phib_dc;
                    Vgb1_ac      =  Vgb1_dc;
                    phit1_ac     =  phit1_dc;
                    Gf_ac        =  Gf_dc;
                    xg_ac        =  xg_dc;
                    xno_s_ac     =  xno_s_dc;
                    qbs_ac       =  qbs_dc;
                    dps_ac       =  dps_dc;
                    qbd_ac       =  qbd_dc;
                    eta_p_ac     =  eta_p_dc;
                    alpha_ac     =  alpha_dc;
                    qim_ac       =  qim_dc;
                    qim1_ac      =  qim1_dc;
                    qeff1_ac     =  qeff1_dc;
                    Gmob_ac      =  Gmob_dc;
                    s1_ac        =  s1_dc;
                    thesateff_ac =  thesateff_dc;
                    Voxm_ac      =  Voxm_dc;
                    `ifdef NQSmodel
                        inv_phit1_ac =  inv_phit1_dc;
                        margin_ac    =  margin_dc;
                        x_m_ac       =  x_m_dc;
                        xgm_ac       =  xgm_dc;
                    `endif // NQSmodel
                    //  Threshold voltage calculation for .OP
                    vthac_i      =  vth_i;
                end
            end // SPcalc_ac

            //  Quantum mechanical corrections
            COX_qm       =  COX_i;
            if (qq > 0.0) begin
                COX_qm       =  COX_i / (1.0 + qq * pow(qeff1_ac * qeff1_ac + qlim2, -1.0 * `oneSixth));
            end

            //  Intrinsic charge model
            GdL_ac       =  1.0;
            Gmob_dL_ac   =  1.0;
            thesat1_ac   =  0.0;
            Gvsat_ac     =  1.0;
            H_ac         =  1.0;
            QG           =  Voxm_ac;
            QI           =  0.0;
            QD           =  0.0;
            QB           =  QG;
            if (xg_ac > 0.0) begin
                // Channel length modulation
                dL           =  (ALPAC_i + ALP1AC_i / qim1_ac) * qim_ac / qim1_ac * s1_ac;
                if (dL > 0.0) begin
                    GdL_ac       =  1.0 / (1.0 + dL + dL * dL);
                end else begin
                    GdL_ac       =  1.0 - dL;
                end
                // Velocity saturation
                Gmob_dL_ac   =  Gmob_ac * GdL_ac;
                thesat1_ac   =  thesateff_ac / Gmob_dL_ac;
                zsat         =  thesat1_ac * thesat1_ac * dps_ac * dps_ac;
                if (CHNL_TYPE == `PMOS) begin
                    zsat         =  zsat / (1.0 + thesat1_ac * dps_ac);
                end
                Gvsat_ac     =  0.5 * (Gmob_dL_ac * (1.0 + sqrt(1.0 + 2.0 * zsat)));
                // Intrinsic charges
                temp         =  Gmob_dL_ac / Gvsat_ac;
                alpha1       =  alpha_ac * (1.0 + 0.5 * (zsat * temp * temp));
                H_ac         =  temp * qim1_ac / alpha1;
                Fj           =  0.5 * (dps_ac / H_ac);
                Fj2          =  Fj * Fj;
                QG           =  Voxm_ac + 0.5 * (eta_p_ac * dps_ac * (Fj * GdL_ac * `oneThird - 1.0 + GdL_ac));
                temp         =  alpha_ac * dps_ac * `oneSixth;
                if (SWQPART == 1) begin
                    QCLM         =  0.0;
                    QD           =  0.5 * GdL_ac * GdL_ac * (qim_ac - 3.0 * temp * (2.0 - Fj));
                end else begin
                    QCLM         =  (1.0 - GdL_ac) * (qim_ac - 0.5 * (alpha_ac * dps_ac));
                    QD           =  0.5 * (GdL_ac * GdL_ac * (qim_ac - temp * (1.0 - Fj - 0.2 * Fj2)) + QCLM * (1.0 + GdL_ac));
                end
                QI           =  GdL_ac * (qim_ac + temp * Fj) + QCLM;
                QB           =  QG - QI;
            end
            Qg           =  QG * COX_qm;
            Qd           = -QD * COX_qm;
            Qb           = -QB * COX_qm;

            //  Inner fringe charge model
            Qsinr        =  0.0;
            Qdinr        =  0.0;
            Qginr        =  0.0;
            if ((CINR_i > 0.0)||(CINRD_i > 0.0)) begin
                finracc      =  1.0;
                dVinracc     =  Vgb1_ac;
                if (FCINRACC_i > 1.0e-10) begin
                    Vginr        =  Vgb1_ac - DVFBINR_i + Vinr_max;
                    temp         = `MAXA(Vginr, Vinr_max, ainr);
                    temp1        =  temp * (2.0 * temp - Vinr_max - Vginr);
                    temp2        =  Vinr_max / temp;
                    Vginreff     =  Vginr * temp2;
                    fqinr        =  sqrt(1.0 - Vginreff * FCINRACC_i);
                    dVinracc     =  (1.0 - fqinr) / FCINRACC_i + Vginr - Vginreff;
                    finracc      =  (0.5 / fqinr - 1.0) * (temp1 + Vginr * (Vinr_max - temp)) * temp2 / temp1 + 1.0;
                end
                finrdep      =  1.0;
                dVinrdep     =  0.0;
                if (FCINRDEP_i > 0.0) begin
                    temp         =  0.5 * phib_ac + phit1_ac * (1.0 + Gf_ac * `invSqrt2);
                    xginrdep     =  Vgb1_ac / temp;
                    if (abs(xginrdep) < `se05) begin
                        finrdep      =  1.0 / (1.0 + exp(-xginrdep));
                    end else begin
                        if (xginrdep < 0.0) begin
                            finrdep      =  `ke05 / `P3(-`se05 + xginrdep);
                        end
                    end
                    if (xginrdep < `se05) begin
                        temp1        =  ln(1.0 + exp(xginrdep));
                    end else begin
                        temp1        =  xginrdep;
                    end
                    dVinrdep     =  temp * temp1;
                end
                finr         =  FCINRDEP_i * (finrdep - finracc) + finracc;
                dVinr        =  FCINRDEP_i * (dVinrdep - dVinracc) + dVinracc;
                Vgsinr       =  Vgb1_ac - phit1_ac * xno_s_ac - Voxm_ac - 0.5 * dps_ac;
                Vsginr       =  Vgb1_ac - Vgsinr - qbs_ac;
                Vgdinr       =  dps_ac + Vgsinr - V_ds;
                Vdginr       =  Vgb1_ac - Vgdinr - qbd_ac;
                if (sigVds > 0.0) begin
                    Qginr        =  finr * (CINRD_i * Vgdinr + CINR_i * Vgsinr);
                    Qsinr        =  CINR_i * (Vsginr - dVinr);
                    Qdinr        =  CINRD_i * (Vdginr - dVinr);
                end else begin
                    Qginr        =  finr * (CINR_i * Vgdinr + CINRD_i * Vgsinr);
                    Qsinr        =  CINRD_i * (Vsginr - dVinr);
                    Qdinr        =  CINR_i * (Vdginr - dVinr);
                end
                Qg           =  Qg + Qginr;
                Qd           =  Qd + Qdinr;
                Qb           =  Qb - Qginr - Qdinr - Qsinr;
            end

            //  Overlaps charge model
            Qgs_ov       =  CGOV_i * Vovs;
            Qgd_ov       =  CGOVD_i * Vovd;
            Qg_ov_s      =  0.0;
            yb_ov_s      =  0.0;
            if ((CGOV_i > 0.0)&&(FCGOVACC_i > 0.0)) begin
                temp         =  CGOVACCG_i * (0.5 * xgb_ov + dxgb_ov_s);
                if (temp < `se05) begin
                    `expl_low(temp, yb_ov_s)
                    if (yb_ov_s > 1.0e-10) begin
                        xgbeff_ov_s  =  ln(1.0 + yb_ov_s);
                        temp1        =  xgbeff_ov_s * (1.0 - ln(1.0 + xgbeff_ov_s) / (2.0 + xgbeff_ov_s));
                    end else begin
                        xgbeff_ov_s  =  yb_ov_s;
                        temp1        =  2.0 * xgbeff_ov_s / (2.0 + xgbeff_ov_s);
                    end
                end else begin
                    xgbeff_ov_s  =  temp;
                    temp1        =  xgbeff_ov_s * (1.0 - ln(1.0 + xgbeff_ov_s) / (2.0 + xgbeff_ov_s));
                end
                Qg_ov_s      = -2.0 * FCGOVACC_i / CGOVACCG_i * CGOV_i * phita * temp1;
            end
            Qg_ov_d      =  0.0;
            yb_ov_d      =  0.0;
            if ((CGOVD_i > 0.0)&&(FCGOVACCD_i > 0.0)) begin
                temp         =  CGOVACCG_i * (0.5 * xgb_ov + dxgb_ov_d);
                if (temp < `se05) begin
                    `expl_low(temp, yb_ov_d)
                    if (yb_ov_d > 1.0e-10) begin
                        xgbeff_ov_d  =  ln(1.0 + yb_ov_d);
                        temp1        =  xgbeff_ov_d * (1.0 - ln(1.0 + xgbeff_ov_d) / (2.0 + xgbeff_ov_d));
                    end else begin
                        xgbeff_ov_d  =  yb_ov_d;
                        temp1        =  2.0 * xgbeff_ov_d / (2.0 + xgbeff_ov_d);
                    end
                end else begin
                    xgbeff_ov_d  =  temp;
                    temp1        =  xgbeff_ov_d * (1.0 - ln(1.0 + xgbeff_ov_d) / (2.0 + xgbeff_ov_d));
                end
                Qg_ov_d      = -2.0 * FCGOVACCD_i / CGOVACCG_i * CGOVD_i * phita * temp1;
            end
            Qg_ov        =  Qg_ov_s + Qg_ov_d;
            Qgb_ov       =  CGBOV_i * Vgb + Qg_ov;

            //  Outer fringe charges
            Qfgs         =  CFR_i * VgsPrime;
            Qfgd         =  CFRD_i * VgdPrime;

            //  Variables for NQS model
            `ifdef NQSmodel
                Gp           =  0.0;
                Gp2          =  0.0;
                a_factrp     =  0.0;
                marginp      =  0.0;
                if (SWNQS_i != 0) begin
                    if (xg_ac <= 0.0) begin
                        ym           =  0.5;
                        pd           =  1.0;
                        Gp           =  Gf_ac;
                    end else begin
                        ym           =  0.5 * ( 1.0 + 0.25 * (dps_ac / H_ac));
                        pd           =  xgm_ac / (xg_ac - x_m_ac);
                        Gp           =  Gf_ac / pd;
                    end
                    Gp2          =  Gp * Gp;
                    a_factrp     =  1.0 + Gp * `invSqrt2;
                    marginp      =  1.0e-5 * a_factrp;
                end
            `endif // NQSmodel

        end // evaluateDynamic

        //  --------------------------------------------------------------------------------------------------------------
        //  JUNCAP2 contribs
        //  --------------------------------------------------------------------------------------------------------------
        begin : evaluateStaticDynamic

            //  Fix: add here variables declaration; required for some verilog-A compilers
            `LocalGlobalVars
            real nu, vjtmp;

            // Fix: initialization of (local) variables; required for some verilog-A compilers
            `JuncapLocalVarInit

            nu           =  0.0;
            vjtmp        =  0.0;
            ijun_s       =  0.0;
            ijunbot_s    =  0.0;
            ijunsti_s    =  0.0;
            ijungat_s    =  0.0;
            ijun_d       =  0.0;
            ijunbot_d    =  0.0;
            ijunsti_d    =  0.0;
            ijungat_d    =  0.0;
            qjun_s       =  0.0;
            qjunbot_s    =  0.0;
            qjunsti_s    =  0.0;
            qjungat_s    =  0.0;
            qjun_d       =  0.0;
            qjunbot_d    =  0.0;
            qjunsti_d    =  0.0;
            qjungat_d    =  0.0;
            if (SWJUNCAP > 0) begin
                if (SWJUNEXP_i == 1) begin
                    `JuncapExpressCurrent(Vjun_s, MFOR1_s, ISATFOR1_s, MFOR2_s, ISATFOR2_s, MREV_s, ISATREV_s, m0flag_s, xhighf1_s, expxhf1_s, xhighf2_s, expxhf2_s, xhighr_s, expxhr_s, ijun_s)
                    `JuncapExpressCurrent(Vjun_d, MFOR1_d, ISATFOR1_d, MFOR2_d, ISATFOR2_d, MREV_d, ISATREV_d, m0flag_d, xhighf1_d, expxhf1_d, xhighf2_d, expxhf2_d, xhighr_d, expxhr_d, ijun_d)
                    begin : evaluateDynamic
                        real tmpv, vjv;
                        `JuncapExpressCharge(Vjun_s, ABSOURCE_i, LSSOURCE_i, LGSOURCE_i, qprefbot,   qprefsti,   qprefgat,   qpref2bot,   qpref2sti,   qpref2gat,   vbiinvbot,   vbiinvsti,   vbiinvgat,   one_minus_PBOT,   one_minus_PSTI,   one_minus_PGAT,   vfmin_s, vch_s, zflagbot_s, zflagsti_s, zflaggat_s, qjunbot_s, qjunsti_s, qjungat_s)
                        `JuncapExpressCharge(Vjun_d, ABDRAIN_i,  LSDRAIN_i,  LGDRAIN_i,  qprefbot_d, qprefsti_d, qprefgat_d, qpref2bot_d, qpref2sti_d, qpref2gat_d, vbiinvbot_d, vbiinvsti_d, vbiinvgat_d, one_minus_PBOT_d, one_minus_PSTI_d, one_minus_PGAT_d, vfmin_d, vch_d, zflagbot_d, zflagsti_d, zflaggat_d, qjunbot_d, qjunsti_d, qjungat_d)
                    end
                end else begin
                    // Gate-dependent breakdown voltage shift model
                    if (ADVBRGAT > 0 ) begin
                        dvbrgat     = ADVBRGAT  * (pow(`MAXA(V_gs + V_sb, 0.0, `SDVBRGAT * `SDVBRGAT), BDVBRGAT) - pow(0.5 * `SDVBRGAT, BDVBRGAT));
                        vbrgat_var  = VBRGAT + dvbrgat;
                        VBRinvgat   =  1.0 / vbrgat_var;
                        slopegat    = slopegat / (1.0 + dvbrgat / VBRGAT);
                    end else begin
                        vbrgat_var  = VBRGAT;
                    end
                    // Gate-dependent BBT current shift model
                    if (ADBBTGAT > 0 ) begin
                        dfbbtgat    = ADBBTGAT  * (pow(`MAXA(V_gs + V_sb, 0.0, `SDBBTGAT * `SDBBTGAT), BDBBTGAT) - pow(0.5 * `SDBBTGAT, BDBBTGAT));
                        fbbtgat     = fbbtgat * (1.0 + dfbbtgat);
                    end
                    `juncapcommon(Vjun_s, ABSOURCE_i, LSSOURCE_i, LGSOURCE_i, qprefbot, qpref2bot, vbiinvbot, one_minus_PBOT, idsatbot, CSRHBOT, CTATBOT, vbibot, wdepnulrbot, VBIRBOTinv, PBOT, ftdbot, btatpartbot, atatbot, one_over_one_minus_PBOT, CBBTBOT, VBIRBOT, wdepnulrinvbot, fbbtbot, VBRBOT, VBRinvbot, PBRBOT, fstopbot, slopebot, qprefsti, qpref2sti, vbiinvsti, one_minus_PSTI, idsatsti, CSRHSTI, CTATSTI, vbisti, wdepnulrsti, VBIRSTIinv, PSTI, ftdsti, btatpartsti, atatsti, one_over_one_minus_PSTI, CBBTSTI, VBIRSTI, wdepnulrinvsti, fbbtsti, VBRSTI, VBRinvsti, PBRSTI, fstopsti, slopesti, qprefgat, qpref2gat, vbiinvgat, one_minus_PGAT, swgat2nd, qprefgat2nd, qpref2gat2nd, vbiinvgat2nd, one_minus_pgat2nd, VTRGAT, ANUGAT, idsatgat, CSRHGAT, CTATGAT, vbigat, wdepnulrgat, VBIRGATinv, PGAT, ftdgat, btatpartgat, atatgat, one_over_one_minus_PGAT, CBBTGAT, VBIRGAT, wdepnulrinvgat, fbbtgat, vbrgat_var, VBRinvgat, PBRGAT, fstopgat, slopegat, VMAX_s, exp_VMAX_over_phitd_s, vbimin_s, vch_s, vfmin_s, vbbtlim_s, ijunbot_s, qjunbot_s, ijunsti_s, qjunsti_s, ijungat_s, qjungat_s)
                    ijun_s = ABSOURCE_i * ijunbot_s + LSSOURCE_i * ijunsti_s + LGSOURCE_i * ijungat_s;
                    // Gate-dependent breakdown voltage shift model
                    if (ADVBRGATD_i > 0 ) begin
                        dvbrgat_d     = ADVBRGATD_i  * (pow(`MAXA(V_gs + V_sb, 0.0,`SDVBRGAT * `SDVBRGAT), BDVBRGATD_i) - pow(0.5 * `SDVBRGAT, BDVBRGATD_i));
                        vbrgat_var_d  = VBRGATD_i + dvbrgat_d;
                        VBRinvgat_d   =  1.0 / vbrgat_var_d;
                        slopegat_d    = slopegat_d / (1.0 + dvbrgat_d / VBRGATD_i);
                    end else begin
                        vbrgat_var_d  = VBRGATD_i;
                    end
                    // Gate-dependent BBT current shift model
                    if (ADBBTGATD_i > 0 ) begin
                        dfbbtgat_d    = ADBBTGATD_i  * (pow(`MAXA(V_gs + V_sb, 0.0, `SDBBTGAT * `SDBBTGAT), BDBBTGATD_i) - pow(0.5 * `SDBBTGAT, BDBBTGATD_i));
                        fbbtgat_d     = fbbtgat_d * (1.0 + dfbbtgat_d);
                    end
                    `juncapcommon(Vjun_d, ABDRAIN_i,  LSDRAIN_i,  LGDRAIN_i,  qprefbot_d, qpref2bot_d, vbiinvbot_d, one_minus_PBOT_d, idsatbot_d, CSRHBOTD_i, CTATBOTD_i, vbibot_d, wdepnulrbot_d, VBIRBOTinv_d, PBOTD_i, ftdbot_d, btatpartbot_d, atatbot_d, one_over_one_minus_PBOT_d, CBBTBOTD_i, VBIRBOTD_i, wdepnulrinvbot_d, fbbtbot_d, VBRBOTD_i, VBRinvbot_d, PBRBOTD_i, fstopbot_d, slopebot_d, qprefsti_d, qpref2sti_d, vbiinvsti_d, one_minus_PSTI_d, idsatsti_d, CSRHSTID_i, CTATSTID_i, vbisti_d, wdepnulrsti_d, VBIRSTIinv_d, PSTID_i, ftdsti_d, btatpartsti_d, atatsti_d, one_over_one_minus_PSTI_d, CBBTSTID_i, VBIRSTID_i, wdepnulrinvsti_d, fbbtsti_d, VBRSTID_i, VBRinvsti_d, PBRSTID_i, fstopsti_d, slopesti_d, qprefgat_d, qpref2gat_d, vbiinvgat_d, one_minus_PGAT_d, swgat2nd_d, qprefgat2nd_d, qpref2gat2nd_d, vbiinvgat2nd_d, one_minus_pgat2nd_d, VTRGATD_i, ANUGATD_i, idsatgat_d, CSRHGATD_i, CTATGATD_i, vbigat_d, wdepnulrgat_d, VBIRGATinv_d, PGATD_i, ftdgat_d, btatpartgat_d, atatgat_d, one_over_one_minus_PGAT_d, CBBTGATD_i, VBIRGATD_i, wdepnulrinvgat_d, fbbtgat_d, vbrgat_var_d, VBRinvgat_d, PBRGATD_i, fstopgat_d, slopegat_d, VMAX_d, exp_VMAX_over_phitd_d, vbimin_d, vch_d, vfmin_d, vbbtlim_d, ijunbot_d, qjunbot_d, ijunsti_d, qjunsti_d, ijungat_d, qjungat_d)
                    ijun_d = ABDRAIN_i * ijunbot_d + LSDRAIN_i * ijunsti_d + LGDRAIN_i * ijungat_d;
                end
            end

            //  --------------------------------------------------------------------------------------------------------------
            //  NQS and parasitic resistance contribs
            //  --------------------------------------------------------------------------------------------------------------

            //  Set initial conditions for NQS model
            `ifdef NQSmodel
                `InitNQS
            `endif // NQSmodel

            //  Parasitic resistances (including noise)
            rgatenoise   =  nt0 * ggate;
            rsourcenoise =  nt0 * gsource;
            rdrainnoise  =  nt0 * gdrain;
            rbulknoise   =  nt0 * gbulk;
            rjunsnoise   =  nt0 * gjuns;
            rjundnoise   =  nt0 * gjund;
            rwellnoise   =  nt0 * gwell;

        end // evaluateStaticDynamic

        //  --------------------------------------------------------------------------------------------------------------
        //  Current contribs
        //  --------------------------------------------------------------------------------------------------------------
        begin : loadStatic

            //  Convert back for NMOS-PMOS and Source-Drain interchange
            if (sigVds > 0.0) begin
                I(di, bp)    <+  CHNL_TYPE * MULT_inst * MULT_I * Iimpact;
                I(di, si)    <+  CHNL_TYPE * MULT_inst * MULT_I * (I_ds + I_dsedge);
                I(gp, si)    <+  CHNL_TYPE * MULT_inst * MULT_I * I_gcs;
                I(gp, di)    <+  CHNL_TYPE * MULT_inst * MULT_I * I_gcd;
            end else begin
                I(si, bp)    <+  CHNL_TYPE * MULT_inst * MULT_I * Iimpact;
                I(si, di)    <+  CHNL_TYPE * MULT_inst * MULT_I * (I_ds + I_dsedge);
                I(gp, di)    <+  CHNL_TYPE * MULT_inst * MULT_I * I_gcs;
                I(gp, si)    <+  CHNL_TYPE * MULT_inst * MULT_I * I_gcd;
            end
            I(gp, bp)    <+  CHNL_TYPE * MULT_inst * MULT_I * I_gb;
            I(gp, si)    <+  CHNL_TYPE * MULT_inst * MULT_I * Igsov;
            I(gp, di)    <+  CHNL_TYPE * MULT_inst * MULT_I * Igdov;
            I(si, bp)    <+  CHNL_TYPE * MULT_inst * MULT_I * I_gisl;
            I(di, bp)    <+  CHNL_TYPE * MULT_inst * MULT_I * I_gidl;
            I(bs, si)    <+  CHNL_TYPE * MULT_inst * MULT_I * ijun_s;
            I(bd, di)    <+  CHNL_TYPE * MULT_inst * MULT_I * ijun_d;

            // Node collapse in case of zero resistance
            `CollapsableR(ggate,   RG_i,    rgatenoise,   g,  gp, "rgate")
            `CollapsableR(gsource, RSE_i,   rsourcenoise, s,  si, "rsource")
            `CollapsableR(gdrain,  RDE_i,   rdrainnoise,  d,  di, "rdrain")
            `CollapsableR(gbulk,   RBULK_i, rbulknoise,   bp, bi, "rbulk")
            `CollapsableR(gjuns,   RJUNS_i, rjunsnoise,   bs, bi, "rjuns")
            `CollapsableR(gjund,   RJUND_i, rjundnoise,   bd, bi, "rjund")
            `CollapsableR(gwell,   RWELL_i, rwellnoise,   b,  bi, "rwell")

            I(di, bp)    <+  MULT_I  * gmin * V(di, bp);
            I(si, bp)    <+  MULT_I  * gmin * V(si, bp);

        end // loadStatic

        //  --------------------------------------------------------------------------------------------------------------
        //  ddt() contribs from charges (Note: MULT is handled explicitly)
        //  --------------------------------------------------------------------------------------------------------------
        begin : loadStaticDynamic

            //  Implementation of NQS charges
            `ifdef NQSmodel
                `CalcChargesNQS
            `endif // NQSmodel

            //  Implementation of Self heating effect
            `ifdef SelfHeating
                begin : self_heating
                    real Pdiss_s, Pdiss_d;
                    Pdiss        =  0.0;
                    Pdiss_s      =  0.0;
                    Pdiss_d      =  0.0;
                    if (RSE_i > 0.0) begin
                        Pdiss_s      =  gsource * V(s, si) * V(s, si);
                    end
                    if (RDE_i > 0.0) begin
                        Pdiss_d      =  gdrain * V(d, di) * V(d, di);
                    end
                    if (RTH_p > 1.0e-3) begin
                        Pdiss        =  ((I_ds + I_dsedge) * V_ds + Iimpact * (V_ds + V_sb) + Pdiss_s + Pdiss_d);
                    end
                    Pwr(br_ith)  <+ -MULT_inst * Pdiss;
                    Pwr(br_rth)  <+  ddt(MULT_inst * CTH_i * Temp(br_rth));
                    Pwr(br_rth)  <+  MULT_inst * Temp(br_rth) / RTH_T;
                end // self_heating
            `endif // SelfHeating

        end // loadStaticDynamic

        begin : loadDynamic

            //  Local variable
            real temp;

            //  Intrinsic MOSFET charges
            Qs           =  -(Qg + Qb + Qd);

            //  Total outerFringe + overlap for gate-source and gate-drain.
            Qfgs         =  Qfgs + Qgs_ov;
            Qfgd         =  Qfgd + Qgd_ov;

            //  JUNCAP2 charges
            qjun_s       =  ABSOURCE_i * qjunbot_s + LSSOURCE_i * qjunsti_s + LGSOURCE_i * qjungat_s;
            qjun_d       =  ABDRAIN_i * qjunbot_d + LSDRAIN_i * qjunsti_d + LGDRAIN_i * qjungat_d;

            //  Convert back (undo S-D interchange)
            if (sigVds < 0.0) begin
                temp         =  Qd;    // Qd <--> Qs
                Qd           =  Qs;
                Qs           =  temp;
            end

            I(gp, si)    <+  ddt(CHNL_TYPE * MULT_inst * MULT_Q * Qg);
            I(bp, si)    <+  ddt(CHNL_TYPE * MULT_inst * MULT_Q * Qb);
            I(di, si)    <+  ddt(CHNL_TYPE * MULT_inst * MULT_Q * Qd);
            I(gp, si)    <+  ddt(CHNL_TYPE * MULT_inst * MULT_Q * Qfgs);
            I(gp, di)    <+  ddt(CHNL_TYPE * MULT_inst * MULT_Q * Qfgd);
            I(gp, bp)    <+  ddt(CHNL_TYPE * MULT_inst * MULT_Q * Qgb_ov);
            I(bs, si)    <+  ddt(CHNL_TYPE * MULT_inst * MULT_Q * qjun_s);
            I(bd, di)    <+  ddt(CHNL_TYPE * MULT_inst * MULT_Q * qjun_d);

        end // loadDynamic

        //  --------------------------------------------------------------------------------------------------------------
        //  Noise
        //  --------------------------------------------------------------------------------------------------------------
        begin : noise

            //  Declaration of local variables
            real N1, Nm1, Delta_N1, H0, t1, sqt2, t2, r, lc, lcinv2, g_ideal, mid;
            real thesat1_exc, zsat_exc, Gvsat_exc, gfac, Sidexc, migid0, sqig, anoisedge, N1edge, Nm1edge, Delta_N1edge;
            real H0edge, t1edge, sqt2edge, t2edge, redge, lcedge, lcinv2edge, g_idealedge, midedge;

            //  Noise variable calculation
            S_fl         =  0.0;
            Sidexc       =  0.0;
            mid          =  0.0;
            mig          =  1.0e-40;
            migid        =  0.0;
            c_igid       =  0.0;
            CGeff        =  COX_qm * eta_p_ac;
            sqid         =  0.0;
            sqig         =  0.0;
            Sfledge      =  0.0;
            midedge      =  0.0;
            sqidedge     =  0.0;

            //  Channel noise contributions
            if ((xg_dc > 0.0) && (BET_i > 0.0)) begin
                // Flicker noise
                if (MULT_FN > 0.0) begin
                    N1           =  Cox_over_q * alpha_dc * phit;
                    Nm1          =  Cox_over_q * qim1_dc;
                    Delta_N1     =  Cox_over_q * alpha_dc * dps_dc;
                    S_fl         =  (NFA_i - NFB_i * N1 + NFC_i * (N1 * N1)) * ln((Nm1 + 0.5 * Delta_N1) / (Nm1 - 0.5 * Delta_N1));
                    S_fl         =  S_fl + (NFB_i + NFC_i * (Nm1 - 2.0 * N1)) * Delta_N1;
                    S_fl         =  Sfl_prefac * I_ds * Gvsatinv_dc * S_fl / N1;
                    S_fl         = `CLIP_LOW(S_fl, 0.0);
                end

                //  Thermal channel noise
                if (MULT_I > 0.0) begin
                    H0           =  qim1_dc / alpha_dc;
                    t1           =  qim_dc / qim1_dc;
                    sqt2         =  0.5 * `oneSixth * (dps_dc / H0);
                    t2           =  sqt2 * sqt2;
                    r            =  H0 / H_dc - 1.0;
                    lc           = `CLIP_LOW(1.0 - 12.0 * (r * t2), 1.0e-20);
                    lcinv2       =  1.0 / (lc * lc);
                    g_ideal      =  BET_i * qim1_dc * Gvsatinv_dc;
                    mid          =  t1 + 12.0 * t2 - 24.0 * ((1.0 + t1) * t2 * r);
                    mid          = `CLIP_LOW(mid, 1.0e-40);
                    mid          =  g_ideal * lcinv2 * mid;
                    if (FNTEXC_i > 0.0) begin
                        //  Recalculate Gvsat, excluding GdL-effect
                        thesat1_exc  =  thesateff_dc / Gmob_dc;
                        zsat_exc     =  thesat1_exc * thesat1_exc * dps_dc * dps_dc;
                        if (CHNL_TYPE == `PMOS) begin
                            zsat_exc     =  zsat_exc / (1.0 + thesat1_exc * dps_dc);
                        end
                        Gvsat_exc    =  0.5 * (Gmob_dc * (1.0 + sqrt(1.0 + 2.0 * zsat_exc)));
                        gfac         =  Gmob_dc / (Gvsat_exc * lc);
                        Sidexc       =  fac_exc * I_ds * Vdse_dc * gfac * gfac;
                        mid          =  mid + Sidexc / nt0;
                    end
                    sqid         =  sqrt(nt * mid);
                end
                //  Induced gate noise
                if ((SWIGN == 1) && (nt > 0.0) && (MULT_I > 0.0) && (MULT_Q > 0.0)) begin
                    mig          =  t1 / 12.0 - t2 * (t1 + 0.2 - 12.0 * t2) - 1.6 * (t2 * (t1 + 1.0 - 12.0 * t2) * r);
                    mig          = `CLIP_LOW(mig, 1.0e-40);
                    mig          =  lcinv2 / g_ideal * mig;
                    migid0       =  lcinv2 * sqt2 * (1.0 - 12.0 * t2 - (t1 + 19.2 * t2 - 12.0 * (t1 * t2)) * r);
                    CGeff        =  Gvsat_ac * Gvsat_ac * COX_qm * eta_p_ac / (Gmob_dL_ac * Gmob_dL_ac);
                    if (FNTEXC_i > 0.0) begin
                        mig          =  mig + Sidexc * (1.0 + 12.0 * t2) / (12.0 * g_ideal * g_ideal * nt0);
                        migid0       =  migid0 - Sidexc * sqt2 * (1.0 + r) / (g_ideal * nt0);
                    end
                    sqig         =  sqrt(nt / mig);
                    if (sqid <= 0) begin
                        c_igid       =  0.0;
                    end else begin
                        c_igid       =  migid0 * sqig / sqid; // = migid0 / sqrt(mig * mid);
                    end
                    c_igid       = `CLIP_BOTH(c_igid, 0.0, 1.0);
                    migid        =  c_igid * sqid / sqig;
                end
            end

            //  Noise of gate leakage currents
            shot_igcsx   =  2.0 * `QELE * abs(I_gcs);
            shot_igcdx   =  2.0 * `QELE * abs(I_gcd);
            shot_igsov   =  2.0 * `QELE * abs(Igsov);
            shot_igdov   =  2.0 * `QELE * abs(Igdov);

            //  Noise of impact ionization currents
            shot_iavl    =  2.0 * `QELE * ((mavl + 1) * abs(Iimpact));

            //  Noise of junctions (JUNCAP2)
            jnoisex_s    =  2.0 * `QELE * abs(ijun_s);
            jnoisex_d    =  2.0 * `QELE * abs(ijun_d);
            if (sigVds > 0.0) begin
                shot_igs     =  shot_igcsx + shot_igsov;
                shot_igd     =  shot_igcdx + shot_igdov;
                jnoise_s     =  jnoisex_s;
                jnoise_d     =  jnoisex_d + shot_iavl;
            end else begin
                shot_igs     =  shot_igcdx + shot_igsov;
                shot_igd     =  shot_igcsx + shot_igdov;
                jnoise_s     =  jnoisex_s + shot_iavl;
                jnoise_d     =  jnoisex_d;
            end

            //  Noise of edge transistors
            if ((SWEDGE != 0) && (BETNEDGE_i > 0.0) && (xgedge > 0.0)) begin
                // Flicker noise of edge transistor
                temp1        =  4.0 * dsqredge / Gfedge2;
                anoisedge    =  sqrt(temp1 + 1.0) / (sqrt(temp1 + 1.1) - 1.0);
                temp1        =  Cox_over_q * phit;
                N1edge       =  temp1 * anoisedge;
                Nm1edge      =  temp1 * (qmeffedge + anoisedge);
                Delta_N1edge = -temp1 * anoisedge * alphabmedge * qdseffedge;
                Sfledge      =  (NFAEDGE_i - (NFBEDGE_i - NFCEDGE_i * N1edge) * N1edge) * ln((Nm1edge + 0.5 * Delta_N1edge) / (Nm1edge - 0.5 * Delta_N1edge));
                Sfledge      =  Sfledge + (NFBEDGE_i + NFCEDGE_i * (Nm1edge - 2.0 * N1edge)) * Delta_N1edge;
                Sfledge      =  Sfl_prefac_edge * I_dsedge * Gvsatinv_dc * Sfledge / N1edge;
                Sfledge      = `CLIP_LOW(Sfledge, 0.0);

                //  Thermal channel noise of edge transistor
                H0edge       =  phit * (qmeffedge + anoisedge) / anoisedge;
                t1edge       =  phit1_dc / phit * qmeffedge / (qmeffedge + anoisedge);
                sqt2edge     = -0.5 * `oneSixth * phit * alphabmedge * qdseffedge / H0edge;
                t2edge       =  sqt2edge * sqt2edge;
                redge        =  0.0;
                temp1        =  alpha_dc * H_dc;
                if (temp1 > 1.0e-10) begin
                    redge        =  anoisedge * H0edge / temp1 - 1.0;
                end
                lcedge       = `CLIP_LOW(1.0 - 12.0 * (redge * t2edge), 1.0e-20);
                lcinv2edge   =  1.0 / (lcedge * lcedge);
                g_idealedge  =  BETEDGE_i * phit * (qmeffedge + anoisedge) * Gvsatinv_dc;
                midedge      =  t1edge + 12.0 * t2edge - 24.0 * ((1.0 + t1edge) * t2edge * redge);
                midedge      = `CLIP_LOW(midedge, 1.0e-40);
                midedge      =  g_idealedge * lcinv2edge * midedge;
                sqidedge     =  sqrt(ntedge * midedge);
            end

            //  Noise contributions
            I(NOII)      <+  white_noise((nt / mig), "igig");
            I(NOIR)      <+  V(NOIR) / mig;
            I(NOIC)      <+  ddt(CGeff * V(NOIC));
            I(gp,si)     <+ -ddt(sqrt(MULT_inst * MULT_I ) * 0.5 * CGeff * V(NOIC));
            I(gp,di)     <+ -ddt(sqrt(MULT_inst * MULT_I ) * 0.5 * CGeff * V(NOIC));
            I(di,si)     <+  sigVds * sqrt(MULT_inst * MULT_I ) * migid *  I(NOII);
            I(di,si)     <+  white_noise(MULT_inst * MULT_I * sqid * sqid * (1.0 - c_igid * c_igid), "idid");
            I(di,si)     <+  flicker_noise(sigVds * MULT_inst * MULT_FN * S_fl, EF_i, "flicker");
            I(gp,si)     <+  white_noise(MULT_inst * MULT_I * shot_igs, "igs");
            I(gp,di)     <+  white_noise(MULT_inst * MULT_I * shot_igd, "igd");
            I(bs,si)     <+  white_noise(MULT_inst * MULT_I * jnoise_s, "ibs");
            I(bd,di)     <+  white_noise(MULT_inst * MULT_I * jnoise_d, "ibd");
            I(di,si)     <+  flicker_noise(sigVds * MULT_inst * MULT_FN * Sfledge, EFEDGE_i, "flicker");
            I(di,si)     <+  white_noise(MULT_inst * MULT_I * sqidedge * sqidedge, "ididedge");

        end // noise

        //  --------------------------------------------------------------------------------------------------------------
        //  Operating point info
        //  --------------------------------------------------------------------------------------------------------------
        begin : OPinfo

            // Local variables declaration
            `OPLocVarDecl

            // Calculation of variables related to OP-output variables
            `OPVarCalc
            `OPVarCalcRacc
            `OPVarCalcAnalog
            `OPVarSDInter

            // Definition of OP-output variables
            `OPVarDef
            `ifdef SelfHeating
                `OPVarDef_she
            `endif

        end // OPinfo

    end // evaluateblock

end // analogBlock
// ---- end `include "PSP104_module.include" ----

endmodule
