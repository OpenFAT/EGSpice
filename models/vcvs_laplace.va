// VCVS through a rational transfer function: HSPICE's E ... LAPLACE in+ in-
// k0 k1 ... / d0 d1 ... [SCALE=val], V(p,n) = scale * H(s) V(cp,cn) with
// H(s) = (k0 + k1 s + ...) / (d0 + d1 s + ...), coefficients ascending.
// With LAPLACE_CURRENT defined (vccs_laplace) it is the G card: I(p,n).
// With LAPLACE_ZP defined (vcvs_pole, vccs_pole) it is the POLE card,
// gain * laplace_zp over root vectors the builder fills (see addPole).
//
// Verilog-A implementation: Omar El-Sawy, University of Waterloo.
// Based on: HSPICE E-element Laplace Transform [HSPICE User Guide:
//   Simulation and Analysis, Sources and Stimuli]; VAMS-2023 §4.5.11.4.
//
// The coefficient arrays are zero padded to order 8; VerA runs laplace_nd at
// the runtime degree (trailing zeros dropped), and a common factor of s
// cancels before the DC gain. ponytail: one direct-form section, so orders
// past 8 are refused by the builder; a biquad cascade lifts that.

`include "constants.vams"

`include "disciplines.vams"

`ifdef LAPLACE_ZP
`ifdef LAPLACE_CURRENT
module vccs_pole(p, n, cp, cn);
`else
module vcvs_pole(p, n, cp, cn);
`endif
`elsif LAPLACE_CURRENT
module vccs_laplace(p, n, cp, cn);
`else
module vcvs_laplace(p, n, cp, cn);
`endif
    inout p, n, cp, cn;
    electrical p, n, cp, cn;
    branch (p, n) br;

    parameter real gain = 1.0;               // SCALE (times M for G)
`ifdef LAPLACE_ZP
    // Up to 8 roots a side as (re, im) pairs, s = re + j im; the builder pads
    // with re = inf, whose (1 - s/re) term is exactly 1.
    parameter real zeros[0:15] = '{16{0.0}};
    parameter real poles[0:15] = '{16{0.0}};
`define LAPLACE_H laplace_zp(V(cp, cn), zeros, poles)
`else
    parameter real num[0:8] = '{9{0.0}};     // k0 .. k8
    parameter real den[0:8] = '{1.0, 0.0, 0.0, 0.0, 0.0, 0.0, 0.0, 0.0, 0.0}; // d0 .. d8
`define LAPLACE_H laplace_nd(V(cp, cn), num, den)
`endif

    analog begin
`ifdef LAPLACE_CURRENT
        I(br) <+ gain * `LAPLACE_H;
`else
        V(br) <+ gain * `LAPLACE_H;
`endif
    end
endmodule
