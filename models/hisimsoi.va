`include "constants.vams"

/***********************************************************************

 HiSIM (Hiroshima University STARC IGFET Model)
 Copyright (C) 2000-2016 Hiroshima University and STARC
 Copyright (C) 2016-2021 Hiroshima University
 HiSIM_SOI (Silicon-On-Insulator Model)
 Copyright (C) 2012-2016 Hiroshima University and STARC
 Copyright (C) 2016-2021 Hiroshima University

 MODEL NAME : HiSIM_SOI
 ( VERSION : 1  SUBVERSION : 5  REVISION : 0 )
 Model Parameter 'VERSION' : 1.50
 FILE : hisimsoi.va

 Date : 2021.10.08

 released by Hiroshima University

***********************************************************************/
//
////////////////////////////////////////////////////////////////
//
//
//Licensed under the Educational Community License, Version 2.0
//(the "License"); you may not use this file except in
//compliance with the License.
//
//You may obtain a copy of the License at:
//
//      http://opensource.org/licenses/ECL-2.0
//
//Unless required by applicable law or agreed to in writing,
//software distributed under the License is distributed on an
//"AS IS" BASIS, WITHOUT WARRANTIES OR CONDITIONS OF ANY KIND,
//either express or implied. See the License for the specific
//language governing permissions and limitations under the
//License.
//
//
//The HiSIM_SOI standard has been supported by the members of
//Silicon Integration Initiative's Compact Model Coalition. A
//link to the most recent version of this standard can be found
//at:
//
//http://www.si2.org/cmc
//
////////////////////////////////////////////////////////////////
//

`include "disciplines.vams"

// Definitions for `ifdef directives

// Disable COPPRV flag that cause issues in RF simulation.
`define DISABLE_COPPRV

// ---- begin `include "HSMSOI_macrosAndDefs.inc" ----
/***********************************************************************

 HiSIM (Hiroshima University STARC IGFET Model)
 Copyright (C) 2000-2016 Hiroshima University and STARC
 Copyright (C) 2016-2021 Hiroshima University
 HiSIM_SOI (Silicon-On-Insulator Model)
 Copyright (C) 2012-2016 Hiroshima University and STARC
 Copyright (C) 2016-2021 Hiroshima University

 MODEL NAME : HiSIM_SOI
 ( VERSION : 1  SUBVERSION : 5  REVISION : 0 )
 Model Parameter 'VERSION' : 1.50
 FILE : HSMSOI_macrosAndDefs.inc

 Date : 2021.10.08

 released by Hiroshima University

***********************************************************************/
//
////////////////////////////////////////////////////////////////
//
//
//Licensed under the Educational Community License, Version 2.0
//(the "License"); you may not use this file except in
//compliance with the License.
//
//You may obtain a copy of the License at:
//
//      http://opensource.org/licenses/ECL-2.0
//
//Unless required by applicable law or agreed to in writing,
//software distributed under the License is distributed on an
//"AS IS" BASIS, WITHOUT WARRANTIES OR CONDITIONS OF ANY KIND,
//either express or implied. See the License for the specific
//language governing permissions and limitations under the
//License.
//
//
//The HiSIM_SOI standard has been supported by the members of
//Silicon Integration Initiative's Compact Model Coalition. A
//link to the most recent version of this standard can be found
//at:
//
//http://www.si2.org/cmc
//
////////////////////////////////////////////////////////////////
//

//File-name: HSMSOI_macrosAndDefs.inc
//
// General definitions
//
//  Definitions of the ADMS Mark-up
//
//  MPRxx    model    parameter real
//  MPIxx    model    parameter integer
//  IPRxx    instance parameter real
//  IPIxx    instance parameter integer
//     ||
//     cc    closed lower bound, closed upper bound bounds
//     nb    no bounds
//     sw    switch(integer only, values  0=false  and  1=true)
//     ty    switch(integer only, values -1=p-type and +1=n-type)
//
//  IPM   instance parameter mFactor(multiplicity, implicit for LRM2.2)
//  OPP   operating point parameter, includes units and description for printing
//
`define ALIAS(alias,paramName) aliasparam alias = paramName ;
`define OPP(nam,uni,des)               (*units=uni,                   desc=des*)           real    nam ;
`define OPM(nam,uni,des)               (*units=uni, multiplicity="multiply",    desc=des*) real    nam ;
`define OPD(nam,uni,des)               (*units=uni, multiplicity="divide",      desc=des*) real    nam ;
`define MPRnb(nam,def,uni,        des) (*units=uni,                   desc=des*) parameter real    nam=def ;
`define MPRoo(nam,def,uni,lwr,upr,des) (*units=uni,                   desc=des*) parameter real    nam=def from(lwr:upr) ;
`define MPRco(nam,def,uni,lwr,upr,des) (*units=uni,                   desc=des*) parameter real    nam=def from[lwr:upr) ;
`define MPRcc(nam,def,uni,lwr,upr,des) (*units=uni,                   desc=des*) parameter real    nam=def from[lwr:upr] ;
`define MPRoc(nam,def,uni,lwr,upr,des) (*units=uni,                   desc=des*) parameter real    nam=def from(lwr:upr] ;
`define MPIcc(nam,def,uni,lwr,upr,des) (*units=uni,                   desc=des*) parameter integer nam=def from[lwr:upr] ;
`define MPInb(nam,def,uni,        des) (*units=uni,                   desc=des*) parameter integer nam=def ;
`define MPIsw(nam,def,uni,        des) (*units=uni,                   desc=des*) parameter integer nam=def from[  0:  1] ;
`define MPIty(nam,def,uni,        des) (*units=uni,                   desc=des*) parameter integer nam=def from[ -1:  1] exclude 0 ;
`define BPRnb(nam,def,uni,        des) (*units=uni, type="instance",  desc=des*) parameter real    nam=def ;
`define BPRoo(nam,def,uni,lwr,upr,des) (*units=uni, type="instance",  desc=des*) parameter real    nam=def from(lwr:upr) ;
`define BPRco(nam,def,uni,lwr,upr,des) (*units=uni, type="instance",  desc=des*) parameter real    nam=def from[lwr:upr) ;
`define BPRcc(nam,def,uni,lwr,upr,des) (*units=uni, type="instance",  desc=des*) parameter real    nam=def from[lwr:upr] ;
`define BPRoc(nam,def,uni,lwr,upr,des) (*units=uni, type="instance",  desc=des*) parameter real    nam=def from(lwr:upr] ;
`define BPInb(nam,def,uni,        des) (*units=uni, type="instance",  desc=des*) parameter integer nam=def ;
`define IPRnb(nam,def,uni,        des) (*units=uni, type="instance",  desc=des*) parameter real    nam=def ;
`define IPRoo(nam,def,uni,lwr,upr,des) (*units=uni, type="instance",  desc=des*) parameter real    nam=def from(lwr:upr) ;
`define IPRco(nam,def,uni,lwr,upr,des) (*units=uni, type="instance",  desc=des*) parameter real    nam=def from[lwr:upr) ;
`define IPRcc(nam,def,uni,lwr,upr,des) (*units=uni, type="instance",  desc=des*) parameter real    nam=def from[lwr:upr] ;
`define IPRoc(nam,def,uni,lwr,upr,des) (*units=uni, type="instance",  desc=des*) parameter real    nam=def from(lwr:upr] ;
`define IPInb(nam,def,uni,        des) (*units=uni, type="instance",  desc=des*) parameter integer nam=def ;
`ifdef insideADMS
    `define IPM                        (*units="" , type="instance",  desc="multiplicity factor"*) parameter real m=1.0 from(0.0:inf) ;
`else // notInsideADMS
    `define IPM
`endif
`define MFACTOR_USE 1.0

`define Gnqsmin       1e-12
`define Ievb_min      1e-9
`define C_RTH_MIN     0.0001
`define Kflic         1
`define Kwhite        1
`define IGNFPH        -2

// For Debugging print
//`define DEBUG
`ifdef DEBUG
    `define DEBUG_PRINT(xName, x) $strobe("%s = %g", xName, 1.0*x)
`else
    `define DEBUG_PRINT(xName, x)
`endif

`ifdef OK
    `define HiSIM_OK                  OK
    `define HiSIM_ERROR               E_PANIC
`else
    `define HiSIM_OK                  0
    `define HiSIM_ERROR               1
`endif
`define NMOS                      1                     // MOS type
`define PMOS                      -1
`ifdef CMI_NORMAL_MODE
    `define HiSIM_NORMAL_MODE    CMI_NORMAL_MODE
    `define HiSIM_REVERSE_MODE   CMI_REVERSE_MODE
`else
    `define HiSIM_NORMAL_MODE    1                  // device working mode
    `define HiSIM_REVERSE_MODE   -1
`endif
`define NULL                      0                     // others
`define HiSIM_FALSE               0
`define HiSIM_TRUE                1

`define SUBVERSION ( VERSION *  10 % 10 )
`define REVISION   ( VERSION * 100 % 10 )

//---------------------------------------------------*
//* Numerical constants. (macro)
//*-----------------*/
`ifdef  _FLOAT_H
    `define C_EPS_M                   (DBL_EPSILON)         // machine epsilon
`else
    `define C_EPS_M                   (2.2204460492503131e-16)
`endif
`define C_SQRT_2                  (1.414213562373095e+00)       // sqrt(2)
`define C_SQRT_2inv               (0.7071067811865475)          // 1/sqrt(2) 20190507
`define C_1o3                     (3.333333333333333e-01)       // 1/3
`define C_2o3                     (6.666666666666667e-01)       // 2/3
`define C_2p_1o3                  (1.259921049894873e+00)       // 2^(1/3)
`define C_Pi                      (3.141592653589793)   // Pi
`define C_Pio2                    (1.570796326794897)
`define C_m2cm                    (1.0e2)               // Unit change
`define C_m2cm_p2                 (1.0e4)
`define C_m2cm_p1o2               (1.0e1)
`define C_m2um                    (1.0e6)
`define C_cm2m                    (1.0e-2)               // Unit change
`define C_cm2m_p2                 (1.0e-4)
`define C_cm2m_p3                 (1.0e-6)
`define C_cm2m_p1o2               (1.0e-1)
//---------------------------------------------------*
//* Physical constants/properties. (macro)
//*-----------------*/
`define C_QE                      (1.6021918e-19)       // Elemental charge
`define C_KB                      (1.3806226e-23)       // Boltzmann constant
`define C_ESI                     (1.034943e-10 )        // Permittivity of Si, SiO2 and vacuum
`define C_EOX                     (3.453133e-11 )
`define C_VAC                     (8.8541878e-12)
`define C_T300                    (300e+00)             // Room temperature constants
`define C_b300                    (3.868283e+01)
`define C_Eg0                     (1.1785e0)
`define C_Vbi                     (1.0e0)               // Build-in potential
`define C_Nin0                    (1.04e+10 / `C_cm2m_p3)            // Intrinsic carrier density at 300K
//---------------------------------------------------*
//* Inline functions
//*-----------------*/
//---------------------------------------------------*
//* smoothZero: flooring to zero.
//*      y = 0.5 ( x + sqrt( x^2 + 4 delta^2 ) )
//*-----------------*/
//    *dx = 0.5 * (1.0 + x / TMF2) ;
//    *y = 0.5 * (x + TMF2) ;

`define t_fox                     (TFOX)
`define t_SOI                     (TSOI)
`define t_box                     (TBOX)
`define N_sub_SOI                 (UC_NSUBS)
`define N_sub_bulk                (MKS_NSUBB)
`define C_VGS_MAX_ERROE           (1e-11)
`define C_PHI_1_MINIMUM           (1e-9)
`define C_PHI_2_MINIMUM           (1e-9)
`define C_PHI_SDL0_MINIMUM        (1e-15)
`define C_PHI_S0_BULK_MIN         (2.3/beta)
`define EXP_THR                   34.0
//`define C_gidl_delta              0.5
`define C_QBRAT                   0.5
`define C_IDD_MIN                 1E-15

`define lp_s0_max    20
`define lp_sl_max    20

`define Vds_max       ( 20.0 )
`define Vgs_max       ( 20.0 )
`define dP_max        ( 0.1 )
`define ps_conv       ( 5.0e-12 )
`define PSCONVFAC     ( 1.0 )
`define znbd3         ( 3.0 )
`define znbd5         ( 5.0 )
`define cn_nc3        ( `C_SQRT_2 / 108.0 )
`define cn_nc51       ( 0.707106781186548 )  // sqrt(2)/2 */
`define cn_nc52       ( -0.117851130197758 )  // -sqrt(2)/12 */
`define cn_nc53       ( 0.0178800506338833 )  // (187 - 112*sqrt(2))/1600 */
`define cn_nc54       ( -0.00163730162779191 )  // (-131 + 88*sqrt(2))/4000 */
`define cn_nc55       ( 6.36964918866352e-5 )  //(1509-1040*sqrt(2))/600000 */
`define cn_ac1        ( 0.7071067811865475244008 )
`define cn_ac2        ( -0.1178511301977579207335 )
`define cn_ac3        ( 0.1966881562799040361016e-1 )
`define cn_ac4        ( -0.2539763438742807392019e-2 )
`define cn_ac5        ( 0.3485999509229981384212e-3 )
`define c_ps0ini_2    ( 8.0e-4 )
`define c_pslini_1    ( 0.3 )
`define c_pslini_2    ( 3.0e-2 )
`define VgVt_Small    ( 1.0e-12 )
`define epsm10        ( 10.0 * `C_EPS_M )
`define Small         ( 1.0e-50 )
`define Small2        ( 1.0e-12 )    //for Qover */
`define cclmmdf       ( 1.0e-1 )
`define qme_dlt       ( 1.0e-4 )
`define eef_dlt       ( 1.0e-2 )
`define sti2_dlt      ( 2.0e-3 )
`define psisti_dlt    ( 5.0e-3 )
`define c_exp_2       ( 7.38905609893065 )     // exp(2)
`define c_expm3       ( 0.049787068367863944 ) // exp(-3)
`define c_sqrt_15     ( 3.872983346207417e0 )  // sqrt(15) */
`define C_fox_Small   ( 1.0e-6 )
`define c_16o135      ( 1.185185185185185e-1 )  // 16/135 */
`define igate_dlt     ( 1.0e-2 )
`define vth_dlt       ( 1.0e-3 )
`define qme2_dlt      ( 5.0e-2 )
`define pol_dlt       ( 5.0e-2 )
`define pol_b         ( 1.0 )
`define dQdrat        ( 1.0e-8 )
`define cn_im53       ( 2.9693154855770998e-1 )
`define cn_im54       ( -7.0536542840097616e-2 )
`define cn_im55       ( 6.1152888951331797e-3 )
`define large_arg     ( 80 )    // Old value = ( ln(1.0e100) )
`define delta_Vdseff  ( `epsm10 )
`define gs_conv       ( 1.0e-8 )
`define cnst_2esi_q   ( 2 * `C_ESI / `C_QE )
`define N             ( 100 )
`define r             (  i /  `N )
`define X_vbs         ( xvbs )
`define X_sub1        ( xsub1 )
`define X_sub2        ( xsub2 )
`define X_vgs         ( UC_SVGS )
`define Z_vgs         ( zvgs )
`define X_vds         ( SVDS )
`define X_slg         ( xgate )
`define Nd            ( 1e20 / `C_cm2m_p3)
`define Dn            ( 36.0 )
`define Dp            ( 13.0 )
`define Ln            ( sqrt(`Dn * 1e-7 / `C_cm2m_p2) )
`define Lp            ( sqrt(`Dp * 1e-7 / `C_cm2m_p2) )
`define Vds_mod_max   ( 0.5 )
`define W_diod        ( weff_nf + (NF * UC_PDBCP) )
`define W_dios        ( weff_nf + (NF * UC_PSBCP) )

`define tau_min       ( 1e-15 / `C_cm2m_p2)
`define NQS_CAP       ( 1e-9 / `C_cm2m_p2)

`define EXP_THRES     (80)
`define MAX_EXP       (5.540622384e+34)

`define Vbs_bnd 0.8
`define Vbs_max 1.2

//End of File: HSMSOI_macrosAndDefs.inc

//===========================================================*
//* pow
//*=================*/
`ifdef  POW_TO_EXP_AND_LOG
    `define Fn_Pow( x , y )  exp( y * ln( x )  )
`else
    `define Fn_Pow( x , y )  pow( x , y )
`endif
//===========================================================*
//* Exp() for PGD.
//* - ExpLim(-3)=0
//*=================*/
`define Fn_ExpLim( y , x ) begin \
    if ((x) < -3.0 ) begin \
        y = 0.0 ; \
    end else if ((x) < 0.0 ) begin \
        y = 1.0 + (x) * ( 1.0 + (x) * ( (1.0/3.0) + (x) * (1.0/27.0) ) ) ; \
    end else begin \
        y = 1.0 + (x) * ( 1.0 + (x) * ( (1.0/3.0) + (x) * ( 0.0402052934513951 \
              + (x) * 0.148148111111111 ) ) ) ; \
    end \
end
//===========================================================*
//* Macro Functions for ceiling/flooring/symmetrization.
//*=================*/
//---------------------------------------------------*
//* smoothUpper: ceiling.
//*      y = xmax - 0.5 ( arg + sqrt( arg^2 + 4 xmax delta ) )
//*    arg = xmax - x - delta
//*-----------------*/
`define Fn_SU_DX( y , x , xmax , delta , dx ) begin \
    TMF1 = ( xmax ) - ( x ) - ( delta ) ; \
    TMF2 = 4.0 * ( xmax ) * ( delta) ; \
    TMF2 = TMF2 > 0.0 ?  TMF2 : - ( TMF2 ) ; \
    TMF2 = sqrt ( TMF1 * TMF1 + TMF2 ) ; \
    dx = 0.5 * ( 1.0 + TMF1 / TMF2 ) ; \
    y = ( xmax ) - 0.5 * ( TMF1 + TMF2 ) ; \
end
`define Fn_SU2( y , x , xmax , delta , dy_dx , dy_dxmax ) begin \
    TMF1 = ( xmax ) - ( x ) - ( delta ) ; \
    TMF2 = 4.0 * ( xmax ) * ( delta) ; \
    TMF2 = TMF2 > 0.0 ?  TMF2 : - ( TMF2 ) ; \
    TMF2 = sqrt ( TMF1 * TMF1 + TMF2 ) ; \
    dy_dx = 0.5 * ( 1.0 + TMF1 / TMF2 ) ; \
    dy_dxmax = 0.5 * ( 1.0 - ( TMF1 + 2.0 * delta ) / TMF2 ) ; \
    y = ( xmax ) - 0.5 * ( TMF1 + TMF2 ) ; \
end
//---------------------------------------------------*
//* smoothLower: flooring.
//*      y = xmin + 0.5 ( arg + sqrt( arg^2 + 4 xmin delta ) )
//*    arg = x - xmin - delta
//*-----------------*/
`define Fn_SL( y , x , xmin , delta , dx ) begin \
    TMF1 = ( x ) - ( xmin ) - ( delta ) ; \
    TMF2 = 4.0 * ( xmin ) * ( delta ) ; \
    TMF2 = TMF2 > 0.0 ?  TMF2 : - ( TMF2 ) ; \
    TMF2 = sqrt ( TMF1 * TMF1 + TMF2 ) ; \
    dx = 0.5 * ( 1.0 + TMF1 / TMF2 ) ; \
    y = ( xmin ) + 0.5 * ( TMF1 + TMF2 ) ; \
end
`define Fn_SL2( y , x , xmin , delta , dy_dx, dy_dxmin ) begin \
    TMF1 = ( x ) - ( xmin ) - ( delta ) ; \
    TMF2 = 4.0 * ( xmin ) * ( delta ) ; \
    TMF2 = TMF2 > 0.0 ?  TMF2 : - ( TMF2 ) ; \
    TMF2 = sqrt ( TMF1 * TMF1 + TMF2 ) ; \
    dy_dx = 0.5 * ( 1.0 + TMF1 / TMF2 ) ; \
    dy_dxmin = 0.5 * ( 1.0 - ( TMF1 - 2.0 * delta ) / TMF2 ) ; \
    y = ( xmin ) + 0.5 * ( TMF1 + TMF2 ) ; \
end
//* smoothZero: flooring to zero.
//*      y = 0.5 ( x + sqrt( x^2 + 4 delta^2 ) )
//*-----------------*/
`define Fn_SZ_DX( y , x , delta , dx ) begin \
    TMF2 = sqrt ( ( x ) *  ( x ) + 4.0 * ( delta ) * ( delta) ) ; \
    dx = 0.5 * ( 1.0 + ( x ) / TMF2 ) ; \
    y = 0.5 * ( ( x ) + TMF2 ) + 1e-10 * delta ; \
    if ( y < 0.0 ) begin \
        y=0.0; \
        dx=0.0; \
    end \
end
//---------------------------------------------------*
//* CeilingPow: ceiling for positive x, flooring for negative x.
//*      y = x * xmax / ( x^{2m} + xmax^{2m} )^{1/(2m)}
//* note:
//*   - xmax has to be positive.
//*   - -xmax < y < xmax.
//*   - dy/dx|_beginx=0end = 1.
//*-----------------*/
`define Fn_CP( y , x , xmax , pw ) begin \
    x2 = (x) * (x) ; \
    xmax2 = (xmax) * (xmax) ; \
    xp = 1.0  ;\
    xmp = 1.0 ; \
    m0 = 0 ;\
    mm =0 ; \
    arg = 0.0 ;\
    dnm =0.0 ; \
    for ( m0 = 0 ; m0 < pw ; m0 = m0 + 1 ) begin \
        xp = xp * x2 ; \
        xmp = xmp * xmax2 ; \
    end \
    arg = xp + xmp ; \
    dnm = arg ; \
    if ( pw == 1 || pw == 2 || pw == 4 || pw == 8 ) begin \
        if ( pw == 1 ) begin \
            mm = 1 ; \
        end else if ( pw == 2 ) begin \
            mm = 2 ; \
        end else if ( pw == 4 ) begin \
            mm = 3 ; \
        end else if ( pw == 8 ) begin \
            mm = 4 ; \
        end \
        for ( m0 = 0 ; m0 < mm ; m0 = m0 + 1 ) begin \
            dnm = sqrt( dnm ) ; \
        end \
    end else begin \
        dnm = `Fn_Pow( dnm , 1.0 / ( 2.0 * pw ) ) ; \
    end \
    dnm = 1.0 / dnm ; \
    y = (x) * (xmax) * dnm ; \
end

`define Fn_CP_DX( y , x , xmax , pw , dx ) begin \
    x2 = (x) * (x) ; \
    xmax2 = (xmax) * (xmax) ; \
    xp = 1.0  ;\
    xmp = 1.0 ; \
    m0 = 0 ;\
    mm =0 ; \
    arg = 0.0 ;\
    dnm =0.0 ; \
    for ( m0 = 0 ; m0 < pw ; m0 = m0 + 1 ) begin \
        xp = xp * x2 ; \
        xmp = xmp * xmax2 ; \
    end \
    arg = xp + xmp ; \
    dnm = arg ; \
    if ( pw == 1 || pw == 2 || pw == 4 || pw == 8 ) begin \
        if ( pw == 1 ) begin \
            mm = 1 ; \
        end else if ( pw == 2 ) begin \
            mm = 2 ; \
        end else if ( pw == 4 ) begin \
            mm = 3 ; \
        end else if ( pw == 8 ) begin \
            mm = 4 ; \
        end \
        for ( m0 = 0 ; m0 < mm ; m0 = m0 + 1 ) begin \
            dnm = sqrt( dnm ) ; \
        end \
    end else begin \
        dnm = `Fn_Pow( dnm , 1.0 / ( 2.0 * pw ) ) ; \
    end \
    dnm = 1.0 / dnm ; \
    y = (x) * (xmax) * dnm ; \
    dx = (xmax) * xmp * dnm / arg ; \
end

`define Fn_SU_CP( y , x , xmax , delta , pw ) begin \
    if (x > (xmax) - (delta) && (delta) >= 0.0) begin \
        TMF1 = (x) - (xmax) + (delta) ; \
        `Fn_CP( TMF0 , TMF1 , (delta) , (pw) )  \
        y = (xmax) - (delta) + TMF0 ; \
    end else begin \
        y = x ; \
    end \
end

`define Fn_SU_CP_DX( y , x , xmax , delta , pw , dx ) begin \
    if (x > (xmax) - (delta) && (delta) >= 0.0) begin \
        TMF1 = (x) - (xmax) + (delta) ; \
        `Fn_CP_DX( TMF0 , TMF1 , (delta) , (pw) , dx )  \
        y = (xmax) - (delta) + TMF0 ; \
        dx = dx ; \
    end else begin \
        y = x ; \
        dx = 1.0 ; \
    end \
end

`define Fn_SL_CP( y , x , xmin , delta , pw ) begin \
    if ( (x) < (xmin) + (delta) && (delta) >= 0.0) begin \
        TMF1 = (xmin) +(delta) - (x) ; \
        `Fn_CP( TMF0 , TMF1 , (delta) , (pw) )  \
        y = (xmin) + (delta) - TMF0 ; \
    end else begin \
        y = x ; \
    end \
end

`define Fn_SL_CP_DX( y , x , xmin , delta , pw , dx ) begin \
    if ( (x) < (xmin) + (delta) && (delta) >= 0.0) begin \
        TMF1 = (xmin) +(delta) - (x) ; \
        `Fn_CP_DX( TMF0 , TMF1 , (delta) , (pw) , dx )  \
        y = (xmin) + (delta) - TMF0 ; \
        dx = dx ; \
    end else begin \
        y = x ; \
        dx = 1.0 ; \
    end \
end

//---------------------------------------------------*
//* "smoothUpper" using a polynomial
//*-----------------*/
//`Fn_DclPoly4( y , TMF1 , dx ) ;
`define Fn_SUPoly4( y , x , xmax , dx ) begin \
    TMF1 = (x) / xmax ; \
    TMF2 = TMF1 * TMF1 ; \
    TMF3 = TMF2 * TMF1 ; \
    TMF4 = TMF2 * TMF2 ; \
    y = 1.0 / ( 1.0 + (TMF1) + TMF2 + TMF3 + TMF4 ) ; \
    dx = - ( 1.0 + 2.0 * (TMF1) + 3.0 * TMF2 + 4.0 * TMF3 )  * y * y  ; \
    y = xmax * ( 1.0 - y ) ; \
    dx = - dx ; \
end
//---------------------------------------------------*
//* SymAdd: evaluate additional term for symmetry.
//*-----------------*/
`define Fn_SymAdd( y , x , add0 ) begin \
    TMF1 = 2.0 * ( x ) / ( add0 ) ; \
    TMF2 = 1.0 + TMF1 * ( (1.0/2) + TMF1 * ( (1.0/6) \
             + TMF1 * ( (1.0/24) + TMF1 * ( (1.0/120) \
             + TMF1 * ( (1.0/720) + TMF1 * (1.0/5040) ) ) ) ) ) ; \
    y = add0 / TMF2 ; \
end

`define Fn_Sqr(x)   ( (x)*(x) ) // x^2 */
`define Fn_Max(x,y) ( (x) >= (y) ? (x) : (y) ) // max[x,y] */
`define Fn_Min(x,y) ( (x) <= (y) ? (x) : (y) ) // min[x,y] */
`define Fn_Sgn(x)   ( (x) >= 0  ?  (1) : (-1) )    // sign[x] */

//===========================================================*
//* Exp() for large input value.
//*=================*/
`define D_EXP_THRESHOLD (500.0)                //exp(710)=inf
`define D_MAX_EXP       (1.403592217853e+217)  //exp(500.0)
`define C_UNIT_EXP_ARG  (60.0)                 //exp(60.0) may touch the Verilog-A limit
`define C_UNIT_EXP_RES  (1.14200738981568e+26) //exp(60.0)
`define Fn_DExp( y , x , dx) begin \
    if ((x) >= `D_EXP_THRESHOLD) begin \
        y  = `D_MAX_EXP * (1 + (x) - `D_EXP_THRESHOLD); \
        dx = `D_MAX_EXP ; \
    end else begin \
        TMF1 = (x); \
        y = 1.0; \
        while (TMF1 >= `C_UNIT_EXP_ARG ) begin \
            y = y * `C_UNIT_EXP_RES; \
            TMF1 = TMF1 - `C_UNIT_EXP_ARG; \
        end \
        y = y * exp(TMF1); \
        dx = y; \
    end \
end

// End of src/lib/dev/hisimsoi/hsmsoieval.c for definition

// Begin: src/lib/dev/hisimsoi/hsmsoitemp.c for definition
`define BINNING(UC_PARAM, PARAM, LPARAM, WPARAM, PPARAM) UC_PARAM = PARAM \
    + LPARAM / Lbin + WPARAM / Wbin \
    + PPARAM / LWbin ;
`define RANGECHECK(param, min, max, pname) begin \
    if ((param) <(min) ||(param) >(max) ) begin \
        $write("warning(HiSIM_SOI): (%M) The model/instance parameter %s (= %e) must be in the range [%e , %e].\n", \
           pname, (param), (min), (max) ) ; \
    end \
end
`define RANGERESET(param, min, max, pname)              \
    if ( ((param) >(max)) ) begin   \
        $write("reset(HiSIM_SOI(%m)): (%s = %g to %g) range [%g , %g].\n", \
           pname, (param), (max*1.0), (min*1.0), (max*1.0) );     \
    end \
    if ( ((param) <(min)) ) begin   \
        $write("reset(HiSIM_SOI(%m)): (%s = %g to %g) range [%g , %g].\n", \
           pname, (param), (min*1.0), (min*1.0), (max*1.0) );     \
    end \
    if ((param) <(min) ) begin  \
        param  =(min); \
    end    \
    if ((param) >(max) ) begin  \
        param  =(max); \
    end
`define MINCHECK(param, min, pname) \
    if ((param) <(min) ) begin \
        $write("warning(HiSIM_SOI): (%M) The model/instance parameter %s (= %e) must be greater than %e.\n", \
           pname, (param), (min) ) ;                     \
    end
`define PMINCHECK(param, min, mesg) \
    if ( (param) <(min) ) begin \
        $write(" *** Fatal(HiSIM_SOI): (%M) %s\n",mesg ); \
        FATAL_flag = 1; \
    end

//---------------------------------------------------*
//* smoothZero: flooring to zero.
//*      y = 0.5 ( x + sqrt( x^2 + 4 delta^2 ) )
//*-----------------*/
`define Fn_SZtemp( y , x , delta ) begin \
    TMF1 = sqrt ( ( x ) *  ( x ) + 4.0 * ( delta ) * ( delta) ) ; \
    y = 0.5 * ( ( x ) + TMF1 ) + 1e-10 * delta ; \
    if ( y < 0.0 ) begin \
        y=0.0; \
    end \
end
`define Fn_SUtemp( y , x , xmax , delta ) begin \
    TMF1 = ( xmax ) - ( x ) - ( delta ) ; \
    TMF2 = 4.0 * ( xmax ) * ( delta) ; \
    TMF2 = TMF2 > 0.0 ?  TMF2 : - ( TMF2 ) ; \
    TMF2 = sqrt ( TMF1 * TMF1 + TMF2 ) ; \
    y = ( xmax ) - 0.5 * ( TMF1 + TMF2 ) ; \
end
`define Fn_SLtemp( y , x , xmin , delta ) begin \
    TMF1 = ( x ) - ( xmin ) - ( delta ) ; \
    TMF2 = 4.0 * ( xmin ) * ( delta ) ; \
    TMF2 = TMF2 > 0.0 ?  TMF2 : - ( TMF2 ) ; \
    TMF2 = sqrt ( TMF1 * TMF1 + TMF2 ) ; \
    y = ( xmin ) + 0.5 * ( TMF1 + TMF2 ) ; \
end

// End of src/lib/dev/hisimsoi/hsmsoitemp.c for definition
// ---- end `include "HSMSOI_macrosAndDefs.inc" ----

//Start of HiSIM_SOI model code

// Module Definition
//`define _4_PORTS_CONNECTED_
`ifdef  _4_PORTS_CONNECTED_
module hisimsoi_va(d, g, s, e) ;
    inout      d, g, s, e ;
`else
//`define _5_PORTS_CONNECTED_
`ifdef  _5_PORTS_CONNECTED_
module hisimsoi_va(d, g, s, e, bc) ;
    inout      d, g, s, e, bc ;
`else
module hisimsoi_va(d, g, s, e, bc, n6) ;
    inout      d, g, s, e, bc, n6 ;
`endif
`endif
    electrical d, g, s, e, bc, n6 ;        // External Nodes
    electrical dp, sp ;                    // D/S Internal Nodes
    electrical db, sb ;                    // body resistance network (partial; see bp below)
    electrical temp, gp, bp,  nqs_qb, n ;  // Common Internal Nodes
    electrical nqs_qd, nqs_qs, nqs_qhs ;   // for fb
    electrical nqs_qi ;                    // for bt
    //

// ---- begin `include "HSMSOI_TOP_module.inc" ----
/***********************************************************************

 HiSIM (Hiroshima University STARC IGFET Model)
 Copyright (C) 2000-2016 Hiroshima University and STARC
 Copyright (C) 2016-2021 Hiroshima University
 HiSIM_SOI (Silicon-On-Insulator Model)
 Copyright (C) 2012-2016 Hiroshima University and STARC
 Copyright (C) 2016-2021 Hiroshima University

 MODEL NAME : HiSIM_SOI
 ( VERSION : 1  SUBVERSION : 5  REVISION : 0 )
 Model Parameter 'VERSION' : 1.50
 FILE : HSMSOI_TOP_module.inc

 Date : 2021.10.08

 released by Hiroshima University

***********************************************************************/
//
////////////////////////////////////////////////////////////////
//
//
//Licensed under the Educational Community License, Version 2.0
//(the "License"); you may not use this file except in
//compliance with the License.
//
//You may obtain a copy of the License at:
//
//      http://opensource.org/licenses/ECL-2.0
//
//Unless required by applicable law or agreed to in writing,
//software distributed under the License is distributed on an
//"AS IS" BASIS, WITHOUT WARRANTIES OR CONDITIONS OF ANY KIND,
//either express or implied. See the License for the specific
//language governing permissions and limitations under the
//License.
//
//
//The HiSIM_SOI standard has been supported by the members of
//Silicon Integration Initiative's Compact Model Coalition. A
//link to the most recent version of this standard can be found
//at:
//
//http://www.si2.org/cmc
//
////////////////////////////////////////////////////////////////
//

// Branch Definitions

branch(bc,bp) BRbcbp ;

branch(dp,sp) BRdpsp ;
branch(sp,dp) BRspdp ;
branch(dp,bp) BRdpbp ;
branch(sp,bp) BRspbp ;
branch(gp,sp) BRgpsp ;
branch(gp,dp) BRgpdp ;

branch(d ,dp) BRddp  ;
branch(sp,s ) BRsps  ;
branch(bp,sp) BRbpsp ;
branch(bp,dp) BRbpdp ;

branch(g ,gp) BRggp  ;
branch(gp,s ) BRgps  ;
branch(gp,d ) BRgpd  ;
branch(gp,bp) BRgpbp ;
branch(d ,s ) BRds   ;
branch(s ,d ) BRsd   ;
branch(d ,g ) BRdg   ;
branch(g ,d ) BRgd   ;
branch(s ,g ) BRsg   ;
branch(g ,s ) BRgs   ;
branch(bp,d ) BRbpd  ;
branch(d ,bp) BRdbp  ;
branch(bp,s ) BRbps  ;
branch(s ,bp) BRsbp  ;
branch(bp,g ) BRbpg  ;
branch(g ,bp) BRgbp  ;
branch(e ,bp) BRebp  ;

branch(sb,bp) BRsbbp ; // body resistance network
branch(sb,bc) BRsbbc ; // body resistance network
branch(db,bp) BRdbbp ; // body resistance network
branch(db,bc) BRdbbc ; // body resistance network
branch(sb,sp) BRsbsp ; // junction diode (source)
branch(db,dp) BRdbdp ; // junction diode (drain)

//
// Parameter definitions
//******* Device Parameters *******//
`IPRoo( L         , 5.0E-6    , "m"            , 0, inf , "Gate length (Lgate)" )
`IPRoo( W         , 5.0E-6    , "m"            , 0, inf , "Gate width (Wgate)" )
`IPRco( AD        , 0.0       , "m^2"          , 0, inf , "Area of drain junction" )
`IPRco( AS        , 0.0       , "m^2"          , 0, inf , "Area of source junction" )
`IPRco( PD        , 0.0       , "m"            , 0, inf , "Perimeter of drain junction" )
`IPRco( PS        , 0.0       , "m"            , 0, inf , "Perimeter of source junction" )
`IPRoo( NGCON     , 1.0       , "-"            , 0, inf , "Number of gate contacts" )
`IPRco( XGW       , 0E0       , "m"            , 0, inf , "Distance from gate contact to channel edge" )
`IPRco( XGL       , 0E0       , "m"            , 0, L   , "Offset of gate length" )
`IPM
`IPRoo( NF        , 1.0       , "-",             0, inf , "Number of gate fingers" )
`IPRco( SA        , 0         , "m",             0, inf , "Length of diffusion between gate and STI" )
`IPRco( SB        , 0         , "m",             0, inf , "Length of diffusion between gate and STI" )
`IPRco( SD        , 0         , "m",             0, inf , "Length of diffusion between gate and gate" )
`IPRco( PDBCP     , 0.0       , "m",             0, inf , "Parasitic perimeter length for body contact at drain" )
`IPRco( PSBCP     , 0.0       , "m",             0, inf , "Parasitic perimeter length for body contact at source" )
`IPRco( LOD       , 10.0E-6   , "m",             0, inf , "diffusion length between gate and STI edge" )
`IPRoo( TEMP      , 0.0       , "C",       -273.15, inf , "Device temperature" )
`IPRnb( DTEMP     , 0         , "C"                     , "Device temperature change" )
`IPRnb( NBT       , 1.0       , "-"                     , "Number of body contact" )
`IPRco( LBT       , 0.0       , "m"            , 0, inf , "Length of gate over body-contact well" )
`IPRco( WBTP      , 0.0       , "m"            , 0, inf , "Distance of gate protrusion over body-contact well" )
`IPRco( WBTN      , 0.0       , "m"            , 0, inf , "Distance of gate protrusion over body-contact well" )
`IPRco( ABTN      , 0.0       , "m^2"          , 0, inf , "Area of N^+ poly area of body contact" )
`IPRco( ABTP      , 0.0       , "m^2"          , 0, inf , "Area of P^+ poly area of body contact" )

//******* Model Flags *******//
`MPIsw( COADOV    , 1         , ""                      , "Lateral field induced and overlap capacitances are added to intrinsic" )
`MPIsw( COISUB    , 0         , ""                      , "Substrate current flag" )
`MPIcc( COFBE     , 0         , ""                , 0, 2, "Floating-Body Effect flag" )
`MPIsw( COIIGS    , 0         , ""                      , "Gate current flag" )
`MPIsw( COGIDL    , 0         , ""                      , "GIDL current flag" )
`MPIsw( COOVLP    , 0         , ""                      , "Overlap capacitance model selector" )
`MPIsw( COIGN     , 0         , ""                      , "Induced gate and cross correlation noise flag" )
`MPIsw( COFLICK   , 0         , ""                      , "1/f noise flag" )
`MPIsw( COTHRML   , 0         , ""                      , "Thermal noise flag" )
`MPIsw( COISTI    , 0         , ""                      , "STI leakage current flag" )
`MPIsw( CONQS     , 0         , ""                      , "Non-quasi-static model flag" )
`MPIsw( CORG      , 0         , ""                      , "Gate-contact resistance flag" )
`MPIsw( COIEVB    , 0         , ""                      , "Valence-band-electron-tunneling-current model flag" )
`MPIsw( COHIST    , 0         , ""                      , "History Effect flag" )
`MPIsw( COSELFHEAT, 0         , ""                      , "Self-Heating flag" )
`MPIsw( COVBSBIZ  , 0         , ""                      , "Symmetry treatment flag" )
`MPIsw( COLGLEFF  , 0         , ""                      , "Lgate to Leff flag" )
`MPIcc( COQOVSM   , 1         , ""                , 0, 2, "Qover capacitance model selector" )
`MPIcc( COQBDSM   , 1         , ""                , 0, 2, "Gate/body contact well MOS-capacitance model selector" )
`MPRnb( COBCNODE  , 0         , ""                      , "Body contact node flag" )
`MPIsw( COSUBSCALE, 0         , ""                      , "Switch scaling for Isub" )
`MPIsw( COISUBFB  , 0         , ""                      , "Switch Isub in FB mode: 0 with analytical Ids; 1 with iterative Ids" )
`MPInb( INFO      , 0         , ""                      , "print information selector" )
`MPRnb( QHSMAX    , 1e-3      , ""                      , "upper limit Qhs " )
`MPRnb( DVGPSUB   , 0         , ""                      , "delta VGPSUB (in addition to VFBSUB) " )
`MPRnb( DVBSSUB   , 0         , ""                      , "delta VBSSUB for Qh effect " )

//******* Technology Model Parameters *******//
`MPIty( TYPE      , 1         , "-"                     , "1 for nMOS and -1 for pMOS" )
`MPRnb( VERSION   , 1.50      , "-"                     , "model version selector" )
`MPRoo( VMAX      , 7.00E+6   , "cm*s^-1"      , 0, inf , "saturation velocity" )
`MPRnb( BGTMP1    , 90.25E-6  , "eV*K^-1"               , "temperature dependence of bandgap" )
`MPRnb( BGTMP2    , 100.0E-9  , "eV*K^-2"               , "temperature dependence of bandgap" )
`MPRoo( EG0       , 1.1785    , "eV"           , 0, inf , "bandgap" )
`MPRnb( XLD       , 0.0       , "m"                     , "gate overlap length" )
`MPRnb( XLDC      , XLD       , "m"                     , "XLD for capacitance" )
`MPRnb( VFBOVER   , 0.0       , "V"                     , "flat-band voltage in overlap region" )
`MPRco( NOVER     , 1E19      , "cm^-3"        , 0, inf , "impurity concentration in overlap region" )
`MPRnb( XWD       , 0.0       , "m"                     , "gate overlap width" )
`MPRnb( XWDC      , XWD       , "m"                     , "XWD for cap" )
`MPRco( SAREF     , 1E-6      , "m"            , 0, inf , "Reference distance from STI edge to Gate edge" )
`MPRco( SBREF     , 1E-6      , "m"            , 0, inf , "Reference distance from STI edge to Gate edge" )
`MPRco( XQY       , 0.0       , "m"            , 0, inf , "distance from junction to max field point" )
`MPRnb( XQY1      , 0.0       , "F*um^XQY2-1"           , "Vbs-dependence of Qy" )
`MPRnb( XQY2      , 2.0       , "-"                     , "Lgate-dependence of Qy" )
`MPRcc( RSHG      , 0.0       , "Ohm/square"   , 0, 100 , "gate sheet resistance" )
`MPRnb( VFBC      , -1.0      , "V"                     , "flat-band voltage" )
`MPRnb( VBI       , 1.1       , "V"                     , "built-in potential" )
// `MPRnb( NSUBPL    , 0.001     , "m^-1"                  , "modification of pocket-impurity concentration" )
// `MPRnb( NSUBPFAC  , 1         , "-"                     , "modification of pocket-impurity concentration" )
`MPRnb( PARL1     , 10.0E-9   , "cm"                    , "SOI SCE parameter" )
`MPRnb( PARL2     , 10.0E-9   , "m"                     , "depletion width of channel/contact junction" )
`MPRnb( LP        , 0.0       , "m"                     , "pocket penetration length" )
`MPRoo( NSUBP     , 1.0E+17   , "cm^-3"        , 0, inf , "max pocket concentration" )
`MPRnb( NSUBP0    , 0.0       , "-"                     , "modification of pocket concentration for narrow W" )
`MPRnb( NSUBWP    , 1.0       , "-"                     , "modification of pocket concentration for narrow W" )
`MPRnb( WL1       , 0.0       , "m"                     , "small-size effect parameter for STI leakage" )
`MPRnb( WL1P      , 1.0       , "-"                     , "small-size effect parameter for STI leakage" )
`MPRnb( WL2       , 0.0       , "-"                     , "threshold voltage shift due to small-size effect" )
`MPRnb( WL2P      , 1.0       , "-"                     , "threshold voltage shift due to small-size effect" )
`MPRnb( SCP1      , 0.0       , "-"                     , "magnitude of short-channel effect due to pocket" )
`MPRnb( SCP2      , 0.0       , "V^-1"                  , "Vds-dependence of SCE due to pocket" )
`MPRnb( SCP3      , 0.0       , "m*V^-1"                , "Vds-dependence of SCE due to pocket" )
`MPRnb( SC1       , 0.0       , "-"                     , "magnitude of short-channel effect" )
`MPRnb( SC2       , 0.0       , "V^-1"                  , "Vds-dependence of short-channel effect" )
`MPRnb( SC3       , 0.0       , "m*V^-1"                , "Vbs dependence of short-channel effect" )
`MPRnb( SCR1      , 0.0       , "-"                     , "parameter for SCE via BOX" )
`MPRnb( SCR2      , 0.0       , "-"                     , "parameter for SCE via BOX" )
`MPRnb( SCR3      , 0.23      , "-"                     , "parameter for SCE via BOX" )
`MPRnb( PGD1      , 0.0       , "V"                     , "strength of poly-depletion effect" )
`MPRnb( PGD2      , 1.0       , "V"                     , "threshold voltage of poly-depletion effect" )
`MPRnb( PGD4      , 0.0       , "-"                     , "Lgate-dependence of poly-depletion effect" )
`MPRnb( NDEP      , 1.0       , "-"                     , "depletion charge contribution to Eeff" )
`MPRnb( NINV      , 0.5       , "-"                     , "inversion charge contribution to Eeff" )
`MPRnb( NINVD     , 0.0       , "V^-1"                  , "inversion charge parameter" )
`MPRnb( MUECB0    , 300.0     , "cm^2V^-1s^-1"          , "Coulomb scattering" )
`MPRnb( MUECB1    , 30.0      , "cm^2V^-1s^-1"          , "Coulomb scattering" )
`MPRnb( MUEPH0    , 300.0E-3  , "-"                     , "phonon scattering" )
`MPRnb( MUEPHW    , 0.0       , "-"                     , "phonon-related mobility reduction" )
`MPRnb( MUEPWP    , 1.0       , "-"                     , "phonon-related mobility reduction" )
`MPRnb( MUEPHL    , 0.0       , "-"                     , "L-dependence of phonon mobility reduction" )
`MPRnb( MUEPLP    , 1.0       , "-"                     , "L-dependence of phonon mobility reduction" )
`MPRnb( MUEPHS    , 0.0       , "-"                     , "mobility change due to small size" )
`MPRnb( MUEPSP    , 1.0       , "-"                     , "mobility change due to small size" )
`MPRnb( VTMP      , 0.0       , "cm*s^-1"               , "temperature-dependence of saturation velocity" )
`MPRnb( WVTH0     , 0.0       , "Vum"                   , "threshold voltage shift" )
`MPRoo( MUESR1    , 2.0E15    , "cm^2V^-1s^-1" , 0, inf , "surface-roughness scattering" )
`MPRnb( MUESR0    , 2.0       , "-"                     , "surface-roughness scattering" )
`MPRnb( MUESRL    , 0.0       , "-"                     , "L-dependence of surface roughness on mobility" )
`MPRnb( MUESRW    , 0.0       , "-"                     , "surface roughness-related mobility change" )
`MPRnb( MUESWP    , 1.0       , "-"                     , "surface roughness-related mobility change" )
`MPRnb( MUESLP    , 1.0       , "-"                     , "L-dependence of surface roughness on mobility" )
`MPRnb( MUETMP    , 1.5       , "-"                     , "temperature-dependence of phonon scattering" )
`MPRco( BB        , ((TYPE>0)?2.0:1.0), "-"  , 0.1, inf , "high-field-mobility degradation" )
`MPRnb( DDLTMAX   , 10.0      , "-"                     , "smoothing coefficient for Vds" )
`MPRnb( DDLTSLP   , 10.0      , "um^-1"                 , "Lgate-dependence of smoothing coefficient" )
`MPRnb( DDLTICT   , 0.0       , "-"                     , "Lgate-dependence of smoothing coefficient" )
`MPRnb( SUB1      , 0.01      , "V^-1"                  , "substrate current coefficient of magnitude" )
`MPRnb( SUB2      , 20.0      , "V"                     , "substrate current coefficient of exponential term" )
`MPRnb( SUB1L     , 2.5E-3    , "m"                     , "Lgate-dependence of SUB1" )
`MPRnb( SUB1LP    , 1.0       , "-"                     , "Lgate-dependence SUB1" )
`MPRnb( SUB2L     , 2.0E-6    , "m"                     , "Lgate-dependence of SUB2" )
`MPRnb( SVDS      , 3.0       , "-"                     , "Substrate current dependence on Vds" )
`MPRnb( SLG       , 3.0E-8    , "m"                     , "substrate current dependence on Lgate" )
`MPRnb( SVBS      , 0.5       , "-"                     , "substrate current dependence on Vbs" )
`MPRnb( SVBSL     , 0.0       , "-"                     , "Lgate-dependence of SVBS" )
`MPRnb( SVBSLP    , 1.0       , "-"                     , "Lgate-dependence of SVBS" )
`MPRnb( SVGS      , 0.8       , "-"                     , "substrate current dependence on Vgs" )
`MPRnb( SVGSL     , 0.0       , "-"                     , "Lgate-dependence of SVGS" )
`MPRnb( SVGSLP    , 1.0       , "-"                     , "Lgate-dependence of SVGS" )
`MPRnb( SVGSW     , 0.0       , "-"                     , "Wgate-dependence of SVGS" )
`MPRnb( SVGSWP    , 1.0       , "-"                     , "Wgate-dependence of SVGS" )
`MPRnb( SLGL      , 0.0       , ""                      , "Substrate current dependence on Lgate ")
`MPRnb( SLGLP     , 1.0       , ""                      , "Substrate current dependence on Lgate ")
`MPRnb( VFBSUB    , -1.0      , "V"                     , "flatband voltage for Isub calculation" )
`MPRnb( VFBSUBL   , 0.0       , "-"                     , "Lgate-dependence of VFBSUB" )
`MPRnb( VFBSUBLP  , 1.0       , "-"                     , "Lgate-dependence of VFBSUB" )
`MPRnb( SUBDLT    , 2.0E-3    , "-"                     , "smoothing parameter (hisimsoi_fb only)" )
`MPRco( HIST1     , 10E-9     , "V"           ,  0, inf , "history-effect parameter" )
`MPRnb( HIST2     , 1E-20     , "A"                     , "history-effect parameter" )
`MPRnb( QHE1      , 1.5       , "-"                     , "FBE parameter" )
`MPRnb( QHE2      , 0.35      , "V"                     , "FBE parameter" )
`MPRnb( EVB1      , 0.0       , "V^-2s^-1"              , "electron tunneling from valence band" )
`MPRnb( EVB2      , 0.0       , "V*m^-1"                , "electron tunneling from valence band" )
`MPRnb( EVB3      , 0.0       , "-"                     , "electron tunneling from valence band" )
`MPRnb( FVBS      , 0.0       , "-"                     , "Vbs dependence of Fowler-Nordheim current" )
`MPRnb( IBPC1     , 0.0       , "Ohm"                   , "impact-ionization-induced bulk potential change" )
`MPRnb( IBPC2     , 0.0       , "V^-1"                  , "impact-ionization-induced bulk potential change" )
`MPRnb( NSTI      , 5.0E17    , "cm^-3"                 , "substrate impurity concentration at STI edge" )
`MPRnb( WSTI      , 0.0       , "m"                     , "width of high-field region at STI edge" )
`MPRnb( WSTIL     , 0.0       , "-"                     , "channel-length dependence of WSTI" )
`MPRnb( WSTILP    , 1.0       , "-"                     , "channel-length dependence of WSTI" )
`MPRnb( WSTIW     , 0.0       , "-"                     , "channel-width dependence of WSTI" )
`MPRnb( WSTIWP    , 1.0       , "-"                     , "channel-width dependence of WSTI" )
`MPRnb( SCSTI1    , 0.0       , "-"                     , "the same effect as SC1 but at STI edge" )
`MPRnb( SCSTI2    , 0.0       , "V^-1"                  , "the same effect as SC2 but at STI edge" )
`MPRnb( VTHSTI    , 0.0       , "V"                     , "threshold voltage shift due to STI" )
`MPRnb( VDSTI     , 0.0       , "-"                     , "Vds dependence of STI subthreshold" )
`MPRnb( MUESTI1   , 0.0       , "m"                     , "mobility change due to diffusion length" )
`MPRoo( MUESTI2   , 0.0       , "-"            ,-1, inf , "mobility change due to diffusion length" )
`MPRnb( MUESTI3   , 1.0       , "-"                     , "mobility change due to diffusion length" )
`MPRnb( NSUBPSTI1 , 0.0       , "m"                     , "pocket concentration modifier" )
`MPRoo( NSUBPSTI2 , 0.0       , "-"            ,-1, inf , "pocket concentration modifier" )
`MPRnb( NSUBPSTI3 , 1.0       , "-"                     , "pocket concentration modifier" )
`MPRnb( NSUBCSTI1 , 0.0       , "m"                     , "channel concentration modifier" )
`MPRoo( NSUBCSTI2 , 0.0       , "-"            ,-1, inf , "channel concentration modifier" )
`MPRnb( NSUBCSTI3 , 1.0       , "-"                     , "channel concentration modifier" )
`MPRnb( TPOLY     , 0.0       , "m"                     , "height of poly-Si gate for fringing cap" )
`MPRco( CGBO      , 0.0       , "F*m^-1"       , 0, inf , "gate-to-B overlap cap" )
`MPRco( CGDO      , 0.0       , "F*m^-1"       , 0, inf , "gate-to-drain overlap cap" )
`MPRco( CGSO      , 0.0       , "F*m^-1"       , 0, inf , "gate-to-source overlap cap" )
`MPRnb( OVSLP     , 2.1E-7    , "mV^-1"                 , "coefficient for overlap capacitance" )
`MPRnb( OVMAG     , 0.6E0     , "V"                     , "coefficient for overlap capacitance" )
`MPRnb( JS0       , 1.0E-4    , "A*m^-2"                , "saturation current density" )
`MPRoo( NJ        , 1.0       , "-"            , 0, inf , "emission coefficient" )
`MPRnb( XTI       , 2.0       , "-"                     , "temp coefficient for forward current densities" )
`MPRnb( XTI2      , 0.0       , "-"                     , "temp coefficient for reverse current densities" )
`MPRnb( VDIFFJ    , 1.6E-3    , "V"                     , "diode threshold voltage at junction" )
`MPRnb( DIVX      , 0.0       , "V^-1"                  , "reverse current coefficient" )
`MPRnb( CJ        , 5.0E-04   , "F*m^-2"                , "bottom junc cap/unit area at zero bias" )
`MPRnb( CJSW      , 5.0E-10   , "F*m^-1"                , "sidewall junc cap grading coefficient" )
`MPRnb( CJSWG     , 5.0E-10   , "F*m^-1"                , "sidewall junc cap per unit length at zero bias" )
`MPRco( MJ        , 0.33      , "-"            , 0, 1.0 , "bottom junc cap grading coefficient" )
`MPRco( MJSW      , 0.33      , "-"            , 0, 1.0 , "sidewall junc cap grading coefficient" )
`MPRco( MJSWG     , 0.33      , "-"            , 0, 1.0 , "gate sidewall junc cap grading coefficient" )
`MPRoo( PB        , 1.0       , "V"            , 0, inf , "bottom junc built-in potential" )
`MPRoo( PBSW      , 1.0       , "V"            , 0, inf , "sidewall junc built-in potential" )
`MPRoo( PBSWG     , 1.0       , "V"            , 0, inf , "gate sidewall junc built-in potential" )
`MPRnb( LOVER     , 30E-9     , "m"                     , "overlap length" )
`MPRnb( CLM1      , 700.0E-3  , "-"                     , "hardness coefficient of channel/contact junction" )
`MPRnb( CLM2      , 2.0       , "-"                     , "coefficient for QB contribution" )
`MPRnb( CLM3      , 1.0       , "-"                     , "coefficient for QI contribution" )
`MPRnb( CLM5      , 1.0       , "-"                     , "CLM parameter" )
`MPRnb( CLM6      , 0.0       , "-"                     , "CLM parameter" )
`MPRnb( VOVER     , 10.0E-3   , "-"                     , "velocity overshoot effect parameter" )
`MPRnb( VOVERP    , 100.0E-3  , "-"                     , "Leff-dependence of velocity overshoot" )
`MPRnb( VOVERS    , 0.0       , "-"                     , "modification of max velocity due to small size" )
`MPRnb( VOVERSP   , 1.0       , "-"                     , "modification of max velocity due to small size" )
`MPRnb( WFC       , 0.0       , "F*cm^-2*m^-1"          , "Threshold voltage change due to cap change" )
`MPRnb( NSUBCW    , 0.0       , "-"                     , "substrate concentration modifier" )
`MPRnb( NSUBCWP   , 1.0       , "-"                     , "substrate concentration modifier" )
`MPRnb( NSUBCMAX  , 5E18      , "cm^-3"                 , "upper limit of substrate concentration" )
`MPRnb( NSUBCL    , 0.0       , "-"                     , "Lgate-dependence of substrate concentration " )
`MPRnb( NSUBCLP   , 1.0       , "-"                     , "Lgate-dependence of substrate concentration " )
`MPRnb( QME1      , 0.0       , "mV"                    , "Vgs-dependence of quantum mechanical effect" )
`MPRnb( QME2      , 0.0       , "V"                     , "Vgs-dependence of quantum mechanical effect" )
`MPRnb( QME3      , 0.0       , "m"                     , "minimum Tox modification" )
`MPRnb( GIDL1     , 5.0E-6    , "A*V^-3/2C^-1m"         , "magnitude of GIDL" )
`MPRnb( GIDL2     , 1.0E6     , "V^-2m^-1F^-3/2"        , "field-dependence of GIDL" )
`MPRnb( GIDL3     , 300.0E-3  , "-"                     , "Vds-dependence of GIDL" )
`MPRnb( GIDL4     , 0.0       , "V"                     , "threshold for Vds dependence" )
`MPRnb( GIDL5     , 0.2E0     , "-"                     , "high-field correction" )
`MPRoo( GIDLVB    , 0.5       , "V^3"         ,0, inf   , "Vb-dependence of GIDL")
`MPRnb( GLEAK1    , 10.0E3    , "V^-3/2*s^-1"           , "gate-to-channel current coefficient" )
`MPRnb( GLEAK2    , 20.0E6    , "V^-1/2*m^-1"           , "gate-to-channel current coefficient" )
`MPRnb( GLEAK3    , 300.0E-3  , "-"                     , "gate-to-channel current coefficient" )
`MPRnb( GLEAK4    , 4E0       , "m^-1"                  , "gate-to-channel current coefficient" )
`MPRoo( GLEAK5    , 7.5E3     , "V*m^-1"       , 0, inf , "G-t-C short channel correction" )
`MPRnb( GLEAK6    , 250E-3    , "V"                     , "G-t-C Vds-dependence correction" )
`MPRnb( GLEAK7    , 1E-6      , "m^2"                   , "G-t-C L and W dependence correction" )
`MPRnb( GLKSD1    , 1.0E-15   , "A*m*V^-2"              , "G-t-S/D current coefficient" )
`MPRnb( GLKSD2    , 5E6       , "V^-1*m^-1"             , "G-t-S/D current coefficient" )
`MPRnb( GLKSD3    , -5E6      , "m^-1"                  , "G-t-S/D current coefficient" )
`MPRnb( GLKB1     , 5E-16     , "A*V^-2"                , "G-t-S/D current coefficient" )
`MPRnb( GLKB2     , 1E0       , "m*V^-1"                , "G-t-S/D current coefficient" )
`MPRnb( GLKB3     , 0E0       , "V"                     , "G-t-S/D current coefficient" )
`MPRoo( VZADD0    , 10.0E-3   , "V"            , 0, inf , "symmetry conservation coefficient" )
`MPRoo( PZADD0    , 5.0E-3    , "V"            , 0, inf , "symmetry conservation coefficient" )
`MPRnb( NFTRP     , 10E9      , "V^-1"                  , "ratio of trap density to attenuation coefficient" )
`MPRnb( NFALP     , 1.0E-19   , "cm*s"                  , "contribution of mobility fluctuation" )
`MPRnb( CIT       , 0.0       , "F*cm^-2"               , "cap caused by the interface trapped carriers" )
`MPRnb( FALPH     , 1.0       , "sm^3"                  , "power of f describing deviation of 1/f" )
`MPRcc( TNOM      , 27.0      , "C"            , 22, 32 , "temperature selected as a nominal value" )
`MPRnb( DLY1      , 100.0E-12 , "s"                     , "coefficient for delay due to diffusion of carriers" )
`MPRnb( DLY2      , 0.7E0     , "-"                     , "coefficient for delay due to conduction of carriers" )
`MPRnb( DLY3      , 0.8E-6    , "Ohm"                   , "coefficient for RC delay of bulk carriers" )
`MPRoo( TFOX      , 3.5E-9    , "m"            , 0, inf , "front oxide thickness" )
`MPRoo( TSOI      , 5.0E-8    , "m"            , 0, inf , "silicon film thickness" )
`MPRoo( XJ        , 5.0E-8    , "m"            , 0, inf , "impurity doping depth" )
`MPRoo( TBOX      , 1.1E-7    , "m"            , 0, inf , "buried oxide thickness" )
`MPRoo( NSUBS     , 3.0E+17   , "cm^-3"        , 0, inf , "SOI layer impurity concentration" )
`MPRoo( NSUBB     , 4.0E+14   , "cm^-3"        , 0, inf , "substrate impurity concentration" )
`MPRnb( RTH0      , 0.1       , "Kcm/W"                 , "Thermal resistance" )
`MPRnb( CTH0      , 1.0E-7    , "Ws/(Kcm)"              , "thermal capacitance" )
`MPRnb( PTL       , 0.0       , "V^(1-PTP)"             , "punchthrough parameter" )
`MPRnb( PTP       , 3.5       , "-"                     , "punchthrough parameter" )
`MPRnb( PT2       , 0.0       , "V^-1"                  , "punchthrough parameter" )
`MPRnb( PTLP      , 1.0       , "-"                     , "punchthrough parameter" )
`MPRnb( GDL       , 0.0       , "-"                     , "strength of high-field effect" )
`MPRnb( GDLP      , 0.0       , "-"                     , "modification of channel conductance" )
`MPRnb( GDLD      , 0.0       , "m"                     , "modification of channel conductance" )
`MPRnb( PT4       , 0.0       , "V^-1"                  , "punchthrough parameter" )
`MPRnb( PT4P      , 1.0       , "-"                     , "punchthrough parameter" )
`MPRnb( VGSMIN    , -5.0*TYPE , "V"                     , "surface potential limiter" )
`MPRnb( MUEPH1    , 25.0E3    , "cm^2V^-1s^-1"          , "phonon scattering" )

// Definition for the source resistance

//******* Instance parameters *******//
`IPRco( NRS       , 1.0        , "-"                  ,   0 , inf , "Number of squares in source ")
`IPRco( NRD       , 1.0        , "-"                  ,   0 , inf , "Number of squares in drain ")
`BPRco( LDRIFT    , 1.0E-6     , "m"                 ,   0 , inf , "Parameter for drift region length (drain) ")
`BPRco( LDRIFTS   , 1.0E-6     , "m"                 ,   0 , inf , "Parameter for drift region length (source) ")

//******* Model Flags *******//
`MPIcc( CORS      , 0          , "-"                  ,   0 ,   1 , "source side resistance OFF(0)/ON(1)")
`MPIcc( CORD      , 0          , "-"                  ,   0 ,   1 , "drain side resistance OFF(0)/ON(1)")
`MPIcc( CORBULK   , 0          , "-"                  ,   0 ,   1 , "bulk resistance OFF(0)/ON(1)")
`MPIsw( CORBNET   , 0          , "-"                              , "Activate body resistance net (1) or not (0)")
//******* Model parameters *******//
`MPRco( RSH       , 0.0        , "ohm"               ,   0 , inf , "Drain diffusion sheet resistance ")
`MPRnb( NOVERS    , 1E19       , "cm^-3"                         , "impurity concentration in overlap region" )
`MPRoo( RDRMUE    , 1.0E3      , "cm^2/Vs"                  ,   0 , inf , "Mobility in drift region (drain)")
`MPRoo( RDRMUES   , 1.0E3      , "cm^2/Vs"                  ,   0 , inf , "Mobility in drift region (source)")
`MPRoo( RDRVMAX   , 3.0E7      , "cm/s"                  ,   0 , inf , "Saturation velocity in drift region (drain)")
`MPRoo( RDRVMAXS  , 3.0E7      , "cm/s"                  ,   0 , inf , "Saturation velocity in drift region (source)")
`MPRnb( RDRMUETMP , 0.0        , "-"                              , "Temperature dependence of resistance ")
`MPRnb( RDRVTMP   , 0.0        , "-"                              , "Temperature dependence of resistance ")
`MPRoo( RDRDJUNC  , 1.0E-6     , "m"                  ,   0 , inf , "Junction depth at channel/drift region ")
`MPRco( RDRBB     , 1          , "-"                  , 0.1 , inf , "Degradation of the mobility in drift region (drain)")
`MPRco( RDRBBS    , 1          , "-"                  , 0.1 , inf , "degradation of the mobility in drift region (source)")
`MPRnb( RDRBBTMP  , 0          , "-"                              , "Temperature coefficient of RDRBB ")
`MPRnb( RDRVMAXW  , 0.0        , "-"                              , "Wgate dependence of the saturation velocity in drift region")
`MPRnb( RDRVMAXWP , 1.0        , "-"                              , "Wgate dependence of the saturation velocity in drift region")
`MPRnb( RDRVMAXL  , 0.0        , "-"                              , "Lgate dependence of the saturation velocity in drift region")
`MPRnb( RDRVMAXLP , 1.0        , "-"                              , "Lgate dependence of the saturation velocity in drift region")
`MPRnb( RDRMUEL   , 0.0        , "-"                              , "Lgate dependence of the mobility in drift region ")
`MPRnb( RDRMUELP  , 1.0        , "-"                              , "Lgate dependence of the mobility in drift region ")

// for new punchthrough model
`MPIcc( COPT      , 0          , "-"                 ,  0 , 1    , "flag punchthrough ")
`MPIsw( COPSPT    , 0          , "-"                             , "flag Ps0 method for deep punchthrough ")
`MPRoc( XJPT      , TSOI       , "m"             ,  0 , TSOI*1.2 , "Junction depth for deep punchthrough ")
`MPRoo( NJUNC     , 1e20       , "cm-3"              ,  0 , inf  , "Junction doping conc; deep punchthrough  ")
`MPRco( MUPT      , 0.0        , "m^2/V/s"           ,  0 , inf  , "mobility for deep punchthrough ")
`MPRnb( VFBPT     , 0.0        , "V"                             , "dVfb for deep punchthrough ")
`MPRnb( PSLIMPT   , 0.0        , "V"                             , "Ps0 limit for deep punchthrough ")
//bulk resistance
`MPRco( RBULK0    , 0.0        , "Ohm"               , 0  , inf  , "offset of bulk resistance ")
`MPRco( RBULKW    , 0.0        , "Ohm/m"             , 0  , inf  , "bulk resistance per width ")
`BPRco( RBDB      , 50.0       , "Ohm"                ,   0 , inf , "Substrate resistance network")
`BPRco( RBSB      , 50.0       , "Ohm"                ,   0 , inf , "Substrate resistance network")
//******* Output Values *******//
`OPD( Rdd       , "Ohm" , " Drift Resistance on Drain side")
`OPD( Rsd       , "Ohm" , " Drift Resistance on Source side")
`OPD( Rbulk     , "Ohm" , " Body Contact Resistance ")

integer rdmod /* 1:RS 2:RD */ ;
real Rdde , Rsde , Conductance , drainConductance , sourceConductance ;

`define Res_min       ( 1e-4 )
`define Gres_max      ( 1e4  )
`define Gres_min      ( 1e-6 )

//`define __DEBUG_RDRIFTS__

// Control Parameters for Qs,bdep
`define QDEP_DLT   7.0
`define QDEP_DLT2  1.0
`define QDEP_DLT3  0.1
`define QDEP_PW    2
`define Qn_alpha   0
`define Qb_alpha   1
`define QnT3_alp   0
`define QbT3_alp   1
`define WDSOILMT       // Enable WDSOI Limitter
`define PF2ADDFAC  0

// Capacitive contribution from MOSFET built in body contact tub.
`MPRnb( VFBBTP    , (VFBC+1.12), "V"                    , "flatband voltage for overlapped MOSFET part" )
`MPRnb( CBTBN     , 0.0       , "F/m^2"                 , "N^+ poly capacitance" )
`MPRnb( CBTBP     , 0.0       , "F/m^2"                 , "P^+ poly capacitance" )
`MPRnb( XWDBT     , 0.0       , "m"                     , "BT overlap width" )

// Output Physical Values in operating point analysis //
`OPM( idse      , "A"   , "Drain-Source current")
`OPM( Isuba     , "A"   , "Substrate current")
`OPM( igidle    , "A"   , "Gate-Induced Drain Leakage current")
`OPM( igisle    , "A"   , "Gate-Induced Source Leakage current")
`OPM( igde      , "A"   , "Gate-Drain current")
`OPM( igse      , "A"   , "Gate-Source current")
`OPM( igbe      , "A"   , "Gate-Substrate current")
`OPM( ggm       , "S"   , "Transconductance")
`OPM( ggds      , "S"   , "Channel conductance")
`OPM( ggmbs     , "S"   , "Body effect(Back gate) transconductance")
`OPM( ggmt      , "S"   , "Temperature transconductance")
`OPM( deltemp   , "S"   , "Temperature ")
`OPP( vone      , "V"   , "Threshold voltage")
`OPP( vdsate    , "V"   , "Saturation voltage")
`OPM( qge       , "C"   , "Gate charge")
`OPM( qde       , "C"   , "Drain charge")
`OPM( qse       , "C"   , "Bulk charge")
`OPM( cggbd     , "F"   , " g-g MOSFET capacitance")
`OPM( cgdbd     , "F"   , " g-d MOSFET capacitance")
`OPM( cgsbd     , "F"   , " g-s MOSFET capacitance")
`OPM( cbgbd     , "F"   , " b-g MOSFET capacitance")
`OPM( cbsbd     , "F"   , " b-s MOSFET capacitance")
`OPM( cbdbd     , "F"   , " b-d MOSFET capacitance")
`OPM( cdgbd     , "F"   , " d-g MOSFET capacitance")
`OPM( cddbd     , "F"   , " d-d MOSFET capacitance")
`OPM( cdsbd     , "F"   , " d-s MOSFET capacitance")
`OPM( ibdb      , "A"   , " b-d Diode current")
`OPM( ibsb      , "A"   , " b-s Diode current")
`OPM( Gbd       , "S"   , " b-d Diode conductance")
`OPM( Gbs       , "S"   , " b-s Diode conductance")
`OPM( capbdb    , "F"   , " b-d Diode capacitance")
`OPM( capbsb    , "F"   , " b-s Diode capacitance")
`OPP( OP_QHS    , "C/m^2"," Qhs ")
`OPP( OP_DVBS_FBE,"V"   , " delat Vbs for FBE")
// End of Output Physical Values //

//*-----------------*/
real       TMF0 , TMF1 , TMF2 , TMF3 , TMF4   ;
real       arg, x2 , xmax2 , xp , xmp , dnm , m0, mm ;

analog function real expm1 ;
    input   x ; real x ;
    expm1=exp(x)-1.0 ;
endfunction

analog function real log1p ;
    input   x ; real x ;
    log1p=ln (1.0+x) ;
endfunction

analog function real FPOW ;
    input   x , y ; real x , y ;
    FPOW = (x==0.0 && y==0.0) ? 1.0 : pow(x,y) ;
endfunction

// localparam
integer   SUBVERSION;
integer   lp_s0_max;
integer   lp_sl_max;

//-----------------------------------------------------------*
//Change units into MKS.
//----------------//
real      MKS_NSUBP;
real      MKS_VTMP;
real      MKS_NSUBCMAX;
real      MKS_NFALP;
real      MKS_NFTRP;
real      MKS_CIT;
real      MKS_NSUBS;
real      MKS_NSUBB;
real      MKS_RTH0;
real      MKS_CTH0;
real      MKS_NOVER;
real      MKS_NJUNC;
real      MKS_NSTI;
real      MKS_WFC;
real      MKS_VMAX;
real      MKS_PARL1;

//-----------------------------------------------------------*
//----------------//
real      UC_SC2;
real      UC_SC3;
real      UC_SCP2;
real      UC_SCP3;
real      UC_GDLD;
real      UC_CLM2;
real      UC_TNOM;
real      UC_VFBOVER;
real      UC_LOD;
integer   flg_info;
integer   flg_nqs;
integer   flg_skipAcc  ;

real      egtnom;
real      Tfox0;
real      C_soi;
real      C_soi_inv;
real      C_fox0;
real      C_fox0_inv;
real      C_box;
real      C_box_inv;
real      C_box_FD_inv;
real      Lgate;
real      Leff , Leff_cv;
real      Lgleff;
real      LGLE;
real      Wgate;
real      dW;
real      dWBT;
real      dWCV;
real      Weff;
real      weff_cv;
real      weff_nf;
real      weffcv_nf;
real      WG;
real      WL;
real      muesr;
//   Surface   impurity   profile   //
real      Nsubpp;
real      Lod_half_ref;

real      betatnom;
real      qnbulk_esi;
//   Parasitic   component   of   the   channel   current   //
real      ptl0;
real      pt40;
real      gdl0;
//   costi0   and   costi1   for   STI   transistor   model(temperature-independent   part)   //
real      costi00;
real      nsti_p2;
real      cnstpgd;
real      c0bulk;
real      Vfb;
//   Wg   dependence   for   short   channel   devices   //
real      lgatesm;
real      dVthsm;
//   Lg   dependence   of   wsti   //
real      UC_WSTI;
//   CLM5   &   CLM6   //
real      clmmod;
//   Gate   resistance   //
real      grg_cnst;
//   Isub   //
real      zvgs;
real      xvbs;
real      xgate;
real      xsub1;
real      xsub2;
real      vg2const;
//   Additional   term   of   lateral-field-induced   capacitance   //
real      cqyb0;
//   Lg   dependence   for   Vfbsub   //
real      vfbsub0;
//   Lg   dependence   for   SVGS   //
real      UC_SVGS;
//   Vdseff   //
real      DDLTe;

real      Vgs_min;

//--------------------------------------------------
//  Local Variables
// Constants ----------------------- //
//
real      Vbs_max ;
real      Vbs_bnd ;
real      Gjmin ;
//
real      sti2_dlt ;
// Internal flags --------------------//
integer   flg_pprv ;
integer   flg_noqi ;
integer   flg_ign ;
integer   flg_dPpg ;
integer   flg_qme ;
// Important Variables in HiSIM -------//
// external bias //
real      Vbse, Vdse, Vgse ;
// confine bias //
real      Vdsc, Vgsc, Vbsc, Vbsc_dVbse ;
// internal bias //
real      Vbs, Vds, Vgs, Vgp, Vgs_fb ;
// Ps0 : surface potential at the source side //
real      Ps0 ;
// Psl : surface potential at the drain side //
real      Psl, Psl_lim ;
// Pds :=Psl - Ps0 //
real      Pds, Pds_ini, Pds_max ;
// iteration numbers of Ps0 and Psl equations. //
integer   lp_s0, lp_sl ;
// Xi0 :=beta * ( Ps0 - Vbs ) - 1. //
real      Xi0, Xi0p12 ;
// Xil :=beta * ( Psl - Vbs ) - 1. //
real           Xilp12 ;
// modified bias and potential for sym.//
real      Vbsz, Vdsz, Vgsz, Vzadd, Ps0z, Pzadd, Vgpz ;
real      Vgpd, Ps0_iniC ;
// Chi :=beta * ( Ps{0/l} - Vbs ) //
real      Chi ;
// threshold voltage //
real      Vth, Vth0 , Wd0 ;
// variation of threshold voltage //
real      dVth, dVth0, dVthSC ;
//
real      dVthSCR ;
//
real      dVthW ;
// Alpha and related parameters //
real      Alpha, Achi, VgVt, Pslsat, VdsatS, Vdsat ;
//
// Q_B and capacitances //
real      Qb ;
// Q_BC and capacitances //
// Q_I and capacitances //
real      Qi ;
// Q_D and capacitances //
real      Qd ;
// channel current //
real      Ids, Ids0 , IdsPT , Idsorg , IdsPT0 , IdsPT1 ;
// STI //
real      costi0_p2 ;
real      dVthSCSTI, Vgssti, costi0, costi1, costi3, costi4, costi5, costi6 ;
real      costi7, Psasti, Psbsti, Psab, Psti, sq1sti, sq2sti, Qn0sti, Idssti ;
real      Asti , expsti ;
// constants ------- //
real      beta, beta2, beta_inv ;
// device instances //
real      Ldby, q_Nsub, Nin, Pb2, Pb20, Pb20b, Pbsum, sqrt_Pbsum ;
real      Pb2c, Eg;
// PART-1 ---------- //
real      cnst0SOI, cnst1bulk, fac1, fac1p2 ;
//
real      fb, exp_Chi; // fb_dChi used in COQOVSM==1 block (Qover)
//
real      Qn0, Qb0 ;
//
real      Idd, Idd1 ;
//
real      Eeff, Rns, Mu, Muun, Ey,  Vmaxe ;
//
real      Ps0_min, Acn, Acd, Ac1, Ac2, Ac3, Ac4, Ac31, Ac41 ;
// PART-2 (Isub)---------- //
real      Isub ;
//
//
// (Isub)+//
// IBPC //
real      betaWL;
real      IdsIBPC ;
// PART-3 (overlap) //
integer   flg_overgiven ;
real      Qgos, Qgod, Cgdoe, Cgsoe, Cgbe, Qgob ;
// fringing capacitance //
real      Cf ;
real      Cfd, Cfs, Cfu, Qfd, Qfs, Qfbc ;
// Cqy //
real      Qy ;
// PART-4 (junction diode) //
real      Ibs, Ibd;
// junction capacitance //
real      Qbs, Qbd;
real      W_dios , W_diod , W_dioscv , W_diodcv ;
// PART-5 (NQS) //
real      tau, taub ;
// PART-6 (noise) //
real      Nflic ;
// thermal //
real      Nthrml, Mud_hoso ;

// induced gate noise ( Part 0/3 ) //
real      kusai00, kusaidd, kusaiL, kusai00L, sqrtkusaiL, kusai_ig, gds0_ign ;
real      crl_f ;
// Igate , Gidl , Gisl //
real      Egp12, Egp32, Egidl, Egisl, Igs, Igd ;
real      Igb, Igate, GLPART1, Igidl, Igisl ;
// Accumulation zone //
real      Psa ;
// CLM //
real      Psdl, Ec, Lred, Aclm ;
// Pocket Implant //
real      Vthp, dVthLP ;
// Poly-Depletion Effect //
real      dPpg ;
// Quantum Effect //
real      Tfoxe, dTfox, C_fox, C_fox_inv;
real      Vthq ;
// FMD* parameters for dPpg model //
real      FMDVDS ;
// temporary vars.-- //
real      T0, T1, T2, T3, T4, T5, T6, T7, T8, TX, TY ;
integer   flg_zone, flg_depmode, flg_depmode_d ;
real      Q_FD_SOI ;
real      Vbi_SOI, phi_s0_SOI_ini, phi_b0_SOI_ini, phi_s0_bulk_ini, phi_sL_SOI_ini ;
real      phi_bL_SOI_ini, phi_sL_bulk_ini, phi_s0_SOI, phi_b0_SOI, phi_s0_bulk ;
real      phi_sL_SOI, phi_bL_SOI, phi_sL_bulk, Q_n0, Q_dep0, Q_s0_bulk ;
real      Q_nL, Q_depL, Q_sL_bulk ;
real      Q_s0_dep , Q_sL_dep ;
real      Q_b0_dep , Q_b0_dep_dPbs , Q_b0_dep_dPss ;
real      Q_bL_dep , Q_bL_dep_dPbs , Q_bL_dep_dPss ;
real      Q_s0_dep_ini ;
real      Q_dep_SOI ;
real      Q_depS0 ;
real      Q_depSL ;
// Idd parameters. //
real      Ps0b, Ps0s, PsLs, Ps0_iniA, Ps0_iniB, Ps0_ini ;
real      cnst1SOI, psb_iniA, psb_iniB, Pb2_bulk, shift ;
real      FD_start, FD_end, Q_s0_bulk_0, phi_s0_bulk_0 ;
real      phi_b_dep, phi_b_dep_dPsb, phi_b_dep0, phi_b_dep0_dPsb, Qsub ;

// Qh0* and QhL* are History Effect parameters. //
real      Qhs, Ids_isub, Ps0_isub ;
// Qhs history effect //
real      Qhs_prev, tauh, Rsb ;
//
real      Vgp_ini ;
real      C_S_inv, WdSOI, WdSOI_0, WdSOI_ini0, WdSOI_ini1, WdSOI_ini2 ;
real      Q_WdSOI_max ;
real      scale_fac , PSCONV_3D ;
real      RRR_B, RRR_CSOI_Cbox, RRR_P0, RRR_alpha_SOI, RRR_eta, RRR_CC, RRR_DD ;
real      WdSOI_ini, phi_SOI0, phi_SOIL ;
real      dphi_sb, c_sb, Chib, phi_SOIb, phi_SOIb_dPss ;
real      Ab, Ai,  Db, Di, C2;

// the parameter SHE //
real      TTEMP;
integer   flg_conv ;
integer   flg_conv_0, flg_conv_L; // source side and drain side; =1: successful convergence
real      ptovr, cnstC_foxi ;
// constants //
real      Vbsz2, Qiu, Qbu, Qdrat , Qdrat_noi ;
real      Vbslim;
real      Lch , Lch_cv ;
real      fb_dPss, C_W_SOI ;

real      Vgpsub, vfbsub1 ;
// For limiting the bottom-junction depletion charges in the SOI layer //
real      Ievb, phib ;
real      Pds_qwe, Ievb0;
real      Mfactor ;
// Vdseff //
real      Vdseff, Vdsorg ;
// G/S and G/D Overlap Charges: Qovs/Qovd //
real      Qovd, Qovs ;
real      QbdLD, QbsLD, QbuLD, QsuLD, QiuLD ;

// Mode flag (=0 | 1 ) //
real      ModeNML, ModeRVS ;

// Body contact well MOSFET (capacitance only) variable names are tentative.
real      Qbody_bt_p_sus, Qbody_bt_p_sud, Qbody_bt_p_ius, Qbody_bt_p_iud;
real      Qbody_bt_n_sus, Qbody_bt_n_sud, Qbody_bt_n_ius, Qbody_bt_n_iud;
real      q_bt_ge, q_bt_de, q_bt_se;

// for consts //
real      cnst0bulk ;
real      Vbsbiz ;
// Qb for FB devices //
real      Qs_FB, Qd_FB ;
real      Qinm , Qidn ,  Qdnm , Qddn , Quot ;
//unused//         real      Isub_FB , Isub_QH ;
real      dVbssub ;
// for BT device //
real      exp_bVbsVds, exp_bPs0, exp_bVbs, cfs1, fs01 ;
real      fs01_dPs0, fs02, fs02_dPs0, Fs0, Fs0_dPs0, dPs0, dPsl, dPlim ;
real      fsl1, fsl1_dPsl, fsl2, fsl2_dPsl, Rho, exp_Rho, Fsl, Fsl_dPsl ;
real      Eta, Eta1, Eta1p12, Zeta12, F00 ;
real      F10, Fdd, DtPds ;
real      Vbsp , Vbspz , Vbcs_cl ;
real      Vbs0 , VbsL  ;
// for bt device //
// uc_*** vars. for device and model parameters -> many of them are now localparam.
real      UC_PDBCP    , UC_PSBCP    ;
real      UC_TEMP     ;

// mosfet overlapped with body contact tub.
real      UC_NSUBBTTUB ;
real      UC_AREABT , UC_VFBBT ;
integer   CBTBN_GIVEN , CBTBP_GIVEN , ABTN_GIVEN , ABTP_GIVEN , CBTB_GIVEN ;
integer   PDBCP_GIVEN , PSBCP_GIVEN ;
real      Cbtp , Cbtn , area_bt_p , area_bt_n ;
real      peri_hhi ;

// vars. for hsm2temp.c
real      Nsub;
real      Lod_half ;
real      Nsubps ;
// here->hsmsoi_ vars. for hsmsoieval.c
real      temp_Given , dtemp_Given;
real      rth   ;
real      cth   ;
real      CGS_mphn0 ;
real      UC_NSUBS;
real      qnsub_esi , qnsub_esi2 , cnst_2esi_q_Nsubs ;
real      ptovr0 , wdpl;
real      vmax0 ;
// real ddlte;
real      grg;
real      grbpdb, grbpsb; // body resistance network
real      qbe;
// Vars for capacitance fitting
real      cgsb   , Xd     ,  isube   , noiigate;
real      noicross , qbd_s0 , qbs_s0 ;

// Local Vars. for hsmsoieval.c
integer   i    ;
real      Cthe    ;
real      CGBO_GIVEN , CGDO_GIVEN , CGSO_GIVEN  ;
real      nume   ;
real      Q_depS0_SOI_o_cnst0SOI , Q_depSL_SOI_o_cnst0SOI;
real      Vbsi    , Vdsi    , Vgsi    , Isubs  ;
real      Iqd_nqs , Iqs_nqs, Qd_qs  , Qs_qs ;
real      Rpower  , Qs     , Qi_nqs;
real      Qb_nqs , Iqi_nqs , Iqb_nqs , Qd_nqs , Qs_nqs , Qg_nqs , Qi_qs  , Qb_qs  , Gth   ;
real      vbcd   , vbcs   ;
// Local Definition Vars. by User
real      Iqh_nqs ;
real      Nsubb0  , Qg     , Itemp  , Qhs_hist;
real      noiflick , noithrml , Vdsei   , Vgsei   , Vbsei   , ggdss ;
real      cgbbd  , cdbbd  , csgbd  , csdbd  , cssbd  , csbbd  , cbbbd  , whi_noise ;
// Others
integer   flg_brk8 ;
integer   end_of_part_1  ;
integer   mode ;
real      ci, sid, sigrat, sigrat_s, sigrat_d ;

//
// Definitions for Memory State Variables for COPPRV model
//
real Pss0_ini, Pbs0_ini, Psb0_ini ;
real Pssl_ini, Pbsl_ini, Psbl_ini ;

`ifndef DISABLE_COPPRV
    integer called , mode_prv , mode_prv2 , flg_zone_prv ;
    real    vtol_pprv ;
    real    vtol_pprv_l, vtol_pprv_u ;
    integer flg_pprv_prv;
    real    vbsc_prv  , vdsc_prv  , vgsc_prv ;
    real    vbsc_prv2 , vdsc_prv2 , vgsc_prv2 ;
    real    Vbsc_dif  , Vdsc_dif  , Vgsc_dif  , sum_vdif ;
    real    Vbsc_dif2 , Vdsc_dif2 , Vgsc_dif2 , sum_vdif2 ;
    real    dVbs  , dVds  , dVgs  ;
    real    ddVbs , ddVds , ddVgs ;
    real    TXdvbs , TXdvds , TXdvgs ;
    real    pss0_prv  , pbs0_prv  , psb0_prv ;
    real    pssl_prv  , pbsl_prv  , psbl_prv ;
    // End of Definitions
`endif // COPPRV

analog begin
`ifdef _4_PORTS_CONNECTED_
        V(n6) <+ 0.0;
        V(bc) <+ 0.0;
        if ( COBCNODE == 1 ) begin
            //$write(" *** Fatal(HiSIM_SOI): COBCNODE = 1 but terminal 'bc' is not connected.\n" );
            //$finish(0);
            $error(" *** Fatal(HiSIM_SOI): COBCNODE = 1 but terminal 'bc' is not connected.\n"); //changed from $finish(0) for NOTICE from VAMPyRE
        end
`else
`ifdef _5_PORTS_CONNECTED_
            V(n6) <+ 0.0;
            if ($port_connected(bc) == 0) begin // 4 nodes
                if ( COBCNODE == 1 )  begin
                    //$write(" *** Fatal(HiSIM_SOI): 'bc' is not connected but COBCNODE = 1.\n" );
                    //$finish(0);
                    $error(" *** Fatal(HiSIM_SOI): 'bc' is not connected but COBCNODE = 1.\n"); //changed from $finish(0) for NOTICE from VAMPyRE
                end
            end
`else
            //    _6_PORTS_CONNECTED_
            if ($port_connected(n6) == 1) begin
                V(n6,temp) <+ 0.0;
                if ( COBCNODE == 0 ) begin
                    //$write(" *** Fatal(HiSIM_SOI): 6 nodes are connected but COBCNODE = 0.\n" );
                    //$finish(0);
                    $error(" *** Fatal(HiSIM_SOI): 6 nodes are connected but COBCNODE = 0.\n"); //changed from $finish(0) for NOTICE from VAMPyRE
                end
            end
            else begin
                V(n6) <+ 0.0;
                if ($port_connected(bc) == 0) begin // 4 nodes
                    if ( COBCNODE == 1 )  begin
                        //$write(" *** Fatal(HiSIM_SOI): 'bc' is not connected but COBCNODE = 1.\n" );
                        //$finish(0);
                        $error(" *** Fatal(HiSIM_SOI): 'bc' is not connected but COBCNODE = 1.\n"); //changed from $finish(0) for NOTICE from VAMPyRE
                    end
                end
            end
`endif
        if (COBCNODE == 0) begin
            V(bc,temp) <+ 0.0;
        end
`endif

    //begin : HSMSOI_model

    // Initial Settings

    Idd        = 0.0 ;
    gds0_ign   = 1e-12 ;
    qse        = 0.0 ;
    flg_ign    = 0 ;
    end_of_part_1 =0 ;
    Xd         = 0.0 ;
    flg_noqi   = 0 ;
    flg_zone   = 0 ;
    Psl        = 0.0 ;
    Psl_lim    = 0.0 ;
    Pds        = 0.0 ;
    Pds_ini    = 0.0 ;
    Ps0z       = 1.0 ;
    Alpha      = 0.0 ;
    VgVt       = 0.0 ;
    Vdsat      = 0.0 ;
    Qb         = 0.0 ;
    Qi         = 0.0 ;
    Qd         = 0.0 ;
    Ids        = 0.0 ;
    fb         = 0.0 ;
    Qn0        = 0.0 ;
    Mu         = 0.0 ;
    Muun       = 0.0 ;
    Ey         = 0.0 ;
    Isub       = 0.0 ;
    //unused//         Isub_FB    = 0.0 ;
    //unused//         Isub_QH    = 0.0 ;
    betaWL     = 1.0 ;
    IdsIBPC    = 0.0 ;
    Qgos       = 0.0 ;
    Qgod       = 0.0 ;
    Qgob       = 0.0 ;
    Qovd       = 0.0 ;
    Qovs       = 0.0 ;
    QbdLD      = 0.0 ;
    QbsLD      = 0.0 ;
    Ibd        = 0.0 ;
    Ibs        = 0.0 ;
    Gbd        = 0.0 ;
    Gbs        = 0.0 ;
    Qbd        = 0.0 ;
    Qbs        = 0.0 ;
    Qinm       = 0.0 ;
    Qidn       = 0.0 ;
    WdSOI_0    = `t_SOI ;

    // Body contact well parasitic nMOSFET 4 lines
    Qbody_bt_p_sus = 0.0;
    Qbody_bt_p_sud = 0.0;
    Qbody_bt_p_iud = 0.0;
    Qbody_bt_p_ius = 0.0;
    //
    Qbody_bt_n_sus = 0.0;
    Qbody_bt_n_sud = 0.0;
    Qbody_bt_n_iud = 0.0;
    Qbody_bt_n_ius = 0.0;
    UC_AREABT  = 0.0 ;
    UC_VFBBT   = 0.0 ;
    q_bt_ge = 0.0;
    q_bt_se = 0.0;

    tau        = 0.0 ;
    taub       = 0.0 ;
    Mud_hoso   = 0.0 ;
    kusai00    = 0.0 ;
    kusaiL     = 0.0 ;
    kusai00L   = 0.0 ;
    sqrtkusaiL = 0.0 ;
    kusai_ig   = 0.0 ;
    crl_f      = 0.0 ;
    Psdl       = 0.0 ;
    Ec         = 0.0 ;
    Lred       = 0.0 ;
    flg_depmode = 0 ;
    flg_depmode_d = 0 ;
    phi_sL_SOI_ini = 0.0 ;
    phi_bL_SOI_ini = 0.0 ;
    phi_sL_bulk_ini = 0.0 ;
    phi_s0_SOI = 0.0 ;
    phi_b0_SOI = 0.0 ;
    phi_s0_bulk = 0.0 ;
    phi_sL_SOI = 0.0 ;
    phi_bL_SOI = 0.0 ;
    phi_sL_bulk = 0.0 ;
    Q_dep_SOI  = 0.0 ;
    Q_n0       = 0.0 ;
    Q_b0_dep   = 0.0 ;
    Q_bL_dep   = 0.0 ;
    Q_dep0     = 0.0 ;
    Q_s0_bulk  = 0.0 ;
    Q_nL       = 0.0 ;
    Q_depL     = 0.0 ;
    Q_sL_bulk  = 0.0 ;
    shift      = 0.0 ;
    Q_s0_bulk_0 = 0.0 ;
    Iqd_nqs    = 0.0 ;
    Iqs_nqs    = 0.0 ;
    Iqi_nqs    = 0.0 ;
    Qi_nqs     = 0.0 ;
    Qd_nqs     = 0.0 ;
    Qs_nqs     = 0.0 ;

    OP_QHS = 0.0;      // 20201013 probing
    OP_DVBS_FBE = 0.0; // 20201013 probing

    phi_b_dep0 = 0.0 ;
    Qsub       = 0.0 ;
    Qhs        = 0.0 ;
    WdSOI      = 0.0 ;
    Ps0_iniA   = 0.0 ;
    Qiu        = 0.0 ;
    Qbu        = 0.0 ;
    Qdrat      = 0.5 ;
    Qdrat_noi  = 0.5 ; // for Noise
    Ievb       = 0.0 ;
    Qs_FB      = 0.0 ;
    Qd_FB      = 0.0 ;
    Iqh_nqs    = 0.0 ;
    Qd_qs      = 0.0 ;
    Qs_qs      = 0.0 ;
    Qi_qs      = 0.0 ;
    Qb_qs      = 0.0 ;
    fs01       = 0.0 ;
    fs02       = 0.0 ;
    fsl1       = 0.0 ;
    fsl2       = 0.0 ;
    SUBVERSION = `SUBVERSION;
    lp_s0_max = 200;
    lp_sl_max = 200;
    flg_skipAcc = 0;

    // for Hidden states
    Vbsbiz       = 0.0 ;
    Ps0_ini      = 0.0 ;
    Q_s0_dep_ini = 0.0 ;
    IdsPT0 = 0.0 ;
    Lch_cv = 0.0;
    Ps0          = 0.0 ;
    Vbcs_cl      = 0.0 ;

    //-----------------------------------------------------------*
    //Change units into MKS.
    //----------------//
    MKS_VMAX     = VMAX     * `C_cm2m;    //"cm*s^-1"
    MKS_NSUBP    = NSUBP    / `C_cm2m_p3; //"cm^-3"
    MKS_VTMP     = VTMP     * `C_cm2m;    //"cm*s^-1"
    MKS_NSUBCMAX = NSUBCMAX / `C_cm2m_p3; //"cm^-3"
    MKS_NFALP    = NFALP    * `C_cm2m;    //"cm*s"
    MKS_NFTRP    = NFTRP    / `C_cm2m_p2; //V^-1
    MKS_CIT      = CIT      / `C_cm2m_p2; //"F*cm^-2"
    MKS_NSUBS    = NSUBS    / `C_cm2m_p3; //"cm^-3"
    MKS_NSUBB    = NSUBB    / `C_cm2m_p3; //"cm^-3"
    MKS_RTH0     = RTH0     * `C_cm2m;    //"Kcm/W"
    MKS_CTH0     = CTH0     / `C_cm2m;    //"Ws/(Kcm)"
    MKS_NOVER    = NOVER    / `C_cm2m_p3; //"cm^-3"
    MKS_NJUNC    = NJUNC    / `C_cm2m_p3; //"cm^-3"
    MKS_NSTI     = NSTI     / `C_cm2m_p3; //"cm^-3"
    MKS_WFC      = WFC / `C_cm2m_p2; // "F*cm^-2*m^-1"
    MKS_PARL1    = PARL1    * `C_cm2m; //cm

    //-----------------------------------------------------------*
    //----------------//
    UC_SC2    = (( SC1 == 0.0 )? 0.0 : SC2 );
    UC_SC3    = (( SC1 == 0.0 )? 0.0 : SC3 );
    UC_SCP2   = (( SCP1 == 0.0 )? 0.0 : SCP2 );
    UC_SCP3   = (( SC1 == 0.0 )? 0.0 : SCP3 );
    UC_GDLD  = GDLD  * `C_m2um ;
    UC_TNOM   = TNOM  + 273.15;      // [C] -> [K] //
    UC_VFBOVER = VFBOVER;
    UC_LOD    = LOD   * `C_m2cm;
    flg_info = INFO;
    flg_nqs  = CONQS;

    UC_CLM2 = (($param_given(CLM2)) ? CLM2 : 5.0e9/(`t_SOI * NSUBS));
    `Fn_SL_CP(UC_CLM2, UC_CLM2, 2.0, 0.1, 2 )

    // Calculation for Loacl Parameter
    egtnom = EG0 - UC_TNOM * ( 90.25e-6 + UC_TNOM * 1.0e-7 );
    Tfox0 = `t_fox;
    C_soi = `C_ESI / `t_SOI ;
    C_soi_inv = 1.0 / C_soi ;
    C_fox0 = `C_EOX / Tfox0;
    C_fox0_inv = Tfox0 / `C_EOX;
    C_box = `C_EOX / `t_box ;
    C_box_inv = `t_box / `C_EOX ;
    C_box_FD_inv = C_box_inv + C_soi_inv ;
    Lgate = L;
    Leff = Lgate - 2.0e0 * XLD ;
    Leff_cv = Lgate - 2.0e0 * XLDC ;
    Lgleff = (COLGLEFF == 0) ? Lgate : Leff;
    LGLE = Lgleff * `C_m2um;
    Wgate = W / NF;
    dW = XWD;
    dWBT = ((SUBVERSION < 1)? 0.0 : XWDBT);
    dWCV = ((SUBVERSION < 1)? XWD : XWDC );
    if ( COBCNODE == 0 ) begin
        Weff = Wgate - 2.0e0 * dW;
        weff_cv = Wgate - 2.0e0 * dWCV;
    end else begin
        Weff = Wgate - NBT * dWBT - (2.0e0 - NBT) * dW;
        weff_cv = Wgate - NBT * dWBT - (2.0e0 - NBT) * dWCV;
    end
    weff_nf = Weff * NF;
    weffcv_nf = weff_cv * NF;
    WG = Wgate * `C_m2um;     // in um
    WL = WG * LGLE;
    muesr = MUESR0 * (1.0e0 + (MUESRL / pow(LGLE, MUESLP))) * (1.0e0 + (MUESRW / pow(WG, MUESWP)));

    // Surface impurity profile //
    // Check NSUBP > NSUBC
    if (SUBVERSION > 3 && MKS_NSUBP < MKS_NSUBS && LP > 0) begin
        //         if( COERRREP ) begin
        $write("*** error(HiSIM_SOI): NSUBP is smaller than NSUBS when LP > 0.\n" ) ;
        $write("    ( NSUBP = %g < NSUBS = %g, LP %g > 0), reset to NSUBS.\n",NSUBP,NSUBS,LP);
        //         end
        MKS_NSUBP = MKS_NSUBS ;
    end

    Nsubpp = MKS_NSUBP * (1.0e0 + (NSUBP0 / pow(WG, NSUBWP)));
    Lod_half_ref = 2.0 / ( 1.0 / (SAREF + 0.5 * Lgate) + 1.0 / (SBREF + 0.5 * Lgate) ) ;
    betatnom = `C_QE / (`C_KB * UC_TNOM);
    qnbulk_esi = `C_QE * MKS_NSUBB * `C_ESI ;

    // Parasitic component of the channel current //
    ptl0 = PTL * pow(LGLE, -PTLP);
    pt40 = PT4 * pow(LGLE, -PT4P);
    gdl0 = GDL * pow(LGLE + UC_GDLD, -GDLP) ;

    // costi0 and costi1 for STI transistor model(temperature-independent part) //
    costi00 = sqrt (2.0 * `C_QE * MKS_NSTI * `C_ESI );
    nsti_p2 = 1.0 / ( MKS_NSTI * MKS_NSTI );
    cnstpgd = pow(1e0 + 1e0 / LGLE, PGD4) * PGD1;
    c0bulk = qnbulk_esi ;

    Vfb = VFBC;

    // Wg dependence for short channel devices //
    lgatesm = Lgleff + WL1 / pow( WL , WL1P );
    dVthsm = WL2 / pow(WL, WL2P);

    // Lg dependence of wsti //
    UC_WSTI =  WSTI * ( 1.0e0 + WSTIL / pow( lgatesm * `C_m2um , WSTILP )) *
                    1.0e0 + WSTIW / pow( WG , WSTIWP );

    // CLM5 & CLM6 //
    clmmod = 1e0 + pow(LGLE, CLM5) * CLM6;

    // Gate resistance //
    grg_cnst = RSHG * ( XGW + Weff / (3.0e0 * NGCON)) / (NGCON * ( Lgate - XGL ) * NF);

    // Isub //
    if ( COSUBSCALE <= 0 ) begin //version 1.4.0:
        zvgs = 1.0 + SVGSW / pow(WG, SVGSWP);
        xvbs = SVBS  * (1.0 + SVBSL / pow(LGLE, SVBSLP));
        xgate = LGLE / (LGLE + SLG);
        xsub1 = SUB1  * (1.0  + SUB1L / pow(LGLE, SUB1LP));
        xsub2 = SUB2 * (1.0 + SUB2L / LGLE);
    end else begin //version 1.5.0:
        T2 = pow( WG , SVGSWP ) ;
        vg2const = SVGS
                          * ( 1.0e0 + SVGSL / pow( LGLE , SVGSLP ) )
                            * ( T2 / ( T2 + SVGSW ) ) ;
        xvbs = SVBS  * (1.0 + SVBSL / pow(LGLE, SVBSLP));
        xgate = SLG * ( 1.0 + SLGL / pow( LGLE , SLGLP ) );
        xsub1 = SUB1 * (1.0 + SUB1L / pow(LGLE, SUB1LP));
        xsub2 = SUB2 * (1.0 + SUB2L / LGLE);
    end

    // Additional term of lateral-field-induced capacitance //
    cqyb0 = `C_m2um * weffcv_nf * XQY1 / pow(LGLE, XQY2);

    // Lg dependence for Vfbsub //
    vfbsub0 = VFBSUB * (1.0e0 + (VFBSUBL / pow(LGLE, VFBSUBLP)));

    // Lg dependence for SVGS //
    if ( COSUBSCALE <= 0 ) begin //version 1.4.0:
        UC_SVGS = SVGS * (1.0e0 + (SVGSL / pow(LGLE, SVGSLP)));
    end

    // Vdseff //
    DDLTe = DDLTSLP * LGLE * DDLTMAX / (DDLTSLP * LGLE + DDLTMAX) + DDLTICT + `Small;
    if (DDLTe < 3.0) begin
        DDLTe = 3.0;
    end

    Vgs_min = TYPE * VGSMIN;

    // @( initial_step or initial_step("static") ) begin

    begin : initializeModel

        CGBO_GIVEN  = $param_given(CGBO) ;
        CGDO_GIVEN  = $param_given(CGDO) ;
        CGSO_GIVEN  = $param_given(CGSO) ;
        CBTBP_GIVEN = $param_given(CBTBP) ;
        CBTBN_GIVEN = $param_given(CBTBN) ;
        PDBCP_GIVEN = $param_given(PDBCP) ;
        PSBCP_GIVEN = $param_given(PSBCP) ;
        ABTP_GIVEN  = $param_given(ABTP) ;
        ABTN_GIVEN  = $param_given(ABTN) ;
        temp_Given  = $param_given(TEMP) ;
        dtemp_Given = (DTEMP==0) ? 0 : 1 ;

        Mfactor = `MFACTOR_USE ;
        Gjmin = $simparam("gmin",0); //changed from 1.0e-12 for VAMPyRE WARNING.

    end // initializeModel

    begin : initializeInstance

        UC_PDBCP = PDBCP; // deferred
        UC_PSBCP = PSBCP; // deferred

        UC_TEMP  = TEMP  + 273.15 ;      // [C] -> [K] //

        //  Beginning of hsmsoitemp.c

        rth = MKS_RTH0 / (Mfactor * weff_nf) ;
        cth = MKS_CTH0 * (Mfactor * weffcv_nf) ;

        // Half length of diffusion //
        if (SA > 0.0 && SB > 0.0
               &&(NF == 1.0 ||(NF > 1.0 && SD > 0.0))) begin
            T1 = 0.0 ;
            for (i = 0 ; i < NF ; i= i + 1) begin
                T1 = T1 + 1.0 / (SA + 0.5 * Lgate + i * (SD + Lgate))
                    + 1.0 / (SB + 0.5 * Lgate + i * (SD + Lgate)) ;
            end
            Lod_half = 2.0 * NF / T1 ;
        end else begin
            Lod_half = 0.0 ;
        end

        // Surface impurity profile //
        if (Lod_half > 0.0) begin
            T1 = 1.0e0 / (1.0e0 + NSUBPSTI2) ;
            T2 = pow(NSUBPSTI1 / Lod_half, NSUBPSTI3) ;
            T3 = pow(NSUBPSTI1 / Lod_half_ref, NSUBPSTI3) ;
            Nsubps = Nsubpp * (1.0e0 + T1 * T2) / (1.0e0 + T1 * T3) ;
        end else begin
            Nsubps = Nsubpp ;
        end

        T2 = (1.0e0 + (NSUBCW / pow(WG, NSUBCWP)))
               * (1.0e0 + (NSUBCL / pow(LGLE, NSUBCLP))) ;
        T3 = MKS_NSUBCMAX / MKS_NSUBS ;
        `Fn_SUtemp( T1, T2, T3, 0.01)
        UC_NSUBS = MKS_NSUBS * T1 ;

        if (Lod_half > 0.0) begin
            T1 = 1.0e0 / (1.0e0 + NSUBCSTI2) ;
            T2 = pow (NSUBCSTI1 / Lod_half, NSUBCSTI3) ;
            T3 = pow (NSUBCSTI1 / Lod_half_ref, NSUBCSTI3) ;
            UC_NSUBS = UC_NSUBS * (1.0e0 + T1 * T2) / (1.0e0 + T1 * T3) ;
        end

        if (Lgleff > LP || LP <= 0.0) begin
            Nsub = (UC_NSUBS * (Lgleff - LP) + Nsubps * LP) / Lgleff ;
        end else begin
            Nsub = Nsubps + (Nsubps - UC_NSUBS) * (LP - Lgleff) / LP ;
        end

        q_Nsub   = `C_QE * Nsub ;
        qnsub_esi = q_Nsub * `C_ESI ;
        qnsub_esi2 = 2.0 * qnsub_esi ;

        // Pocket Overlap(temperature-independent part) //
        if (Lgleff <= 2.0e0 * LP && LP > 0) begin
            Nsubb0 = 2.0e0 * Nsubps - (Nsubps - UC_NSUBS) * Lgleff / LP - UC_NSUBS ;
            ptovr0 = ln (Nsubb0 / UC_NSUBS) ;
            // ptovr0 will be divided by beta later. //
        end else begin
            ptovr0 = 0.0e0 ;
        end

        // 2 phi_B //
        // @300K, with pocket //
        Pb20   = 2.0e0 / `C_b300 * ln (Nsub / `C_Nin0) ;
        // @300K, w/o pocket //
        Pb2c   = 2.0e0 / `C_b300 * ln (UC_NSUBS / `C_Nin0) ;

        // Depletion Width //
        wdpl = sqrt(2.0e0 * `C_ESI / `C_QE / Nsub) ;

        // Velocity Temperature Dependence(Temperature-dependent part will be multiplied later.) //
        T1 = (1.0e0 + (VOVER / pow(LGLE, VOVERP)))
              * (1.0e0 + (VOVERS / pow(WL, VOVERSP))) ;
        `Fn_SZtemp(vmax0, T1, 0.001)

        // Gate resistance //
        if (CORG == 1) begin
            if (grg_cnst > 1.0e-3) begin
                grg = Mfactor / grg_cnst ; // grg_cnst: localparam
            end else begin
                grg = Mfactor * 1.0e3 ;
                $write("warning(HiSIM_SOI): The gate conductance reset to 1.0e3 mho.\n") ;
            end
        end else begin
            grg = Mfactor * 1.0e3 ;
        end

        // Bulk resistance //
        if (CORBULK == 1) begin // originally intended for body potential build-up
            T0 = RBULKW * weff_nf + RBULK0 ;
            Rbulk = T0 / Mfactor ;
            if (Rbulk < `Res_min) Rbulk = `Res_min ;
        end else begin
            Rbulk = `Res_min ;
        end
        // Any conflict against Gmin/Rmin WG policy?
        // Body resistance network other than Rbulk above
        grbpdb = 0.0; grbpsb = 0.0;
        if (CORBNET == 1) begin
            if (RBDB < `Res_min) grbpdb = Mfactor * `Gres_max;
            else grbpdb = Mfactor * ( `Gres_min + 1.0 / RBDB );
            if (RBSB < `Res_min) grbpsb = Mfactor * `Gres_max;
            else grbpsb = Mfactor * ( `Gres_min + 1.0 / RBSB );
        end

        //  End of hsmsoitemp.c
        if ( COBCNODE == 1 ) begin // bt model
            /* Calc. the parasitic parameters and caps for body contact */
            if ( COADOV ) begin

                area_bt_p = (ABTP_GIVEN) ? ABTP : WBTP * NF * LBT ;
                area_bt_n = (ABTN_GIVEN) ? ABTN : WBTN * NF * LBT ;
                Cbtp = 0.0 ;
                Cbtn = 0.0 ;

                if ( area_bt_p > 0.0 && CBTBP_GIVEN) begin
                    Cbtp =  -area_bt_p * CBTBP ;
                end else Cbtp = 0.0 ;
                if ( area_bt_n > 0.0 && CBTBN_GIVEN) begin
                    Cbtn =  -area_bt_n * CBTBN ;
                    area_bt_n = 0.0 ;
                end

            end else begin /* COADOV=0 */
                area_bt_n = 0.0 ;
                Cbtn = 0.0 ;
                area_bt_p = 0.0 ;
                Cbtp = 0.0 ;
            end

            /* Calc. the parasitic parameters for j-diode */
            peri_hhi = ( LBT > Lgate ) ?  0.5 * (LBT - Lgate) : 0.0 ;
            if ( PDBCP_GIVEN==0 ) UC_PDBCP = peri_hhi ;
            if ( PSBCP_GIVEN==0 ) UC_PSBCP = peri_hhi ;

            W_diod   = `W_diod ;
            W_dios   = `W_dios ;
            W_diodcv = weffcv_nf + (NF * UC_PDBCP) ;
            W_dioscv = weffcv_nf + (NF * UC_PSBCP) ;

        end else begin
            area_bt_n = 0.0 ;
            Cbtn = 0.0 ;
            area_bt_p = 0.0 ;
            Cbtp = 0.0 ;
            W_diod    = 0.0 ;
            W_dios   = 0.0 ;
            W_diodcv  = 0.0 ;
            W_dioscv = 0.0 ;
        end
    end // initializeInstance

    //   Initial Settings for each steps.

    //   get biases from CKT //
    Vdsi  = TYPE * V(BRdpsp) ;
    Vgsi  = TYPE * V(BRgpsp) ;
    Vbsi  = TYPE * V(BRbpsp) ;
    Vdsei = TYPE * V(BRds ) ;
    Vgsei = TYPE * V(BRgps) ;
    Vbsei = TYPE * V(BRbps) ;
    if ( COBCNODE == 1 ) begin // bt model
        vbcd = TYPE * V(BRbpdp) ;
        vbcs = TYPE * V(BRbpsp) ;

        //   NQS nodes
        if (flg_nqs) begin
            Qi_nqs = `NQS_CAP * V(nqs_qi) ;
            Qb_nqs = `NQS_CAP * V(nqs_qb) ;
        end else begin
            Qi_nqs = 0.0 ; // bt
            Qb_nqs = 0.0 ;
        end
    end else begin
        vbcd = 0.0 ;
        vbcs = 0.0 ;

        //   NQS nodes
        if (flg_nqs) begin
            Qd_nqs = `NQS_CAP * V(nqs_qd) ;
            Qs_nqs = `NQS_CAP * V(nqs_qs) ;
            Qb_nqs = `NQS_CAP * V(nqs_qb) ;
        end else begin
            Qd_nqs = 0.0 ; // fb
            Qs_nqs = 0.0 ; // fb
            Qb_nqs = 0.0 ;
        end
    end

    //
    //-------------SHE------------------//
    deltemp = (COSELFHEAT > 0 && MKS_RTH0 > 0) ? ( V(temp) > 0.0 ? V(temp) : 0.0 ) : 0.0 ;

    if (Vdsi >= 0) begin  // normal mode //
        mode = 1 ;
        ModeNML = 1.0 ;
        ModeRVS = 0.0 ;
        Vds  = Vdsi ;
        Vgs  = Vgsi ;
        Vbs  = Vbsi ;
        Vdse = Vdsei ;
        Vgse = Vgsei ;
        Vbse = Vbsei ;
    end  else  begin     // reverse mode //
        mode = -1 ;
        ModeNML = 0.0 ;
        ModeRVS = 1.0 ;
        Vds  = -Vdsi ;
        Vgs  =  Vgsi - Vdsi ;
        Vbs  =  Vbsi - Vdsi ;
        Vdse = -Vdsei ;
        Vgse = Vgsei - Vdsei ;
        Vbse = Vbsei - Vdsei ;
    end

    if ( INFO >= 5 ) begin  // mode, bias conditions ... //
        $write( "--- variables given to HSMevaluate() ----\n" ) ;
        $write( "TYPE   = %d\n" , TYPE ) ;
        $write( "mode   = %d\n" , mode ) ;
        $write( "Vbsei Vbsi    = %20.10e %20.10e\n" , Vbsei, Vbsi ) ;
        $write( "Vdsei Vdsi    = %20.10e %20.10e\n" , Vdsei, Vdsi ) ;
        $write( "Vgsei Vgsi    = %20.10e %20.10e\n" , Vgsei, Vgsi ) ;
        $write( "vbcs vbcd     = %20.10e %20.10e\n" , vbcs, vbcd ) ;
    end

    if ( INFO >= 6 ) begin  // input flags //
        $write( "corg    = %d\n" , CORG ) ;
        $write( "coadov  = %d\n" , COADOV ) ;
        $write( "cofbe   = %d\n" , COFBE ) ;
        $write( "coisub  = %d\n" , COISUB ) ;
        $write( "coievb  = %d\n" , COIEVB ) ;
        $write( "coiigs  = %d\n" , COIIGS ) ;
        $write( "cogidl  = %d\n" , COGIDL ) ;
        $write( "coovlp  = %d\n" , COOVLP ) ;
        $write( "coflick = %d\n" , COFLICK ) ;
        $write( "coisti  = %d\n" , COISTI ) ;
        $write( "conqs   = %d\n" , CONQS  ) ;
        $write( "cohist  = %d\n" , COHIST ) ;
        $write( "cothrml = %d\n" , COTHRML ) ;
        $write( "coign   = %d\n" , COIGN ) ;
        $write( "coselfheat = %d\n" , COSELFHEAT ) ;
    end

    //start_of_evaluation ;

    //-----------------------------------------------------------*
    //* Temperature dependent constants.
    //*-----------------//
    TTEMP = $temperature ;
    if ( temp_Given) TTEMP = UC_TEMP ;
    if (dtemp_Given) begin
        TTEMP = TTEMP + DTEMP ;
    end
    TTEMP = TTEMP + deltemp ;

    // Band gap //
    T1 = TTEMP - UC_TNOM ;
    T2 = T1 * (TTEMP + UC_TNOM) ;
    Eg   = egtnom - BGTMP1 * T1 - BGTMP2 * T2 ;
    beta   = `C_QE / (`C_KB * TTEMP) ;
    beta2   = beta * beta ;
    beta_inv = 1.0 / beta ;

    begin : MUEPH
        //CGS unit
        real CGS_mueph, CGS_wmueph, T1, T2, T3;
        CGS_mueph = MUEPH1 * (1.0e0 + (MUEPHW / pow(WG, MUEPWP)))
              * (1.0e0 + (MUEPHL / pow(LGLE, MUEPLP)))
                * (1.0e0 + (MUEPHS / pow(WL, MUEPSP))) ;
        T2 = 1.0e0 / (1.0e0 + MUESTI2) ;
        T3 = FPOW(MUESTI1 / UC_LOD, MUESTI3) ;
        CGS_wmueph = CGS_mueph * (1.0e0 + T2 * T3) ;
        T1 = pow(TTEMP / UC_TNOM, MUETMP) ;
        CGS_mphn0 = T1 / CGS_wmueph ;
    end

    // Pocket Overlap(temperature-dependent part) //
    ptovr = ptovr0 * beta_inv ;

    // Velocity Temperature Dependence //
    T1 = TTEMP / UC_TNOM ;
    Vmaxe = (vmax0 * MKS_VMAX / (1.8 + 0.4 * T1 + 0.1 * T1 * T1 - MKS_VTMP * (1.0 - T1))) ;

    Egp12 = sqrt(Eg) ;
    Egp32 = Eg * Egp12 ;

    // Intrinsic carrier concentration //
    Nin   = `C_Nin0 * `Fn_Pow(TTEMP / UC_TNOM, 1.5e0)
         * exp(- Eg / 2.0e0 * beta + egtnom / 2.0e0 * betatnom) ;

    // costi0 and costi1 for STI transistor model(temperature-dependent part) //
    costi0 = costi00 * sqrt(beta_inv) ;
    costi0_p2 = costi0 * costi0 ;
    costi1 = Nin * Nin * nsti_p2 ;

    //-----------------------------------------------------------*
    //Fixed part.
    //----------------//

    // Metallurgical channel geometry //
    Lch = Lgate - 2.0e0 * XLD ;

    // 2 phi_B //
    // @temp, with pocket //
    if (SUBVERSION > 3) begin
        Pb2   = 2.0 * beta_inv * ln (Nsub / Nin) ;
    end else begin
        Pb2   = 2.0 * beta_inv * ln (`N_sub_SOI / Nin) ;
    end
    // Debye length //
    Ldby = sqrt((`C_ESI / q_Nsub) * beta_inv) ;
    // Coefficient of the F function for bulk charge //
    // cnst0bulk //
    cnst0SOI = (q_Nsub * `C_SQRT_2) * Ldby ;

    // cnst1: n_{p0} / p_{p0} //
    if ( COBCNODE == 1 ) begin
        cnst0bulk = 0.0 ;
        cnst1bulk = 0.0 ;
        T1 = Nin / Nsub ;
    end else begin
        cnst0bulk    = sqrt(2.0 * c0bulk * beta_inv) ;
        T1 = Nin / `N_sub_bulk ;
        cnst1bulk = T1 * T1 ;
        T1 = Nin / `N_sub_SOI ;
    end
    cnst1SOI = T1 * T1 ;

    C_W_SOI = sqrt(2.0 * (`C_ESI / q_Nsub / beta)) ;

    cnst_2esi_q_Nsubs = `cnst_2esi_q / `N_sub_SOI ;
    // Initial guess of the depletion width in the SOI layer //
    WdSOI_ini = sqrt(`cnst_2esi_q * Pb2 / `N_sub_SOI) ;

    begin : paramCheck

        integer FATAL_flag ;
        FATAL_flag = 0 ;
        `PMINCHECK(Weff,1e-9,"An effective channel width  < 1nm ")
        `PMINCHECK(weff_cv,1e-9,"An effective channel width for C-V < 1nm")
        `PMINCHECK(Leff,1e-9,"An effective channel length < 1nm")
        //if(FATAL_flag) $finish(0);
        if (FATAL_flag) $error(" *** Fatal(HiSIM_SOI): An effective channel width/length < 1nm"); //changed from $finish(0) for NOTICE from VAMPyRE

    end // paramCheck

    //-----------------------------------------------------------*
    //set a clamping voltage for Ves.
    //Select Ves or Vbcs according to the existence of the "bc" node.
    //----------------//
    if ( COBCNODE == 1 ) begin
        Vbs_bnd = 0.4 ;
        Vbs_max = 0.8 ;
    end else begin
        Vbs_bnd = `Vbs_bnd ;
        Vbs_max = `Vbs_max ;
    end

    //---------------------------------------------------*
    //Clamp too large biases.
    //-note: Quantities are extrapolated in PART-5.
    //----------------//
    if (Vbs_bnd > Vbs_max * 0.5) begin
        Vbs_bnd = 0.5 * Vbs_max ;
    end
    if (Vbs > Vbs_bnd) begin
        T2 = Vbs - Vbs_bnd ;
        T3 = Vbs_max - Vbs_bnd ;
        `Fn_CP_DX(T4, T2, T3, 4, T8)
        Vbsc = Vbs_bnd + T4 ;
        Vbsc_dVbse = T8 ;
    end else begin
        Vbsc = Vbs ;
        Vbsc_dVbse = 1.0 ;
    end
    Vdsc = (Vds  >  `Vds_max) ?  `Vds_max : Vds  ;
    Vgsc = (Vgs  >  `Vgs_max) ?  `Vgs_max : Vgs  ;
    Vgsc = (Vgs  < -`Vgs_max) ? -`Vgs_max : Vgsc ;
    Vbsc = (Vbsc < -`Vgs_max) ? -`Vgs_max : Vbsc ;

    //  Vbs, Vds and Vgs are determined.  //
    Vds  = Vdsc ;
    Vgs  = Vgsc ;
    Vbs  = Vbsc ;

    // begin : COPPRV_model // (copprv = 1)

    /* Initialize for Hidden states */
    flg_pprv = 0;

    /* Initialization for hidden states */
    Pss0_ini=0.0;
    Pbs0_ini=0.0;
    Psb0_ini=0.0;
    Pssl_ini=0.0;
    Pbsl_ini=0.0;
    Psbl_ini=0.0;
    Ai       = 0.0 ;
    Db       = 0.0 ;
    Di       = 0.0 ;
    C2       = 0.0 ;

    //++++++++++++++++++++++++++++++++++++++++++++++++++++++++++++
    //PART-1: Basic device characteristics.
    //+++++++++++++++++++++++++++++++++++++++++++++++++++++++++++//

    //-----------------------------------------------------------*
    //Initialization.
    //----------------//
    // Initialization of counters is needed for restart. //
    lp_s0 = 0 ;
    lp_sl = 0 ;

    //-----------------------------------------------------------*
    //    Vxsz: Modified bias introduced to realize symmetry at Vds=0.
    //    ----------------  from HiSIM 2 //
    begin : Vxsz
        real T1;
        T1 = Vbsc_dVbse * Vds / 2 ;
        `Fn_SymAdd(Vzadd, T1, VZADD0)
        if (Vzadd < `ps_conv) begin
            Vzadd = `ps_conv ;
        end

        Vbsz = Vbs + Vzadd ;
        Vdsz = Vds + 2.0 * Vzadd ;
        Vgsz = Vgs + Vzadd ;
    end

    //-----------------------------------------------------------*
    //  Define Vbcs and Vbcsz for FB and BC device.
    //  ----------------
    if ( COBCNODE == 1 ) begin
        Vbsp  = Vbs ;
        Vbspz = Vbsz ;
    end else begin
        Vbsp  = (SUBVERSION < 3) ? Vbs  : 0.0 ;
        Vbspz = (SUBVERSION < 3) ? Vbsz : 0.0 ;
    end

    //---------------------------------------------------*
    //* Factor of modification for symmetry.
    //*-----------------//
    begin : Factor_of_Modification_for_Symmetry
        real T1, T2, T3, TX;
        T1 = (2.0 * q_Nsub * `C_ESI) * C_fox0_inv * C_fox0_inv ;
        T2 = Vgs - Vfb ;
        T3 = 1 + 2.0 / T1 * (T2 - beta_inv - Vbsp) ;
        `Fn_SZtemp(T4, T3, 1e-3)
        TX = sqrt(T4 + `Small) ;
        Pslsat = T2 + T1 * (1.0 - TX) ;
        VdsatS = Pslsat - Pb2 ;
        `Fn_SLtemp(VdsatS, VdsatS, 0.1, 5e-2)
        T1 = Vds / VdsatS ;
        `Fn_SUPoly4(TX, T1, 1.0, T0)
        FMDVDS = TX * TX ;
    end

    //-----------------------------------------------------------*
    //* Quantum Mechanical Effect
    //*-----------------//
    begin : QuantumMechanicalEffect
        real T2, T3, T4, T4w, T5, T6 ;
        if ((QME1 == 0.0 && QME3 == 0.0) || QME2 == 0.0) begin
            flg_qme = 0 ;
        end else begin
            flg_qme = 1 ;
        end
        T2 = sqrt((2.0 * q_Nsub * `C_ESI) * Pb20) ;
        Vthq = Pb20 + Vfb + T2 / C_fox0 ;
        if (flg_qme == 0) begin
            Tfoxe = Tfox0 ;
            C_fox = C_fox0 ;
            C_fox_inv = C_fox0_inv ;
            cnstC_foxi = (cnst0SOI * C_fox0_inv * C_fox0_inv) * cnst0SOI ;

        end else begin             //!if( flg_qme == 0 )
            T5 = Vgs  - Vbsp - Vthq + QME2 ;
            `Fn_SZtemp( T2 , T5 , `qme_dlt)
            T3 = 1.0 /  T2 ;
            T4w = 2.0 * abs(Vthq) ;
            T6 = Vfb - Vthq + QME2 ;
            T4 = (T6 > T4w) ? T6 : T4w;

            `Fn_SUtemp( T2 , T3 , 1.0 / T4  , `qme_dlt )
            dTfox = QME1 * T2 + QME3 ;
            if ( dTfox * 1.0e12 < Tfox0 ) begin
                dTfox = 0.0 ;
                flg_qme = 0 ;
            end
            Tfoxe = Tfox0 + dTfox ;
            C_fox = `C_EOX / Tfoxe ;
            C_fox_inv  = Tfoxe / `C_EOX ;
            cnstC_foxi = (cnst0SOI * cnst0SOI * C_fox_inv) * C_fox_inv ;

        end                        // end of flg_qme if-blocks //
    end

    //---------------------------------------------------*
    //* Vbsz2 : Vbs for dVth
    //*-----------------//
    if ( COBCNODE == 1 || SUBVERSION < 3 ) begin
        `Fn_SUtemp(Vbsz2, Vbspz, 0.5, 1.0e-3)
        Vbslim = - `t_SOI*`t_SOI * q_Nsub/(2.0*`C_ESI) + Pb2 - beta_inv;
        `Fn_SLtemp(Vbsz2, Vbsz2, Vbslim, 1.0e-3) //lower limit for FD condition
        if ( SUBVERSION > 2 ) begin
            `Fn_SUtemp(Vbsz2, Vbsz2, Pb20, 1.0e-3) //lower limit for FD condition
        end
    end else begin
        Vbsz2 = 0.0 ;
    end

    //---------------------------------------------------*
    //* Wd0 : depletion-layer thickness
    //*-----------------//
    // Fixed Wd to Tsoi //
    if ( SUBVERSION < 3 ) begin
        Wd0 = `t_SOI ;
    end else begin
        T1 = 2.0 * `C_ESI / q_Nsub ;
        Wd0 = sqrt(T1 *  (Pb20 - Vbsz2)) ;
    end

    //---------------------------------------------------*
    //* Vthp : Vth with pocket.
    //*-----------------//
    begin : SetVthp
        real T1, T0, T2, T3;
        // Disable Vbs dependence for Vthp(Pocket)  //
        Qb0 = (SUBVERSION < 3) ? sqrt(qnsub_esi2 * Pb20)
                                      : sqrt(qnsub_esi2 * (Pb20 - Vbsz2)) ;
        Vthp = Pb20 + Vfb + Qb0 * C_fox_inv + ptovr ;
        Pb20b = Pb20 ;
        T0 = 0.95 ;
        T1 = T0 * Pb20b - Vbsz2 - 1.0e-3 ;
        T2 = sqrt(T1 * T1 + 4.0 * T0 * Pb20b * 1.0e-3) ;
        T3 = T0 * Pb20b - 0.5 * (T1 + T2) ;
        Pbsum = Pb20b - T3 ;
        sqrt_Pbsum = sqrt(Pbsum) ;
    end

    //-------------------------------------------*
    //     dVthLP : Short-channel effect induced by pocket.
    //     - Vth0 : Vth without pocket.
    //    -----------------//
    begin : SetdVthLP
        real T0, T1, T2, T3, T4, T5, dVth0;

        if (LP != 0.0) begin
            T1 = 2.0 * `C_QE * UC_NSUBS * `C_ESI ;
            T2 = (SUBVERSION < 3) ? sqrt(T1 * Pb2c)
                                        : sqrt(T1 * (Pb2c - Vbsz2)) ;
            Vth0 = Pb2c + Vfb + T2 * C_fox_inv ;
            T1 = `C_ESI * C_fox_inv ;

            T4 = 1.0e0 / (LP * LP) ;
            T3 = 2.0e0 * Wd0 * T4 ;
            T5 = T1 * T3 * (VBI - Pb20b) ;
            dVth0 = T5 ;

            T1 = Vthp - Vth0 ;
            T0 = UC_SCP3 / LP ;
            T2 = SCP1 + T0 * Pbsum ;
            T5 = UC_SCP2 ;
            T3 = T2 + T5 * Vdsz ;
            dVthLP = T1 * dVth0 * T3 ;
        end else begin
            dVthLP = 0.0 ;
        end
    end

    //---------------------------------------------------*
    //* dVthSC : Short-channel effect.
    //*-----------------//
    begin : SetdVthSC
        real T0, T1, T2, T3, T4, T5, dVth0;
        T0 = `C_ESI * Wd0 * 2.0e0 ;
        T1 = C_fox_inv * T0 ;
        T2 = VBI - Pb20b ;
        T3 = Lgleff - PARL2 ;
        T4 = 1.0e0 / (T3 * T3) ;
        dVth0 = T1 * T2 * T4 ;
        T1 = UC_SC3 / Lgleff ;
        T4 = SC1 + T1 * Pbsum ;
        T5 = T4 + UC_SC2 * Vdsz ;
        dVthSC = dVth0 * T5 ;
    end

    //---------------------------------------------------*
    //* dVthSCR : back-field effect.
    //*------------------------//
    begin : SetdVthSCR
        real T1, T2, T3;
        if (SCR1 > 0.0) begin
            T1 = Eg + Pb2 - 2.0 * SCR3 + SCR2 * Vdsz ;
            T2 = Lgleff * 0.5 + MKS_PARL1 ;
            T3 = SCR1 * `t_SOI / T2 ;
            dVthSCR = T1 * T3 ;
        end else begin
            dVthSCR = 0.0 ;
        end
    end

    //---------------------------------------------------*
    //* dVthW : narrow-channel effect.
    //*-----------------//
    begin : SetdVthW
        real T1, T3, T5;

        T1 = C_fox_inv ;
        T3 = 1.0 / (C_fox + MKS_WFC / Weff) ;
        T5 = T1 - T3 ;
        dVthW = Qb0 * T5 + WVTH0 / WG ;
    end

    //---------------------------------------------------*
    //    dVth : Total variation.
    //    - Positive dVth means the decrease in Vth.
    //    ----------------//
    dVth = dVthSC + dVthLP + dVthW + dVthSCR + dVthsm ;

    //---------------------------------------------------*
    //    Vth : Threshold voltage.
    //    ----------------//
    Vth = Vthp - dVth ;

    //---------------------------------------------------*
    //Poly-Depletion Effect
    //----------------//
    begin : SetPolyDepletionEffect
        real T7, T0, T3;

        if (PGD1 == 0.0) begin
            flg_dPpg = 0 ;
        end else begin
            flg_dPpg = 1 ;
        end
        if (flg_dPpg == 0) begin
            dPpg = 0.0 ;
        end else begin
            T7 = Vgsz ;
            T0 = cnstpgd ;
            T3 = T7 - PGD2 ;
            `Fn_ExpLim( dPpg , T3 )
            `Fn_SZtemp( dPpg , dPpg - 1.0 , 0.1 )
            dPpg = dPpg * T0 ;
            `Fn_SUtemp( dPpg , dPpg , `pol_b , `pol_dlt )

        end                        // end of flg_dPpg if-blocks //
    end  // SetPolyDepletionEffect

    //---------------------------------------------------*
    //    Vgp : Effective gate bias with SCE & RSCE & flatband.
    //    ----------------//
    Vgp = Vgs - Vfb + dVth - dPpg ;
    Vgpz = Vgp ;

    //---------------------------------------------------*
    //    Vbi_SOI : Difference of built-in potential between SOI and bulk.
    //    Vgs_fb : Flatband voltage taking account Vbs.
    //    -----------------//
    T1 = ln (`N_sub_SOI / `N_sub_bulk) ;
    Vbi_SOI = beta_inv * T1 ;
    Vgs_fb = Vfb - dVth + dPpg ;

    //-----------------------------------------------------------*
    //Constants in the equation of Ps0 .
    //----------------//
    fac1 = cnst0SOI * C_fox_inv ;
    fac1p2 = fac1 * fac1 ;

    if ( COBCNODE == 0 ) begin
// ---- begin `include "HSMSOI_FB_module.inc" ----
/***********************************************************************

 HiSIM (Hiroshima University STARC IGFET Model)
 Copyright (C) 2000-2016 Hiroshima University and STARC
 Copyright (C) 2016-2021 Hiroshima University
 HiSIM_SOI (Silicon-On-Insulator Model)
 Copyright (C) 2012-2016 Hiroshima University and STARC
 Copyright (C) 2016-2021 Hiroshima University

 MODEL NAME : HiSIM_SOI
 ( VERSION : 1  SUBVERSION : 5  REVISION : 0 )
 Model Parameter 'VERSION' : 1.50
 FILE : HSMSOI_FB_module.inc

 Date : 2021.10.08

 released by Hiroshima University

***********************************************************************/
//
////////////////////////////////////////////////////////////////
//
//
//Licensed under the Educational Community License, Version 2.0
//(the "License"); you may not use this file except in
//compliance with the License.
//
//You may obtain a copy of the License at:
//
//      http://opensource.org/licenses/ECL-2.0
//
//Unless required by applicable law or agreed to in writing,
//software distributed under the License is distributed on an
//"AS IS" BASIS, WITHOUT WARRANTIES OR CONDITIONS OF ANY KIND,
//either express or implied. See the License for the specific
//language governing permissions and limitations under the
//License.
//
//
//The HiSIM_SOI standard has been supported by the members of
//Silicon Integration Initiative's Compact Model Coalition. A
//link to the most recent version of this standard can be found
//at:
//
//http://www.si2.org/cmc
//
////////////////////////////////////////////////////////////////
//

//================ Start of executable code.=================//

//start_of_routine

begin : HSOI_calc_Phis_FB

    real C_soi , C_soi_inv , t_SOI , WdSOI_ini1_dlt , QDEPB_DLT ;
    real Q_FD_dlt1, Q_FD_dlt2 ;

    //-----------------------------------------------------------*
    // Initial guess of the depletion charge for source side    //
    //
    QDEPB_DLT = 7.0 ;
    Vgp_ini = Pb2 + 1.0 ;
    T1 = 1.0 / cnst1SOI / cnstC_foxi ;
    T2 = T1 * (Vgp_ini - shift) * (Vgp_ini - shift) ;
    T3 = beta + 2.0 / (Vgp_ini - shift) ;
    Ps0_iniC = ln (T2) / T3 ;
    WdSOI_ini0 = sqrt(cnst_2esi_q_Nsubs * Ps0_iniC) ;
    WdSOI_ini0 = (WdSOI_ini0 > `t_SOI) ? `t_SOI : WdSOI_ini0 ;
    Q_WdSOI_max = -`C_QE * `N_sub_SOI * WdSOI_ini0 ;

    // Modifiy Q_FD_SOI and t_SOI
    t_SOI = `t_SOI ;
    Q_FD_SOI = -`C_QE * `N_sub_SOI * t_SOI ;
    WdSOI_ini1_dlt = 1.5 ;
    C_soi = `C_ESI / t_SOI ;
    C_soi_inv = 1.0 / C_soi ;
    Q_FD_dlt1 = -Q_FD_SOI * 1e-3 ;
    Q_FD_dlt2 = -Q_FD_SOI * 1e-5 ;

    //---------------------------------------------------*
    //    phi_s0_bulk_0 :
    //    -----------------//
    // initial value(phi_s0_bulk_0) start //

    begin : InitialValueForPhiS0Bulk0
        real T0, T1, T2, T3, psb_iniA, psb_iniB;

        if (COVBSBIZ) Vbsbiz = Vbsz + Vbi_SOI ;
        else  Vbsbiz = Vbs  + Vbi_SOI ;

        Pb2_bulk = 2.0 / beta * ln (`N_sub_bulk / Nin) ;
        T0 = cnst0bulk * cnst0bulk * C_box_FD_inv * C_box_FD_inv ;
        T1 = -(Vbsbiz) ;
        T2 = (2 * T1 + T0 * beta) * (2 * T1 + T0 * beta) - 4 * (T1 * T1 + T0) ;
        T2 = `Fn_Max(T2, `epsm10) ;
        T2 = sqrt(T2) ;
        T3 = 2 * T1 + T0 * beta ;
        psb_iniA = (T3 - T2) / 2 ;
        psb_iniB = ln (T1 * T1 / T0 / cnst1bulk) / (beta + 2.0 / T1) ;
        if (psb_iniA < Pb2_bulk) begin
            phi_s0_bulk_0 = psb_iniA ;
        end else begin
            `Fn_SUtemp(phi_s0_bulk_0, psb_iniA, psb_iniB, `c_ps0ini_2)
        end
    end
    // initial value(phi_s0_bulk_0) end //

    // newton loop(phi_s0_bulk_0) start //
    begin : NewtonLoopForPhiS0Bulk0
        real T1, T2, T3, T0, T4, T5, T6, T7;

        for (lp_s0 = 0 ; lp_s0 < lp_s0_max ;  lp_s0 = lp_s0 + 1 ) begin

            T1 = cnst0bulk ;
            T2 = beta * phi_s0_bulk_0 ;
            T3 = exp(-T2) ;
            if (phi_s0_bulk_0 > `C_PHI_1_MINIMUM) begin
                T0 = exp(beta * phi_s0_bulk_0) ;
                T4 = -T1 * sqrt(T3 + T2 - 1 + cnst1bulk * (T0 - 1)) ;
                T5 = c0bulk / T4 * (-T3 + 1 + cnst1bulk * (T0)) ;
            end else if (phi_s0_bulk_0 < -`C_PHI_1_MINIMUM) begin
                T4 = T1 * sqrt(T3 + T2 - 1) ;
                T5 = c0bulk / T4 * (-T3 + 1) ;
            end else begin
                T4 = -sqrt(c0bulk / beta) * beta * phi_s0_bulk_0 ;
                T5 = -sqrt(c0bulk * beta) ;
            end
            `Fn_SZ_DX(T6, T4, Q_FD_dlt1, T7)
            `Fn_SU_DX(T6, T6, (-Q_FD_SOI), Q_FD_dlt2, T8)
            T7 = T7 * ( T5 * T8 ) ;
            phi_b_dep0 = T6 * T6 / 2.0 / `C_ESI / `C_QE / `N_sub_SOI ;
            phi_b_dep0_dPsb = 2 * phi_b_dep0 * T7 / T6 ;

            T6 = phi_s0_bulk_0 - ((-phi_s0_bulk_0 + T4 / C_box - Vbsbiz + phi_b_dep0)
            / (-1 + T5 / C_box + phi_b_dep0_dPsb)) ;
            if (abs(T6 - phi_s0_bulk_0) < `ps_conv) begin
                lp_s0 = lp_s0_max ;
            end
            phi_s0_bulk_0 = T6 ;
            Q_s0_bulk_0 = T4 ;
        end
    end  // newton loop(phi_s0_bulk_0) end //

    // Vgs_fb shift for initial guess(start) //
    begin : VgsfbShiftForInitialGuess
        real T0, T1, T2, T3, T4, T5;

        phi_b_dep = phi_b_dep0 ;
        T1 = sqrt(`cnst_2esi_q * phi_b_dep / `N_sub_SOI) ;
        if (T1 > 0.99 * t_SOI) begin
            T0 = 1.0 / C_fox ;
            T1 = t_SOI / `C_ESI ;
            T2 = 1.0 / C_box ;
            T3 = 1.0 / (T0 + T1 + T2) ;
            T4 = 1 - T3 * T0 ;
            T5 = T0 * (T3 * (- Vbsbiz + (T2 + 0.5 * T1) * (-Q_FD_SOI))) ;
            shift = T5 / T4 ;
            Vgs_fb = Vgs_fb + shift ;
        end
    end  //  Vgs_fb shift for initial guess(end) //

    begin : Vxsztmp
        real T1, Vzadd;
        T1 = Vbsc_dVbse * Vds / 2 ;
        `Fn_SymAdd(Vzadd, T1, 10e-2) //10e-3
        if (Vzadd < `ps_conv) begin
            Vzadd = `ps_conv ;
        end
        T3 = Vzadd;
    end //

    Vgpd = Vgs + T3 - Vfb + dVth - dPpg ;
    WdSOI_ini1 = WdSOI_ini0 / (WdSOI_ini1_dlt * Pb2) * Vgpd ;
    `Fn_SL_CP(WdSOI_ini2, WdSOI_ini1,          0, t_SOI * `QDEP_DLT  , `QDEP_PW )
    `Fn_SU_CP(WdSOI_ini2, WdSOI_ini2, WdSOI_ini0, t_SOI * `QDEP_DLT2 , `QDEP_PW )
    Q_s0_dep_ini =  - WdSOI_ini2 * q_Nsub ;

    // Initial guess of the depletion charge for source side end  //
    //-----------------------------------------------------------*

    //-----------------------------------------------------------*
    //* Initial Guess for Source Side.
    //*-----------------//

    FD_start = (-Q_FD_SOI) * t_SOI / 2.0 / `C_ESI + beta_inv ;
    FD_end = FD_start - Q_s0_bulk_0 * t_SOI / `C_ESI ;

`ifndef DISABLE_COPPRV

    //-------------------------------------------------------------------*
    // Update initial potential values by previous values
    //----------------//

    vtol_pprv = 5.0e-2 ;
    vtol_pprv_u = 6.0e-2;
    vtol_pprv_l = 4.0e-2;

    if ( COPPRV ) begin
        if (called >= 1) begin
            Vbsc_dif = Vbsc - vbsc_prv ;
            Vdsc_dif = Vdsc - vdsc_prv ;
            Vgsc_dif = Vgsc - vgsc_prv ;
            sum_vdif = abs(Vbsc_dif) + abs(Vdsc_dif) + abs(Vgsc_dif) ;

            flg_pprv = (flg_pprv_prv > 0 )? 1 : 0 ;
            if (sum_vdif > vtol_pprv_u) flg_pprv = 0;
            if (sum_vdif <= vtol_pprv_l) flg_pprv = 1;
            if (mode * mode_prv < 0) flg_pprv = 0;

            if ( called >=2 && flg_pprv ==1 ) begin
                Vbsc_dif2 = vbsc_prv - vbsc_prv2 ;
                Vdsc_dif2 = vdsc_prv - vdsc_prv2 ;
                Vgsc_dif2 = vgsc_prv - vgsc_prv2 ;
                sum_vdif2 = abs(Vbsc_dif2) + abs(Vdsc_dif2) + abs(Vgsc_dif2) ;
                if (`epsm10 < sum_vdif2 && sum_vdif2 <= vtol_pprv && mode_prv * mode_prv2 > 0 ) flg_pprv = 2 ;
            end
            dVbs = Vbsc_dif ;
            dVds = Vdsc_dif ;
            dVgs = Vgsc_dif ;
            ddVbs = dVbs * dVbs /2 ;
            ddVds = dVds * dVds /2 ;
            ddVgs = dVgs * dVgs /2 ;
            //
            if ( flg_pprv >= 1 ) begin
                Pss0_ini = pss0_prv;
                Pbs0_ini = pbs0_prv;
                Psb0_ini = psb0_prv;

                Pssl_ini = pssl_prv;
                Pbsl_ini = pbsl_prv;
                Psbl_ini = psbl_prv;
            end

            flg_pprv_prv = flg_pprv;

        end else begin
            Vbsc_dif  = 0.0 ;
            Vdsc_dif  = 0.0 ;
            Vgsc_dif  = 0.0 ;
            Vbsc_dif2 = 0.0 ;
            Vdsc_dif2 = 0.0 ;
            Vgsc_dif2 = 0.0 ;
            sum_vdif  = 0.0 ;
            sum_vdif2 = 0.0 ;
            flg_pprv = 0 ;

            flg_pprv_prv = flg_pprv;

        end
    end // End of (COPPRV)

`endif // COPPRV

    if ( flg_pprv >= 1 ) begin
        phi_s0_SOI  = Pss0_ini ;
        phi_b0_SOI  = Pbs0_ini ;
        phi_s0_bulk = Psb0_ini ;
        flg_depmode = (phi_s0_SOI < FD_end) ? 1 : 2 ;
    end

    else begin : HSOI_calc_ini
        //-----------------------------------------------------------*
        //* Initial guess for Ps0. (start)
        //*-----------------//
`define  ps_conv_ini 1E-3

        //---------------------------------------------------*
        //* Ps0_iniA: solution of subthreshold equation assuming zone-D1/D2.
        //*-----------------//
        TX = 1.0e0 + 4.0e0 * ( beta * ( Vgpz ) - 1.0e0 ) / ( fac1p2 * beta2 ) ;
        TX = `Fn_Max( TX , `epsm10 ) ;
        Ps0_iniA = Vgpz + fac1p2 * beta * 0.5 * ( 1.0e0 - sqrt( TX ) ) ;

        //---------------------------------------------------*
        //* Analytical initial guess.
        //*-----------------//
        //-------------------------------------------*
        //* Common part.
        //*-----------------//
        Chi = beta * ( Ps0_iniA ) ;
        if ( Chi < `znbd3 ) begin
            //-----------------------------------*
            //* zone-D1/D2
            //* - Ps0_ini is the analytical solution of Qs=Qb0 with
            //*   Qb0 being approximated to 3-degree polynomial.
            //*-----------------//
            TY = beta * ( Vgpz - Vbs ) ;
            T1 = 1.0e0 / ( `cn_nc3 * beta * fac1 ) ;
            T2 = 81.0 + 3.0 * T1 ;
            T3 = -2916.0 - 81.0 * T1 + 27.0 * T1 * TY ;
            T4 = 1458.0 - 81.0 * ( 54.0 + T1 ) + 27.0 * T1 * TY ;
            T4 = T4 * T4 ;
            T5 = `Fn_Pow( T3 + sqrt( 4 * T2 * T2 * T2 + T4 ) , `C_1o3 ) ;
            TX = 3.0 - ( `C_2p_1o3 * T2 ) / ( 3.0 * T5 )
                + 1.0 / ( 3.0 * `C_2p_1o3 ) * T5 ;
            Ps0_iniA = TX * beta_inv + Vbs ;
            Ps0_ini = Ps0_iniA ;
        end else if ( Vgs - shift <= Vth ) begin
            //-----------------------------------*
            //* Accumulation & Weak inversion zone.
            //*-----------------//
            T0 = 1.0 / C_fox ;
            T1 = t_SOI / `C_ESI ;
            T2 = 1.0 / C_box ;
            T3 = 1.0 / (T0 + T1 + T2) ;
            T4 = T3 * (Vgpz - Vbsbiz + (T2 + 0.5 * T1) * (-Q_s0_dep_ini)) ;
            Ps0_iniA = Vgpz - T4 / C_fox ;
            Ps0_ini = Ps0_iniA ;
        end else begin
            //-----------------------------------*
            //* Strong inversion zone.
            //* - Ps0_iniB : upper bound.
            //*-----------------//
            T1 = 1.0 / cnst1SOI / cnstC_foxi ;
            T2 = T1 * (Vgpz - shift) * (Vgpz - shift) ;
            T3 = beta + 2.0 / (Vgpz - shift) ;
            Ps0_iniB = ln ( T2 ) / T3 ;
            `Fn_SUtemp( Ps0_ini , Ps0_iniA, Ps0_iniB, `c_ps0ini_2)
        end

        WdSOI = (Ps0_ini > 0.0) ? sqrt(`cnst_2esi_q * Ps0_ini / `N_sub_SOI) : 0.0 ;
        if (WdSOI < t_SOI) begin
            flg_depmode = 1 ; /* PD mode */
        end else begin
            flg_depmode = 2 ; /* FD mode */
        end
        if ( Vgs - shift <= Vth ) begin
            //-----------------------------------*
            //* Accumulation & Weak inversion zone.
            //*-----------------//
            T0 = 1.0 / C_fox ;
            T1 = t_SOI / `C_ESI ;
            T2 = 1.0 / C_box ;
            T3 = 1.0 / (T0 + T1 + T2) ;
            T4 = T3 * (Vgpz - Vbsbiz + (T2 + 0.5 * T1) * (-Q_s0_dep_ini)) ;
            Ps0_iniA = Vgpz - T4 / C_fox ;
            Ps0_ini = Ps0_iniA ;
        end else begin
            //---------------------------------------------------*
            //* Ps0_iniA: solution of subthreshold equation assuming zone-D1/D2.
            //*-----------------//
            // begin
            T0 = 1.0 / C_fox ;
            T1 = t_SOI / `C_ESI ;
            T2 = 1.0 / C_box ;
            T3 = 1.0 / (T0 + T1 + T2) ;
            T4 = T3 * (Vgpz - Vbsbiz + (T2 + 0.5 * T1) * (-Q_s0_dep_ini)) ;
            Ps0_iniA = Vgpz - T4 / C_fox ;
            // end
            Ps0_ini = Ps0_iniA ;

            if ( Vgpz - shift > 0 ) begin // for smoothing
                //---------------------------------------------------*
                //* Analytical initial guess.
                //*-----------------//
                //-------------------------------------------*
                //* Common part.
                //*-----------------//
                T1 = 1.0 / cnst1SOI / cnstC_foxi ;
                T2 = T1 * (Vgpz - shift) * (Vgpz - shift) ;
                T3 = beta + 2.0 / (Vgpz - shift) ;
                Ps0_iniB = ln (T2) / T3 ;
                `Fn_SU_CP(Ps0_ini, Ps0_iniA, Ps0_iniB * 0.98 , 0.4 , 2)
            end // End of smoothing
        end // End of FD

        //---------------------------------------------------*
        //* Assign initial guess.
        //*-----------------//
        phi_s0_SOI = Ps0_ini ;
        Psl_lim = Ps0_iniA ;
        // Initial guess for Ps0. (end) //

        // initial guess for phi_s0_bulk. (start) //
        T1 = phi_s0_SOI + 0.5 * Q_FD_SOI * C_soi_inv - Vbsbiz ; // A
        if (T1 < 0.0) begin
            // New equation.
            T2 = cnst0bulk * (C_box_inv + C_soi_inv) ;
            T2 = T2 * T2 ; // B
            T5 = -1.6 * T1 + 0.6 ; // D2
            T4 = 0.5 ;
            `Fn_SUtemp(T4, T4, T5, (T5*1e-3))
            T3 = T2 * T4 * beta2 ;
            phi_s0_bulk = ( T1 * ( 1.0 - sqrt( T3 ) ) ) / ( 1.0 - T3 );
        end else begin
            // Old equation
            T0 = cnst0bulk * cnst0bulk * C_box_FD_inv * C_box_FD_inv ;
            begin : phi_s0_bulk_newton
                T1 = -(Vbsbiz - phi_s0_SOI - Q_FD_SOI / 2 * t_SOI / `C_ESI) ;
                T2 = (2 * T1 + T0 * beta) * (2 * T1 + T0 * beta) - 4 * (T1 * T1 + T0) ;
                T2 = `Fn_Max(T2, `epsm10) ;
                T2 = sqrt(T2) ;
                T3 = 2 * T1 + T0 * beta ;
                psb_iniA = (T3 - T2) / 2 ;
                psb_iniB = ln (T1 * T1 / T0 / cnst1bulk) / (beta + 2.0 / T1) ;
                if (psb_iniA < Pb2_bulk) begin
                    phi_s0_bulk = psb_iniA ;
                end else begin
                    `Fn_SUtemp(phi_s0_bulk, psb_iniA, psb_iniB, `c_ps0ini_2)
                end
            end // phi_s0_bulk_ana
        end // End of Old Eq.
        // initial guess for phi_s0_bulk. (end) //

        // newton loop for phi_s0_bulk(start) //
        begin : phi_s0_bulk_itr
            for (lp_s0 = 0 ; lp_s0 < lp_s0_max ;  lp_s0 = lp_s0 + 1 ) begin
                T1 = cnst0bulk ;
                T2 = beta * phi_s0_bulk ;
                T3 = exp(-T2) ;
                if (phi_s0_bulk > `C_PHI_1_MINIMUM) begin
                    T0 = exp(beta * phi_s0_bulk) ;
                    T4 = -T1 * sqrt(T3 + T2 - 1 + cnst1bulk * (T0 - 1)) ;        //Qbulk
                    T5 = c0bulk / T4 * (-T3 + 1 + cnst1bulk * T0) ;      //dQbulk_dPsb
                end else if (phi_s0_bulk < -`C_PHI_1_MINIMUM) begin
                    T4 = T1 * sqrt(T3 + T2 - 1) ;        //Qbulk
                    T5 = c0bulk / T4 * (-T3 + 1) ;       //dQbulk_dPsb
                end else begin
                    T4 = -sqrt(c0bulk / beta) * beta * phi_s0_bulk ;     //Qbulk
                    T5 = -sqrt(c0bulk * beta) ;  //dQbulk_dPsb
                end
                `Fn_SZ_DX(T6, T4, Q_FD_dlt1, T7)
                `Fn_SU_DX(T6, T6, (-Q_FD_SOI), Q_FD_dlt2, T8)
                T7 = T7 * ( T5 * T8 ) ;
                phi_b_dep = T6 * T6 / 2.0 / `C_ESI / `C_QE / `N_sub_SOI ;
                phi_b_dep_dPsb = 2 * phi_b_dep * T7 / T6 ;

                T6 = (phi_s0_bulk -
                    (phi_s0_SOI - phi_s0_bulk + T4 / C_box + (T4 + Q_FD_SOI / 2) * t_SOI / `C_ESI - Vbsbiz +
                    phi_b_dep) / (-1 + T5 / C_box + T5 * t_SOI / `C_ESI + phi_b_dep_dPsb)) ;
                T7 = lp_s0 ;
                if (abs(T6 - phi_s0_bulk) < `ps_conv_ini) begin
                    lp_s0 = lp_s0_max ;
                end
                phi_s0_bulk = T6 ;
                Q_s0_bulk = T4 ;

                // T8 = Vbsbiz + phi_s0_bulk ;
                // T9 = T8 - Q_s0_bulk / C_box ;
            end
            // phi_s0_bulk = T8 ;
            phi_s0_bulk= Vbsbiz + phi_s0_bulk ;
            phi_b0_SOI = phi_s0_SOI + C_soi_inv * ( 0.5 * Q_FD_SOI + Q_s0_bulk ) ;
        end // phi_s0_bulk_itr
        // FD case(end) //
        // newton loop for phi_s0_bulk(end) //

        // end // End of Initial guess for Ps0s
        //-----------------------------------------------------------*
    end // HSOI_calc_ini

    if (COISUB == 1 &&(Vgs > Vgs_fb + 0.2)) begin
        //---------------------------------------------------*
        //*  Floating Body Effect(FBE) 081120  @@@ ***
        //----------------//

        vfbsub1 = vfbsub0 ;
        Vgpsub = Vgsz - vfbsub1 + dVth - dPpg ;

        sti2_dlt = SUBDLT ;

        //---------------------------------------------------*
        //***  Simplified Isub for FBE
        //*-----------------//

        //  Pseud Ids using STI model @@@ 081110 //
        Vgssti = Vgpsub ;
        costi0 = sqrt(2.0e0 * `C_QE * `N_sub_SOI * `C_ESI / beta) ;
        costi1 = Nin * Nin / `N_sub_SOI / `N_sub_SOI ;
        costi3 = costi0 * costi0 / C_fox / C_fox ;
        costi4 = costi3 * beta / 2.0e0 ;
        costi5 = costi4 * beta * 2.0e0 ;
        costi6 = sqrt(1.0e0 + 4.0e0 * (beta * Vgssti - 1.0e0) / costi5) ;
        Psasti = Vgssti + costi4 * (1.0e0 - costi6) ;
        Asti = 1.0e0 / costi1 / costi3 ;
        Psbsti = ln (Asti * (Vgssti * Vgssti)) / (beta + 2.0e0 / Vgssti) ;
        Psab = Psbsti - Psasti - sti2_dlt ;
        Psti = Psbsti - 0.5e0 * (Psab + sqrt(Psab * Psab + 4.0e0 * sti2_dlt * Psbsti)) ;

        expsti = exp(beta * Psti) ;
        sq1sti = (beta * Psti - 1.0e0 + costi1 * expsti) ;
        sq2sti = (beta * Psti - 1.0e0) ;
        if (sq1sti > 0 && sq2sti > 0) begin
            sq1sti = sqrt(beta * Psti - 1.0e0 + costi1 * expsti) ;
            sq2sti = sqrt(beta * Psti - 1.0e0) ;
            Qn0sti = costi0 * (sq1sti - sq2sti) ;
            costi7 = 2.0e0 * Weff / beta ;
            Mu = 300.0 * `C_cm2m_p2;
            Lred = 0.0 ;
            T1 = -expm1(-beta * Vdsz) ;    // expm1(x) = exp(x) - 1 //
            T2 = 1.0 / (Leff - Lred) ;
            Idssti = costi7 * Mu * Qn0sti * T1 * T2 ;
            Ids_isub = Idssti ;
            Ps0_isub = Psti ;

            //---------------------------------------------------*
            //* Pds calculation for Psl
            //*-----------------//
            TX = 1.0e0 + 4.0e0 * (beta * Vgpz - 1.0e0) / (fac1p2 * beta2) ;
            if ( TX < `epsm10 ) begin
                TX = `epsm10 ;
            end
            Ps0_iniA = Vgpz + fac1p2 * beta * 0.5 * (1.0e0 - sqrt(TX)) ;
            Psl_lim = Ps0_iniA ;

            //---------------------------------------------------*
            //* Analytical initial guess.
            //*-----------------//
            Pds_max = Ps0_iniA - Ps0_isub ;
            if ( Pds_max < 0.0e0 ) begin
                Pds_max = 0.0 ;
            end
            T5 = (1.0e0 + `c_pslini_1) * Pds_max ;
            T6 = T5 - Vdsz - `c_pslini_2 ;
            T7 = sqrt ( T6 *  T6 + 4.0 * ( T5 ) * ( `c_pslini_2 ) ) ;
            Pds_ini = ( T5 ) - 0.5 * ( T6 + T7 ) ;
            if (Pds_ini > Pds_max ) begin
                Pds_ini = Pds_max ;
            end
            Pds_qwe = Pds_ini ;

            begin : COIEVB_model_FB
                real EVB1_QE_WL , EVB1_QE_WL_p_Egp12 , Eevb_wo_Vox ;
                real reali, realN, r, Vox, d0, T0, T1, T2, T3, T4, T5, T6, T7, T8 ;
                real CGS_Tfox0, CGS_weff_nf, CGS_Leff;

                CGS_Tfox0 = Tfox0 * `C_m2cm;
                CGS_weff_nf = weff_nf * `C_m2cm;
                CGS_Leff = Leff * `C_m2cm;
                //---------------------------------------------------*
                //* Ievb induced by Fowler-Nordheim tunneling and direct tunneling
                //*------------------//
                if (COIEVB == 0) begin
                    Ievb = 0e0 ;
                end else begin
                    phib = 4.12 ;
                    // = sqrt( phib ) //
                    // = phib^(3/2) //
                    EVB1_QE_WL = EVB1 * `C_QE * CGS_weff_nf * CGS_Leff ;
                    EVB1_QE_WL_p_Egp12 = EVB1_QE_WL / Egp12 ;
                    Eevb_wo_Vox = -(FVBS * Vbspz + dVthSC + dVthLP + Eg + EVB3) / CGS_Tfox0 ;
                    for (i = 0 ; i <= `N - 1 ; i= i + 1) begin
                        reali = i ;
                        realN = `N ;
                        r =  reali / realN ;
                        Vox = Vgp + Vzadd - (Pds_qwe * r + Ps0_isub) ;
                        d0 = 1.0 - Vox / phib ;

                        // T2 = Eevb //
                        T2 = Eevb_wo_Vox + Vox / CGS_Tfox0 ;
                        T0 = T2 * T2 ;
                        `Fn_SZtemp(d0, d0, 1.0e-3)
                        T1 = EVB2 * (1.0 - sqrt(d0) * d0) ;
                        T3 = -T1 / T2 ;
                        if (T3 < -`EXP_THR) begin
                            T5 = 0.0 ;
                        end else begin
                            T5 = exp(T3) ;
                        end
                        T6 = EVB1_QE_WL_p_Egp12 ;
                        T7 = 0.25e0 * T6 * T1 * T1 * `c_exp_2 ;
                        if (2e0 * T2 + T1 < 0e0) begin
                            Ievb0 = T7 ;     // = 0.25e0 * T6 * T1 * T1 * c_exp_2 ; // minimum value //
                        end else begin
                            T4 = EVB1_QE_WL ;
                            T8 = T4 * T0 * T5 ;
                            if (T8 < T7 || T2 < 0e0) begin
                                Ievb0 = T7 ;   // 0.25e0 * T6 * T1 * T1 * c_exp_2 ; ///* minimum value */
                            end else begin
                                Ievb0 = T8 ;   // T4_0 * T0_0 * T5_0 ; //
                            end
                        end
                        Ievb = Ievb + Ievb0 ; // = Ievb + Ievb_0 ; //
                        if ( Ievb0 < `Ievb_min ) begin
                            i = `N ;  // break
                            lp_s0 = lp_s0_max ;
                        end
                    end
                end // End of COIEVB_model }
            end
            //---------------------------------------------------------//

            //-------------------------------------------*
            //* Conductive case.
            //*-----------------//
            begin : IsubModel_FB
                real T1, T2, T3, T4, T5, T6,T6w, T7, T8, T9;
                real Psislsat, Psisubsat;

                if (SUB1 <= 0.0 || MKS_VMAX <= 0.0) begin
                    Isub = 0.0 ;
                end else begin
                    if ( COSUBSCALE <= 0 ) begin //version 1.4.0:
                        // still compatible //
                        T1 = Vgpsub ;       //ina_fin //
                        T7 = C_fox * C_fox ;
                        T8 = qnsub_esi ;
                        T3 = T8 / T7 ;
                        T9 = 2.0 / T8 ;
                        T4 = T9 * T7 ;
                        T5 = T1 - beta_inv - `X_vbs * Vbspz ;
                        T6w = 1.0 + T4 * T5 ;
                        `Fn_SZtemp(T6, T6w, 1.0e-3)
                        T6 = T6 + `Small ;
                        T6 = sqrt(T6) ;
                        Psislsat = T1 * `X_vgs + T3 * (1.0 - T6) ;
                        Psisubsat = `X_vds * Vdsz + Ps0_isub - `X_slg * `Z_vgs * Psislsat ;  //ina_fin //
                        `Fn_SZtemp(Psisubsat, Psisubsat, 1.0e-2)     // @@@ //
                    end else begin //version 1.5.0:
                        T1 = vg2const * Vgpsub ;
                        T3 = qnsub_esi / (C_fox * C_fox) ;
                        T4 = 2.0 / qnsub_esi * (C_fox * C_fox) ;
                        T5 = T1 - beta_inv - xvbs * Vbspz ;
                        T6 = 1.0 + T4 * T5 ;
                        T7 = 2.0 * ( 1.0 + T4 ) ;
                        `Fn_SL_CP( T6 , T6 , `Small, T7 , 4 )
                        T6 = (T6 <=0 ) ? 0.0 : sqrt( T6 ) ;
                        Psislsat = T1 + T3 * ( 1.0 - T6 ) ;
                        T2 = LGLE / (xgate + LGLE) ;
                        Psisubsat = SVDS * Vdsz + Ps0z - T2 * Psislsat ;
                        `Fn_SZtemp(Psisubsat, Psisubsat, 1.0e-3)
                    end
                    Psisubsat = Psisubsat + `Small ; // @@@ //
                    T2 = exp(-`X_sub2 / Psisubsat) ;
                    Isub = `X_sub1 * Psisubsat * Ids_isub * T2 ;
                end            // end of !if( sub1 < 0 || vmax < 0 )  //
            end //
            // @@@  Qh vs Isub Calculation //
            begin : FBEmodel_FB
                real T1, T2, T4, T5, T6, T7, T8;

                if (COFBE == 1) begin
                    // The following values should not be hard-coded. //
                    T1 = `C_QE * t_SOI * weff_nf * exp(-beta * QHE2) ;  // Vbi => qhe2
                    T2 = `Lp * `Dn * `Nd + `Ln * `Dp * `N_sub_SOI ;
                    T4 = `Lp * `Ln / (T1 * T2) ;
                    nume = (Isub + Ievb) * T4 ;
                    T5 = QHE1 * beta_inv * log1p(nume) ; // qhe1 : fitting param
                    // Qb(Vb=Vbody) - Qb(Vb=0) //
                    T6 = sqrt(2 * `C_ESI * `C_QE * `N_sub_SOI * beta_inv) ;
                    T7 = sqrt(expm1(-beta * (Ps0_isub - T5)) + beta * (Ps0_isub - T5)) ;
                    T8 = sqrt(expm1(-beta * Ps0_isub) + beta * Ps0_isub) ;
                    Qhs = -T6 * (T7 - T8) ;
                    if (COHIST) begin
                        Rsb = HIST1 / (Isub + HIST2) ;
                        tauh = Rsb * C_fox ;
                        Qhs_prev = Qhs ;
                        Qhs_hist = `NQS_CAP * V(nqs_qhs) ;
                        Qhs      =  Qhs_hist ;
                        Iqh_nqs  = (Qhs_hist - Qhs_prev) / tauh ;
                    end //
                end else begin // Case for  W/O FBE //
                    Qhs = 0 ;
                end //
            end // FBEmodel
        end else begin   // sq1sti,sq2sti < 0 //
            Isub = 0.0 ;
            Qhs = 0 ;
        end

    end else begin      //  coisub==0 || Vgs > Vgs_fb + 0.2 //
        Isub = 0.0 ;
        Qhs = 0 ;
    end
    // End of Qh Calculation  //

    begin : Ps0_3_var_NewtonLoop
        real e0, T1, T2, T3, T4, T5 ;
        real Q_n0_dPss, Q_s0_bulk_dPsb ;
        real dPss, dPbs, dPsb, PF1,PF11,PF12,PF13, PF2,PF21,PF22,PF23, PF3,PF32,PF33;
        real PDJ, PDJI, PJI11,PJI12,PJI13,PJI21,PJI22,PJI23,PJI31,PJI32,PJI33;
        real TMF0 , T4_dPss ;

        //-----------------------------------------------------------*
        //*  Solve Poisson's equation for Ps0. (start)
        //*-----------------//
        // save the initial guesses for nonconverged cases //
        phi_s0_SOI_ini = phi_s0_SOI ;
        phi_b0_SOI_ini = phi_b0_SOI ;
        phi_s0_bulk_ini = phi_s0_bulk ;
        flg_conv = 0 ;
        flg_brk8 = 0 ;

        for (lp_s0 = 1 ; lp_s0 <= lp_s0_max ;  lp_s0 = lp_s0 + 1 ) begin

            T1 = phi_s0_bulk - (Vbsbiz) ;
            e0 = beta * (T1) ;
            T0 = exp(-e0) ;
            if (T1 < -`C_PHI_1_MINIMUM) begin
                Q_s0_bulk = cnst0bulk * sqrt(T0 + e0 - 1.0) ;
                Q_s0_bulk_dPsb = c0bulk * (-T0 + 1.0) / Q_s0_bulk ;
            end else if (T1 > `C_PHI_1_MINIMUM) begin
                T2 = exp(e0) ;
                Q_s0_bulk = -cnst0bulk * sqrt(T0 + e0 - 1.0 + cnst1bulk * (T2 + e0 - 1.0)) ;
                Q_s0_bulk_dPsb = c0bulk * (-T0 + 1.0 + cnst1bulk * (T2 + 1) ) / Q_s0_bulk ;
            end else begin
                Q_s0_bulk = -cnst0bulk* e0 ;
                Q_s0_bulk_dPsb = -cnst0bulk * beta ;
            end

            // Eval_calc_Q_n0 (begin)
            Q_s0_dep = Q_s0_dep_ini ;
            e0 = beta * phi_s0_SOI ;
            T5 = exp(beta * phi_s0_SOI) ;
            T3 = 1.0 ; // = exp(beta * phi_b0_SOI) ;
            T4 = sqrt(Q_s0_dep * Q_s0_dep /(cnst0SOI * cnst0SOI) + 2 * cnst1SOI * (T5 + e0 - T3)) ;
            T4_dPss = (   2 * beta * cnst1SOI * (T5 + 1) )/( 2 * T4 ) ;
            Q_n0 = -cnst0SOI * T4 - Q_s0_dep ;
            Q_n0_dPss = - cnst0SOI * T4_dPss ;

            // Eval_calc_Q_b0_dep (begin)
            T1 = (phi_b0_SOI - phi_s0_SOI) /QDEPB_DLT ;
            e0 = beta * (T1) ;
            `Fn_DExp(T0, -e0, T6)
            T0 = exp(-e0) ;
            T2 = sqrt(T0 + e0 - 1.0) ;
            if (T1 < -`C_PHI_1_MINIMUM) begin
                Q_b0_dep = cnst0SOI * T2 ;
                Q_b0_dep_dPbs = cnst0SOI * beta * (-T6 + 1.0) / (2 * T2) /QDEPB_DLT ;
                Q_b0_dep_dPss = - Q_b0_dep_dPbs ;
            end else if (T1 > `C_PHI_1_MINIMUM) begin
                Q_b0_dep = -cnst0SOI * T2 ;
                Q_b0_dep_dPbs = -cnst0SOI * beta * (-T6 + 1.0) / (2 * T2) /QDEPB_DLT ;
                Q_b0_dep_dPss = - Q_b0_dep_dPbs ;
            end else begin
                Q_b0_dep = -cnst0SOI * e0 / `C_SQRT_2 ;
                Q_b0_dep_dPbs = -cnst0SOI *  beta / `C_SQRT_2 ;
                Q_b0_dep_dPss = - Q_b0_dep_dPbs ;
            end
            `Fn_SU_CP_DX(Q_b0_dep, Q_b0_dep , 0, -Q_WdSOI_max*`QDEP_DLT2 , `QDEP_PW , T0)
            Q_b0_dep_dPbs = Q_b0_dep_dPbs * T0 ;
            Q_b0_dep_dPss = Q_b0_dep_dPss * T0 ;
            `Fn_SL_CP_DX(Q_b0_dep, Q_b0_dep , (Q_FD_SOI-Q_s0_dep), -(Q_FD_SOI-Q_s0_dep)*`QDEP_DLT2 , `QDEP_PW , T0)
            Q_b0_dep_dPss = Q_b0_dep_dPss * T0 ;
            Q_b0_dep_dPbs = Q_b0_dep_dPbs * T0 ;

            // Eval_calc_Q_b0_dep (end)

            Q_dep0 = Q_s0_dep + Q_b0_dep ;

            if ( flg_conv == 1 ) begin
                flg_brk8 = lp_s0;
                lp_s0 = lp_s0_max ;
            end else begin

                PF1 = phi_s0_SOI - Vgpz - C_fox_inv * (Q_s0_bulk + Q_s0_dep + Q_n0 + Q_b0_dep + Qhs) ;       // @@@ //
                PF11 = 1.0 - C_fox_inv * (Q_n0_dPss + Q_b0_dep_dPss ) ;
                PF12 =     - C_fox_inv * (          + Q_b0_dep_dPbs ) ;
                PF13 =     - C_fox_inv * (Q_s0_bulk_dPsb ) ;

                T1 = phi_s0_SOI + C_soi_inv * (0.5 * Q_FD_SOI + Q_s0_bulk ) ;
                T3 = C_soi_inv * Q_s0_bulk_dPsb ;
                PF2 = phi_b0_SOI - T1 ;
                PF21 = -1.0 ;
                PF22 =  1.0 ;
                PF23 = -T3 ;

                PF3 = phi_s0_bulk - phi_b0_SOI - C_box_inv * Q_s0_bulk ;
                PF32 = -1.0 ;
                PF33 = 1.0 - C_box_inv * Q_s0_bulk_dPsb ;

                // assuming PF31=0 //
                PDJ = PF11 * PF22 * PF33 - PF11 * PF23 * PF32 - PF12 * PF21 * PF33 + PF13 * PF21 * PF32 ;
                PDJI = 1.0 / (PDJ + `Small) ;
                PJI11 = PF22 * PF33 - PF23 * PF32 ;
                PJI12 = PF13 * PF32 - PF12 * PF33 ;
                PJI13 = PF12 * PF23 - PF13 * PF22 ;
                PJI21 = -PF21 * PF33 ;
                PJI22 = PF11 * PF33 ;
                PJI23 = PF13 * PF21 - PF11 * PF23 ;
                PJI31 = PF21 * PF32 ;
                PJI32 = -PF11 * PF32 ;
                PJI33 = PF11 * PF22 - PF12 * PF21 ;

                dPss = -PDJI * (PJI11 * PF1 + PJI12 * PF2 + PJI13 * PF3) ;
                dPbs = -PDJI * (PJI21 * PF1 + PJI22 * PF2 + PJI23 * PF3) ;
                dPsb = -PDJI * (PJI31 * PF1 + PJI32 * PF2 + PJI33 * PF3) ;

                /* New PS convergence method */
                T1 = abs(dPss) ;
                if (T1 < abs(dPbs)) T1 = abs(dPbs) ;
                if (T1 < abs(dPsb)) T1 = abs(dPsb) ;
                scale_fac=1.0 ;
                if (lp_s0 > 80) begin
                    scale_fac = 125.0 ;
                end else if (lp_s0 > 40) begin
                    scale_fac = 125.0 ;
                end else if (lp_s0 > 20) begin
                    scale_fac = 25.0 ;
                end else if (lp_s0 > 10) begin
                    scale_fac = 5.0 ;
                end

                if (T1 > `dP_max/scale_fac) begin
                    dPss = dPss * ( `dP_max/scale_fac / T1 ) ;
                    dPbs = dPbs * ( `dP_max/scale_fac / T1 ) ;
                    dPsb = dPsb * ( `dP_max/scale_fac / T1 ) ;
                end
                phi_s0_SOI = phi_s0_SOI + dPss ;
                phi_b0_SOI = phi_b0_SOI + dPbs ;
                phi_s0_bulk = phi_s0_bulk + dPsb ;

                PSCONV_3D = `ps_conv * scale_fac * `PSCONVFAC ;
                if (T1 < PSCONV_3D) begin
                    flg_conv = 1 ;
                end

            end  // End of flg_brk8

        end // end of Ps0 3Newton loop with lp_s0   //

        lp_s0 = (flg_brk8 > 0) ? flg_brk8 : lp_s0 ;

        //  Solve Poisson's equation for Ps0. (end) //

        if (flg_conv == 0) begin    // reset to the initial guesses in nonconvergent cases //
            phi_s0_SOI = phi_s0_SOI_ini ;
            phi_b0_SOI = phi_b0_SOI_ini ;
            phi_s0_bulk = phi_s0_bulk_ini ;
        end

        //-------------------------------------------*
        //Procedure for diverged case.
        //----------------//
        Ps0 = phi_s0_SOI ;
        Qn0 = -Q_n0 ;
        if (Qn0 <= `Small) begin
            Qn0 = `Small ;
        end

        flg_conv_0 = flg_conv ; // for Ps0 only.

    end // Ps0_3_var_NewtonLoop

    //---------------------------------------------------*
    //    VgVt : Vgp - Vth_qi. ( Vth_qi is Vth for Qi evaluation. )
    //    ----------------//
    VgVt = Qn0 * C_fox_inv ;

    //-----------------------------------------------------------*
    //make Qi=Qd=Ids=0 if VgVt <= VgVt_Small
    //N.B.: Out of consideration.
    //----------------//
    if (phi_s0_SOI <= 0.0 && flg_skipAcc) begin
        // Accumulation Zone(start) //
        flg_depmode_d = flg_depmode ;
        T0 = -weffcv_nf * Leff_cv ; // 20180718
        Q_sL_dep = Q_s0_dep_ini ;
        Q_bL_dep = Q_b0_dep ;
        Q_depL = Q_sL_dep + Q_bL_dep ;
        Qbu = - 0.5 * (Q_depL + Q_dep0);
        Qb = T0 * Qbu ;
        Qd_FB = Qb * `C_QBRAT ;
        Qs_FB = Qb * (1.0 - `C_QBRAT) ;

        Qi = 0.0 ;
        Qsub = Q_s0_bulk * Leff_cv * weffcv_nf ; // 20180718
        Qd = 0.0 ;
        Ids = 0.0 ;
        VgVt = 0.0 ;
        flg_noqi = 1 ;
        phi_sL_SOI = phi_s0_SOI ;
        phi_bL_SOI = phi_b0_SOI ;
        phi_sL_bulk = phi_s0_bulk ;
        Q_sL_bulk = Q_s0_bulk ;
        Psl = Ps0 ;
        Psdl = Psl ;
        flg_conv_L = 0 ;
    end
    else begin

        // Vdseff(begin) //
        begin : SetVdseffFB
            real T1, T2, T3, T4, T6, T7, T10;

            Vdsorg = Vds ;
            T10 = `Small ;
            T2 = qnsub_esi / (C_fox * C_fox) ;
            T4 = 1.0e0 + 2.0e0 / T2 * ( Vgp -  T10 ) ;
            T5 = 1.0e0 + 2.0e0 / T2 ;
            `Fn_SL_CP( T4 , T4 , 0, T5 , 4 )
            T3 = sqrt(T4) ;
            T10 = Vgp + T2 * ( 1.0 - T3 )  ;
            `Fn_SZtemp(T10, T10, 0.01)
            Vdsat = T10 ;
            T1 = Vds / T10 ;
            T2 = `Fn_Pow(T1, DDLTe - 1.0e0) ;
            T7 = T2 * T1 ;
            T3 = 1.0 + T7 ;
            T4 = `Fn_Pow(T3, 1.0 / DDLTe - 1.0) ;
            T6 = T4 * T3 ;
            Vdseff = Vds / T6 ;
            Vds = Vdseff  ;
        end // SetVdseff
        // Vdseff(end) //

        //---------------------------------------------------*
        //* Skip Psl calculation when Vds is very Small.
        //*-----------------//
        if (Vds < 0.0) begin
            Psl = Ps0 ;
            Pds = Psl - Ps0 ;
            phi_sL_SOI = Psl ;
            phi_bL_SOI = phi_b0_SOI ;
            phi_sL_bulk = phi_s0_bulk ;
            flg_conv = 1 ;
            flg_depmode_d = flg_depmode ;
        end else begin

            //-----------------------------------------------------------*
            //* Initial Guess for Drain Side.
            //*-----------------//
            if ( flg_pprv >= 1 ) begin
                phi_sL_SOI  = Pssl_ini ;
                phi_bL_SOI  = Pbsl_ini ;
                phi_sL_bulk = Psbl_ini ;
                flg_depmode_d = (phi_sL_SOI < FD_end) ? 1 : 2 ;
            end else begin

                //-----------------------------------------------------------*
                //* Initial guess of  Psl(start)
                //*-----------------//

                //---------------------------------------------------*
                //* Analytical initial guess.
                //*-----------------//
                Pds_max = `Fn_Max(Psl_lim - phi_s0_SOI, 0.0) ;
                `Fn_SUtemp(Pds_ini, Vds, (1.0e0 + `c_pslini_1) * Pds_max, `c_pslini_2)
                Pds_ini = `Fn_Min(Pds_ini, Pds_max) ;
                if (Pds_ini < 0.0) Pds_ini = 0.0 ;
                else if (Pds_ini > Vds) Pds_ini = Vds ;

                //---------------------------------------------------*
                //* Assign initial guess.
                //*-----------------//
                Pds = Pds_ini ;
                Psl = phi_s0_SOI + Pds ;
                phi_sL_SOI = Psl ;

                // Initial guess of  Psl(end) //

                // initial value for phi_sL_bulk(start) //
                begin : InitialValueForPhiSLBulk
                    real T0, T1, T2, T3, psb_iniA, psb_iniB;

                    phi_b_dep = phi_b_dep0 ;
                    T0 = cnst0bulk * cnst0bulk * C_box_FD_inv * C_box_FD_inv ;
                    if (phi_sL_SOI < FD_end) begin
                        T1 = -(Vbsbiz) ;
                        T2 = (2 * T1 + T0 * beta) * (2 * T1 + T0 * beta) - 4 * (T1 * T1 + T0) ;
                        T2 = `Fn_Max(T2, `epsm10) ;
                        T2 = sqrt(T2) ;
                        T3 = 2 * T1 + T0 * beta ;
                        psb_iniA = (T3 - T2) / 2 ;
                        psb_iniB = ln (T1 * T1 / T0 / cnst1bulk) / (beta + 2.0 / T1) ;
                        if (psb_iniA < Pb2_bulk) begin
                            phi_sL_bulk = psb_iniA ;
                        end else begin
                            `Fn_SUtemp(phi_sL_bulk, psb_iniA, psb_iniB, `c_ps0ini_2)
                        end
                    end else begin
                        T1 = -(Vbsbiz - phi_sL_SOI - Q_FD_SOI / 2 * t_SOI / `C_ESI) ;
                        T2 = (2 * T1 + T0 * beta) * (2 * T1 + T0 * beta) - 4 * (T1 * T1 + T0) ;
                        T2 = `Fn_Max(T2, `epsm10) ;
                        T2 = sqrt(T2) ;
                        T3 = 2 * T1 + T0 * beta ;
                        psb_iniA = (T3 - T2) / 2 ;
                        psb_iniB = ln (T1 * T1 / T0 / cnst1bulk) / (beta + 2.0 / T1) ;
                        if (psb_iniA < Pb2_bulk) begin
                            phi_sL_bulk = psb_iniA ;
                        end else begin
                            `Fn_SUtemp(phi_sL_bulk, psb_iniA, psb_iniB, `c_ps0ini_2)
                        end
                    end
                end // InitialValueForPhiSLBulk
                // initial value for phi_sL_bulk(end) //

                // newton loop for phi_sL_bulk(start) //
                begin : NewtonLoopForPhiSLBulk
                    real T0, T1, T2, T3, T4, T5, T6, T7;
                    T0 = `cnst_2esi_q * phi_sL_SOI / `N_sub_SOI;
                    if (T0 > 0) begin
                        WdSOI = sqrt(`cnst_2esi_q * phi_sL_SOI / `N_sub_SOI) ;
                    end else begin
                        WdSOI = 0;
                    end
                    if (phi_sL_SOI < FD_end && 0) begin
                        flg_depmode_d = 1 ;      // PD //
                        for (lp_sl = 0 ; lp_sl < lp_sl_max ; lp_sl= lp_sl + 1) begin
                            T1 = cnst0bulk ;
                            T2 = beta * phi_sL_bulk ;
                            T3 = exp(-T2) ;
                            if (phi_sL_bulk > `C_PHI_1_MINIMUM) begin
                                T0 = exp(beta * phi_sL_bulk) ;
                                T4 = -T1 * sqrt(T3 + T2 - 1 + cnst1bulk * (T0 - 1)) ;
                                T5 = c0bulk / T4 * (-T3 + 1 + cnst1bulk * (T0)) ;
                            end else if (phi_sL_bulk < -`C_PHI_1_MINIMUM) begin
                                T4 = T1 * sqrt(T3 + T2 - 1) ;
                                T5 = c0bulk / T4 * (-T3 + 1) ;
                            end else begin
                                T4 = -sqrt(c0bulk / beta) * beta * phi_sL_bulk ;
                                T5 = -sqrt(c0bulk * beta) ;
                            end
                            `Fn_SZ_DX(T6, T4, Q_FD_dlt1, T7)
                            `Fn_SU_DX(T6, T6, (-Q_FD_SOI), Q_FD_dlt2, T8)
                            T7 = T7 * ( T5 * T8 ) ;
                            phi_b_dep = T6 * T6 / 2.0 / `C_ESI / `C_QE / `N_sub_SOI ;
                            phi_b_dep_dPsb = 2 * phi_b_dep * T7 / T6 ;

                            T6 = phi_sL_bulk - ((-phi_sL_bulk + T4 / C_box - Vbsbiz + phi_b_dep)
                                / (-1 + T5 / C_box + phi_b_dep_dPsb)) ;
                            if (abs(T6 - phi_sL_bulk) < `ps_conv) begin
                                lp_sl = lp_sl_max ;
                            end
                            phi_sL_bulk = T6 ;
                            Q_sL_bulk = T4 ;
                        end
                        phi_sL_bulk = Vbsbiz + phi_sL_bulk ;
                        phi_bL_SOI = phi_sL_bulk - Q_sL_bulk / C_box ;
                    end else begin
                        flg_depmode_d = 2 ;      // FD //
                        for (lp_sl = 0 ; lp_sl < lp_sl_max ; lp_sl= lp_sl + 1) begin
                            T1 = cnst0bulk ;
                            T2 = beta * phi_sL_bulk ;
                            T3 = exp(-T2) ;
                            if (phi_sL_bulk > `C_PHI_1_MINIMUM) begin
                                T0 = exp(beta * phi_sL_bulk) ;
                                T4 = -T1 * sqrt(T3 + T2 - 1 + cnst1bulk * (T0 - 1)) ;
                                T5 = c0bulk / T4 * (-T3 + 1 + cnst1bulk * (T0)) ;
                            end else if (phi_sL_bulk < -`C_PHI_1_MINIMUM) begin
                                T4 = T1 * sqrt(T3 + T2 - 1) ;
                                T5 = c0bulk / T4 * (-T3 + 1) ;
                            end else begin
                                T4 = -sqrt(c0bulk / beta) * beta * phi_sL_bulk ;
                                T5 = -sqrt(c0bulk * beta) ;
                            end
                            `Fn_SZ_DX(T6, T4, Q_FD_dlt1, T7)
                            `Fn_SU_DX(T6, T6, (-Q_FD_SOI), Q_FD_dlt2, T8)
                            T7 = T7 * ( T5 * T8 ) ;
                            phi_b_dep = T6 * T6 / 2.0 / `C_ESI / `C_QE / `N_sub_SOI ;
                            phi_b_dep_dPsb = 2 * phi_b_dep * T7 / T6 ;

                            T6 = (phi_sL_bulk -
                                (phi_sL_SOI - phi_sL_bulk + T4 / C_box + (T4 + Q_FD_SOI / 2) * t_SOI / `C_ESI - Vbsbiz +
                                phi_b_dep) / (-1 + T5 / C_box + T5 * t_SOI / `C_ESI + phi_b_dep_dPsb)) ;
                            if (abs(T6 - phi_sL_bulk) < `ps_conv) begin
                                lp_sl = lp_sl_max ;
                            end
                            phi_sL_bulk = T6 ;
                            Q_sL_bulk = T4 ;
                        end
                        phi_sL_bulk = Vbsbiz + phi_sL_bulk ;
                        phi_bL_SOI = phi_sL_bulk - Q_sL_bulk / C_box ;
                    end // else: !if(phi_sL_SOI < FD_end)
                end // NewtonLoopForPhiSLBulk
                if (phi_bL_SOI < 0) begin
                    phi_bL_SOI = 0 ;
                end

            end // End of Initial guess For Psls
            //-----------------------------------------------------------*

            // newton loop for phi_sL_bulk(end) //
        end // end of start_of_loopl;

        begin : Psl_3_var_NewtonLoop
            real eL, T1, T2, T3, T4, T5 ;
            real Q_nL_dPss, Q_sL_bulk_dPsb ;
            real dPss, dPbs, dPsb, PF1,PF11,PF12,PF13, PF2,PF21,PF22,PF23, PF3,PF32,PF33;
            real PDJ, PDJI, PJI11,PJI12,PJI13,PJI21,PJI22,PJI23,PJI31,PJI32,PJI33;
            real TMF0 , T4_dPss ;

            //-----------------------------------------------------------*
            //*  Solve Poisson's equation for Psl. (start)
            //*-----------------//

            if (phi_s0_SOI < 0.0 ) begin
                phi_sL_SOI = phi_s0_SOI ;
            end
            if (phi_bL_SOI < 0.01 ) begin
                phi_bL_SOI = phi_sL_SOI + C_soi_inv * ( 0.5 * Q_FD_SOI + Q_s0_bulk ) ;
            end

            //
            // start_of_sL_loop:
            // save the initial guesses for nonconverged cases //
            phi_sL_SOI_ini = phi_sL_SOI ;
            phi_bL_SOI_ini = phi_bL_SOI ;
            phi_sL_bulk_ini = phi_sL_bulk ;
            flg_conv = 0 ; flg_brk8 = 0 ;

            for (lp_sl = 1 ; lp_sl <= lp_sl_max ;  lp_sl = lp_sl + 1 ) begin

                T1 = phi_sL_bulk - (Vbsbiz) ;
                eL = beta * (T1) ;
                T0 = exp(-eL) ;
                if (T1 < -`C_PHI_1_MINIMUM) begin
                    Q_sL_bulk = cnst0bulk * sqrt(T0 + eL - 1.0) ;
                    Q_sL_bulk_dPsb = c0bulk * (-T0 + 1.0) / Q_sL_bulk ;
                end else if (T1 > `C_PHI_1_MINIMUM) begin
                    T2 = exp(eL) ;
                    Q_sL_bulk = -cnst0bulk * sqrt(T0 + eL - 1.0 + cnst1bulk * (T2 + eL - 1.0)) ;
                    Q_sL_bulk_dPsb = c0bulk * (-T0 + 1.0 + cnst1bulk * (T2 + 1)) / Q_sL_bulk ;
                end else begin
                    Q_sL_bulk = -cnst0bulk* eL ;
                    Q_sL_bulk_dPsb = -cnst0bulk *  beta ;  // minor bug-fix //
                end

                // Eval_calc_Q_nL (begin)
                Q_sL_dep = Q_s0_dep_ini ;
                T5 = exp(beta * (phi_sL_SOI - Vds)) ;
                T3 = 1.0 ; // = exp(beta * (phi_bL_SOI - Vds)) ;
                T4 = sqrt(Q_sL_dep * Q_sL_dep /(cnst0SOI * cnst0SOI) + 2 * cnst1SOI * (T5 + eL - T3)) ;
                T4_dPss = (   2 * beta * cnst1SOI * (T5 +1) )/( 2 * T4 ) ;
                Q_nL = -cnst0SOI * T4 - Q_sL_dep ;
                Q_nL_dPss = - cnst0SOI * T4_dPss ;
                // Eval_calc_Q_nL (end)

                // Eval_calc_Q_bL_dep (begin)
                T1 = (phi_bL_SOI - phi_sL_SOI) /QDEPB_DLT ;
                eL = beta * (T1) ;
                `Fn_DExp(T0, -eL, T6)
                T2 = sqrt(T0 + eL - 1.0) ;
                if (T1 < -`C_PHI_1_MINIMUM) begin
                    Q_bL_dep = cnst0SOI * T2 ;
                    Q_bL_dep_dPbs = cnst0SOI * beta * (-T6 + 1.0) / (2 * T2) /QDEPB_DLT ;
                    Q_bL_dep_dPss = - Q_bL_dep_dPbs ;
                end else if (T1 > `C_PHI_1_MINIMUM) begin
                    Q_bL_dep = -cnst0SOI * T2 ;
                    Q_bL_dep_dPbs = -cnst0SOI * beta * (-T6 + 1.0) / (2 * T2) /QDEPB_DLT ;
                    Q_bL_dep_dPss = - Q_bL_dep_dPbs ;
                end else begin
                    Q_bL_dep = -cnst0SOI * eL / `C_SQRT_2 ;
                    Q_bL_dep_dPbs = -cnst0SOI *  beta / `C_SQRT_2 ;
                    Q_bL_dep_dPss = - Q_bL_dep_dPbs ;
                end
                `Fn_SU_CP_DX(Q_bL_dep,  Q_bL_dep , 0, -Q_WdSOI_max*`QDEP_DLT2 , `QDEP_PW , T0)
                Q_bL_dep_dPbs = Q_bL_dep_dPbs * T0 ;
                Q_bL_dep_dPss = Q_bL_dep_dPss * T0 ;
                `Fn_SL_CP_DX(Q_bL_dep, Q_bL_dep , (Q_FD_SOI-Q_sL_dep), -(Q_FD_SOI-Q_sL_dep)*`QDEP_DLT2 , `QDEP_PW , T0)
                Q_bL_dep_dPss = Q_bL_dep_dPss * T0 ;
                Q_bL_dep_dPbs = Q_bL_dep_dPbs * T0 ;
                // Eval_calc_Q_bL_dep (end)

                Q_depL = Q_sL_dep + Q_bL_dep ;

                if ( flg_conv == 1 && lp_sl > 3) begin
                    flg_brk8 = lp_sl;
                    lp_sl = lp_sl_max ;
                end else begin

                    PF1 = phi_sL_SOI - Vgpz - C_fox_inv * (Q_sL_bulk + Q_sL_dep + Q_nL + Q_bL_dep + Qhs) ;       // @@@ //
                    PF11 = 1.0 - C_fox_inv * (Q_nL_dPss + Q_bL_dep_dPss) ;
                    PF12 =     - C_fox_inv * (            Q_bL_dep_dPbs) ;
                    PF13 =     - C_fox_inv * (Q_sL_bulk_dPsb ) ;

                    T1 = phi_sL_SOI + C_soi_inv * (0.5 * Q_FD_SOI + Q_sL_bulk ) ;
                    T3 = C_soi_inv * Q_sL_bulk_dPsb ;
                    PF2 = phi_bL_SOI - T1 ;
                    PF21 = -1.0 ;
                    PF22 =  1.0 ;
                    PF23 = -T3 ;

                    PF3 = phi_sL_bulk - phi_bL_SOI - C_box_inv * Q_sL_bulk ;
                    PF32 = -1.0 ;
                    PF33 = 1.0 - C_box_inv * Q_sL_bulk_dPsb ;

                    // assuming PF31=0 //
                    PDJ = PF11 * PF22 * PF33 - PF11 * PF23 * PF32 - PF12 * PF21 * PF33 + PF13 * PF21 * PF32 ;
                    PDJI = 1.0 / (PDJ + `Small) ;
                    PJI11 = PF22 * PF33 - PF23 * PF32 ;
                    PJI12 = PF13 * PF32 - PF12 * PF33 ;
                    PJI13 = PF12 * PF23 - PF13 * PF22 ;
                    PJI21 = -PF21 * PF33 ;
                    PJI22 = PF11 * PF33 ;
                    PJI23 = PF13 * PF21 - PF11 * PF23 ;
                    PJI31 = PF21 * PF32 ;
                    PJI32 = -PF11 * PF32 ;
                    PJI33 = PF11 * PF22 - PF12 * PF21 ;

                    dPss = -PDJI * (PJI11 * PF1 + PJI12 * PF2 + PJI13 * PF3) ;
                    dPbs = -PDJI * (PJI21 * PF1 + PJI22 * PF2 + PJI23 * PF3) ;
                    dPsb = -PDJI * (PJI31 * PF1 + PJI32 * PF2 + PJI33 * PF3) ;

                    /* New PS convergence method */
                    T1 = abs(dPss) ;
                    if (T1 < abs(dPbs)) T1 = abs(dPbs) ;
                    if (T1 < abs(dPsb)) T1 = abs(dPsb) ;
                    scale_fac=1.0 ;
                    if (lp_sl > 80) begin
                        scale_fac = 125.0 ;
                    end else if (lp_sl > 40) begin
                        scale_fac = 125.0 ;
                    end else if (lp_sl > 20) begin
                        scale_fac = 25.0 ;
                    end else if (lp_sl > 10) begin
                        scale_fac = 5.0 ;
                    end

                    if (T1 > `dP_max/scale_fac) begin
                        dPss = dPss * ( `dP_max/scale_fac / T1 ) ;
                        dPbs = dPbs * ( `dP_max/scale_fac / T1 ) ;
                        dPsb = dPsb * ( `dP_max/scale_fac / T1 ) ;
                    end
                    phi_sL_SOI = phi_sL_SOI + dPss ;
                    phi_bL_SOI = phi_bL_SOI + dPbs ;
                    phi_sL_bulk = phi_sL_bulk + dPsb ;

                    PSCONV_3D = `ps_conv * scale_fac * `PSCONVFAC ;
                    if (T1 < PSCONV_3D) begin
                        flg_conv = 1 ;
                    end

                end  // End of flg_brk8

            end // end of Psl 3Newton loop with lp_sl   //

            lp_sl = (flg_brk8 > 0) ? flg_brk8 : lp_sl ;

            //  Solve Poisson's equation for Psl. (end) //
            if (flg_conv == 0) begin    // reset to the initial guesses in nonconvergent cases //
                phi_sL_SOI = phi_sL_SOI_ini ;
                phi_bL_SOI = phi_bL_SOI_ini ;
                phi_sL_bulk = phi_sL_bulk_ini ;
            end

            //-------------------------------------------*
            //Procedure for diverged case.
            //----------------//
            Psl = phi_sL_SOI ;

            flg_conv_L = flg_conv ; // for Psl only.

        end // Psl_3_var_NewtonLoop

        // Vdseff //
        Vds = Vdsorg ;

`ifndef DISABLE_COPPRV
        //-----------------------------------------------------------*
        //Restore values for next calculation.
        //----------------//
        if ( COPPRV && ( flg_conv_0 + flg_conv_L == 2 )) begin
            //Activate COPPRV only when iteration has been successful on both sides (source and drain).
            // Confined biases //
            if ( called >= 1 ) begin
                vbsc_prv2 = vbsc_prv ;
                vdsc_prv2 = vdsc_prv ;
                vgsc_prv2 = vgsc_prv ;
                mode_prv2 = mode_prv ;
            end
            vbsc_prv = Vbsc ;
            vdsc_prv = Vdsc ;
            vgsc_prv = Vgsc ;
            mode_prv = mode ;
            // Surface potentials //
            pss0_prv = phi_s0_SOI ;
            pbs0_prv = phi_b0_SOI ;
            psb0_prv = phi_s0_bulk ;
            pssl_prv = phi_sL_SOI ;
            pbsl_prv = phi_bL_SOI ;
            psbl_prv = phi_sL_bulk ;
        end // (COPPRV)
`endif // COPPRV

        if ( phi_s0_SOI < 0.0 ) begin
            flg_noqi = 1 ;
        end

        // start_of_calIdd:
        //---------------------------------------------------*
        //----------------//
        Ps0s = phi_s0_SOI  ;
        PsLs = phi_sL_SOI  ;
        Pds  = PsLs - Ps0s ;
        Ps0b = phi_s0_bulk ;
        C_S_inv = WdSOI / `C_ESI ;    // C_S_inv=1/C_SOI and except infinity of C_SOI. //

        begin : newIddModel

            //---------------------------------------------------*
            //*  Idd(Front)
            //*-----------------//
            //-------------- Idd by front carrier --------------*
            // the 1st term of Iddf //
            Idd  = (Q_nL - Q_n0) - beta * (Q_nL + Q_n0) * (PsLs - Ps0s) * 0.5 ;
            if (Idd < 0.0 || Vds == 0.0) Idd = 0.0 ;
            //---------- End of Idd by front carrier -----------*

        end // newIddModel

        //---------------------------------------------------*
        //* Qbu : -Qb in unit area.
        //*-----------------//
        Qbu = -0.5 * (Q_depL + Q_dep0) ;

        //-----------------------------------------------------------*
        //* Alpha(=eta) : parameter to evaluate charges.
        //*-----------------//
        RRR_P0 = phi_sL_SOI - phi_s0_SOI ;
        RRR_P0 = RRR_P0 + `ps_conv ;
        RRR_CSOI_Cbox = C_box / (C_box * C_S_inv + 1.0) ;
        RRR_B = ((Q_sL_bulk) * (Q_sL_bulk) - (Q_s0_bulk) * (Q_s0_bulk)) / (RRR_CSOI_Cbox) ;
        `Fn_SL_CP(T1, -RRR_B, 0, Q_FD_SOI * 1e-5 , `QDEP_PW )
        RRR_B = -T1 ;

        if (beta *(Ps0b) - 1.0 > 0.0) begin
            T1 = sqrt(beta * (Ps0b) - 1.0) ;
        end
        RRR_CC = -(Q_nL - Q_n0) ;
        `Fn_SL_CP(RRR_CC, RRR_CC, 0, Q_FD_SOI * 1e-5 , `QDEP_PW )

        RRR_alpha_SOI = 1.0 + 2.0 * (-RRR_CC) / (beta * C_fox * RRR_P0 * RRR_P0) ;
        T1 = RRR_P0 * RRR_P0 * RRR_P0 * RRR_P0 ;
        RRR_DD = RRR_alpha_SOI * RRR_P0 ;
        RRR_eta = 1.0 - RRR_DD / VgVt ;
        `Fn_SL_CP(RRR_eta, RRR_eta, 0, 1e-5 , `QDEP_PW )
        Alpha = RRR_eta ;

        // start_of_charges:

        //-----------------------------------------------------------*
        //* Qiu : -Qi in unit area.
        //*-----------------//
        Qinm = 1.0 + Alpha * (1.0 + Alpha) ;
        Qidn = `Fn_Max(1.0 + Alpha, `epsm10) ;

        Qiu  = - 0.5 * (Q_n0 + Q_nL) ;

    end // end if(end_of_part_1==0)

    if (flg_info >= 1) begin
        if (flg_depmode == 1 && flg_depmode_d == 2) begin
            $write("Note: source is PD, but drain is FD.\n") ;
        end
        if (flg_depmode == 2 && flg_depmode_d == 1) begin
            $write("Warning: source is FD, but drain is PD!\n") ;
        end
    end

end //  HSOI_calc_Phis_FB

if (flg_conv_0 == 0) begin
    $write("*** warning(HiSIM_SOI): Went Over Iteration Maximum(%M:Ps0): \n") ;
end
if (flg_conv_L == 0) begin
    $write("*** warning(HiSIM_SOI): Went Over Iteration Maximum(%M:Psl): \n") ;
end
if (flg_conv_0+flg_conv_L < 1) begin
    $write( " Vbse   = %g Vdse = %g Vgse = %g \n" ,
         Vbse , Vdse , Vgse ) ;
end
// ---- end `include "HSMSOI_FB_module.inc" ----
    end else begin
// ---- begin `include "HSMSOI_BT_module.inc" ----
/***********************************************************************

 HiSIM (Hiroshima University STARC IGFET Model)
 Copyright (C) 2000-2016 Hiroshima University and STARC
 Copyright (C) 2016-2021 Hiroshima University
 HiSIM_SOI (Silicon-On-Insulator Model)
 Copyright (C) 2012-2016 Hiroshima University and STARC
 Copyright (C) 2016-2021 Hiroshima University

 MODEL NAME : HiSIM_SOI
 ( VERSION : 1  SUBVERSION : 5  REVISION : 0 )
 Model Parameter 'VERSION' : 1.50
 FILE : HSMSOI_BT_module.inc

 Date : 2021.10.08

 released by Hiroshima University

***********************************************************************/
//
////////////////////////////////////////////////////////////////
//
//
//Licensed under the Educational Community License, Version 2.0
//(the "License"); you may not use this file except in
//compliance with the License.
//
//You may obtain a copy of the License at:
//
//      http://opensource.org/licenses/ECL-2.0
//
//Unless required by applicable law or agreed to in writing,
//software distributed under the License is distributed on an
//"AS IS" BASIS, WITHOUT WARRANTIES OR CONDITIONS OF ANY KIND,
//either express or implied. See the License for the specific
//language governing permissions and limitations under the
//License.
//
//
//The HiSIM_SOI standard has been supported by the members of
//Silicon Integration Initiative's Compact Model Coalition. A
//link to the most recent version of this standard can be found
//at:
//
//http://www.si2.org/cmc
//
////////////////////////////////////////////////////////////////
//

//================ Start of executable code.=================//

//start_of_routine

//-----------------------------------------------------------*
//Determine PD or FD by WdSOI at strong inversion condition.
//- The same definition is used for both source and drain.
//-----------------//
Vbcs_cl = Vbsc ;
if (WdSOI_ini < `t_SOI) begin
    flg_depmode = 1 ; // Partially Depleted (PD) mode //
end else begin
    flg_depmode = 2 ; // Fully Depleted (FD) mode //
end

//-----------------------------------------------------------*
//Solve Poisson's equation for BT devices
//----------------//

// Start of hsmsoieval_btsolps.h //

//-----------------------------------------------------------*
//* Accumulation zone. (zone-A)
//* - evaluate basic characteristics and exit from this part.
//*-----------------//
Vgs_fb = Vfb - dVth + dPpg + Vbcs_cl ; // for BTSOI //
if ( Vgs < Vgs_fb ) begin
    flg_zone = -1 ;

    //---------------------------------------------------*
    //* Evaluation of Ps0.
    //* - Psa : Analytical solution of
    //*             C_fox( Vgp - Psa ) = cnst0SOI * Qacc
    //*         where Qacc is the 3-degree series of(fdep)^{1/2}.
    //*         The unknown  is transformed to Chi=beta(Ps0-Vbs).
    //* - Ps0_min : |Ps0_min| when Vbs=0.
    //*-----------------//
    // Ps0_min: approx. solution of Poisson equation at Vgs_min //
    //          ( easy to improve, if necessary  )              //
    //    Ps0_min = Eg - Pb2 ;
    Ps0_min = 2.0 * beta_inv * ln (-Vgs_min/fac1) ;
    TX = beta * ( Vgp - Vbcs_cl ) ;
    T1 = 1.0 / ( beta * cnst0SOI ) ;
    TY = T1 * C_fox ;
    Ac41 = 2.0 + 3.0 * `C_SQRT_2 * TY ;
    Ac4 = 8.0 * Ac41 * Ac41 * Ac41 ;
    T4 = ( TX - 2.0 ) ;
    T5 = 9.0 * TY * T4 ;
    Ac31 = 7.0 * `C_SQRT_2 - T5 ;
    Ac3 = Ac31 * Ac31 ;
    if ( Ac4 < Ac3 * 1.0e-8 ) begin
        Ac1 = -7.0 * `C_SQRT_2 + Ac31 + 0.5 * Ac4 / Ac31 + T5 ;
    end else begin
        Ac2 = sqrt( Ac4 + Ac3 ) ;
        Ac1 = -7.0 * `C_SQRT_2 + Ac2 + T5 ;
    end
    Acd = `Fn_Pow( Ac1 , `C_1o3 ) ;
    Acn = -4.0 * `C_SQRT_2 - 12.0 * TY + 2.0 * Acd + `C_SQRT_2 * Acd * Acd ;
    T1 = 1.0 / Acd ;
    Chi = Acn * T1 ;
    Psa = Chi * beta_inv + Vbcs_cl ;
    T1 = Psa - Vbcs_cl ;
    T2 = T1 / Ps0_min ;
    T3 = sqrt( 1.0 + ( T2 * T2 ) ) ;
    Ps0 = T1 / T3 + Vbcs_cl ;

end else begin //if( Vgs < Vgs_fb ) begin
    //-----------------------------------------------------------*
    //* Initial guess for Ps0.
    //*-----------------//

`ifndef DISABLE_COPPRV

    //-------------------------------------------------------------------*
    // Update initial potential values by previous values
    //----------------//

    vtol_pprv = 5.0e-2 ;
    vtol_pprv_u = 6.0e-2;
    vtol_pprv_l = 4.0e-2;

    if ( COPPRV ) begin

        if (called >= 1 && flg_zone_prv != -1) begin
            Vbsc_dif = Vbsc - vbsc_prv ;
            Vdsc_dif = Vdsc - vdsc_prv ;
            Vgsc_dif = Vgsc - vgsc_prv ;
            sum_vdif = abs(Vbsc_dif) + abs(Vdsc_dif) + abs(Vgsc_dif) ;

            flg_pprv = (flg_pprv_prv > 0 )? 1 : 0 ;

            if (sum_vdif > vtol_pprv_u) flg_pprv = 0;
            if (sum_vdif <= vtol_pprv_l) flg_pprv = 1;
            if (mode * mode_prv < 0) flg_pprv = 0;

            if ( called >=2 && flg_pprv ==1 ) begin
                Vbsc_dif2 = vbsc_prv - vbsc_prv2 ;
                Vdsc_dif2 = vdsc_prv - vdsc_prv2 ;
                Vgsc_dif2 = vgsc_prv - vgsc_prv2 ;
                sum_vdif2 = abs(Vbsc_dif2) + abs(Vdsc_dif2) + abs(Vgsc_dif2) ;
            end
            dVbs = Vbsc_dif ;
            dVds = Vdsc_dif ;
            dVgs = Vgsc_dif ;
            ddVbs = dVbs * dVbs /2 ;
            ddVds = dVds * dVds /2 ;
            ddVgs = dVgs * dVgs /2 ;
            //
            if ( flg_pprv >= 1 ) begin
                Pss0_ini = pss0_prv ;
                Pssl_ini = pssl_prv ;
            end

            flg_pprv_prv = flg_pprv;

        end else begin
            Vbsc_dif  = 0.0 ;
            Vdsc_dif  = 0.0 ;
            Vgsc_dif  = 0.0 ;
            Vbsc_dif2 = 0.0 ;
            Vdsc_dif2 = 0.0 ;
            Vgsc_dif2 = 0.0 ;
            sum_vdif  = 0.0 ;
            sum_vdif2 = 0.0 ;
            flg_pprv = 0 ;

        end

        flg_pprv_prv = flg_pprv;

    end // End of if (COPPRV)

`endif // COPPRV

    if ( flg_pprv >= 1 ) begin
        phi_s0_SOI  = Pss0_ini ;
        Ps0_ini = Pss0_ini ;
    end else begin  // ( flg_pprv == 0 )
        //---------------------------------------------------*
        //* Ps0_iniA: solution of subthreshold equation assuming zone-D1/D2.
        //*-----------------//
        TX = 1.0e0 + 4.0e0 * ( beta * ( Vgp - Vbcs_cl ) - 1.0e0 ) / ( fac1p2 * beta2 ) ;
        TX = `Fn_Max( TX , `epsm10 ) ;
        Ps0_iniA = Vgp + fac1p2 * beta * 0.5 * ( 1.0e0 - sqrt( TX ) ) ;

        //---------------------------------------------------*
        //* Analytical initial guess.
        //*-----------------//
        //-------------------------------------------*
        //* Common part.
        //*-----------------//
        Chi = beta * ( Ps0_iniA - Vbcs_cl ) ;
        if ( Chi < `znbd3 ) begin
            //-----------------------------------*
            //* zone-D1/D2
            //* - Ps0_ini is the analytical solution of Qs=Qb0 with
            //*   Qb0 being approximated to 3-degree polynomial.
            //*-----------------//
            TY = beta * ( Vgp - Vbcs_cl ) ;
            T1 = 1.0e0 / ( `cn_nc3 * beta * fac1 ) ;
            T2 = 81.0 + 3.0 * T1 ;
            T3 = -2916.0 - 81.0 * T1 + 27.0 * T1 * TY ;
            T4 = 1458.0 - 81.0 * ( 54.0 + T1 ) + 27.0 * T1 * TY ;
            T4 = T4 * T4 ;
            T5 = `Fn_Pow( T3 + sqrt( 4 * T2 * T2 * T2 + T4 ) , `C_1o3 ) ;
            TX = 3.0 - ( `C_2p_1o3 * T2 ) / ( 3.0 * T5 )
                + 1.0 / ( 3.0 * `C_2p_1o3 ) * T5 ;
            Ps0_iniA = TX * beta_inv + Vbcs_cl ;
            Ps0_ini = Ps0_iniA ;
        end else if ( Vgs <= Vth ) begin
            //-----------------------------------*
            //* Weak inversion zone.
            //*-----------------//
            Ps0_ini = Ps0_iniA ;
        end else begin
            //-----------------------------------*
            //* Strong inversion zone.
            //* - Ps0_iniB : upper bound.
            //*-----------------//
            T1 = 1.0 / cnst1SOI / cnstC_foxi ;
            T2 = T1 * Vgp * Vgp ;
            T3 = beta + 2.0 / Vgp ;
            Ps0_iniB = ln ( T2 ) / T3 ;
            `Fn_SUtemp( Ps0_ini , Ps0_iniA, Ps0_iniB, `c_ps0ini_2)
        end
        TX = Vbcs_cl + `ps_conv / 2 ;
        if ( Ps0_ini < TX ) Ps0_ini = TX ;
    end // if ( flg_pprv == 0 )

    //---------------------------------------------------*
    //* Assign initial guess.
    //*-----------------//
    Ps0 = Ps0_ini ;
    Psl_lim = Ps0_iniA ;

end // end of if( Vgs < Vgs_fb )

//Floating-body effects for body-contacted (a.k.a., body-tie) SOI devices
if (COISUB == 1 && COFBE == 2) begin
    Qhs = `NQS_CAP * V(nqs_qhs) ;
end else begin
    Qhs = 0 ;
end
OP_QHS   = Qhs; // 20201013 probing
`ifdef _fdisplay_
$write ("Vds %e Vgs %e Isub %e Qhs %e \n", Vds, Vgs, Isub, Qhs);
`endif
//
//---------------------------------------------------*
//* Calculation of Ps0. (beginning of Newton loop)
//* - Fs0 : Fs0 = 0 is the equation to be solved.
//* - dPs0 : correction value.
//*-----------------//
exp_bVbs = exp( beta * Vbcs_cl ) ;
cfs1 = cnst1SOI * exp_bVbs ;
flg_conv = 0 ;

phi_s0_SOI = Ps0 ;

dphi_sb = q_Nsub * `t_SOI * `t_SOI / 2.0 / `C_ESI ;
T0 = sqrt(2.0 * beta * dphi_sb) ;
T1 = (exp(T0) + exp(-T0)) / 2 ;
c_sb = ln(T1) / dphi_sb ;

for ( lp_s0 = 1 ; lp_s0 <= lp_s0_max + 1 ; lp_s0 = lp_s0 + 1 ) begin
    phi_SOI0 = phi_s0_SOI - Vbcs_cl ;
    Chi = beta * phi_SOI0 ;

    TY = c_sb * (phi_SOI0 - dphi_sb) ;
    if ( TY < `large_arg ) begin
        T1 = exp(TY) ;
        T0 = exp(- c_sb * dphi_sb) ;
        T2 = T1 - T0 ;
        phi_SOIb = ln(1 + T2) / c_sb ;
        phi_SOIb_dPss = T1 / (1 + T2) ;
    end else begin
        phi_SOIb = phi_SOI0 - dphi_sb ;
        phi_SOIb_dPss = 1 ;
    end
    Chib = beta * phi_SOIb ;

    if (abs(Chi) < 1E-16) begin
        T0 = sqrt((1 - phi_SOIb_dPss * phi_SOIb_dPss) / 2) ;
        fb = Chi * T0 ;
        fb_dPss = beta * T0 ;
        if (Chi < 0) begin
            fb = -fb ;
            fb_dPss = -fb_dPss ;
        end
    end else if (abs(Chi) < 5E-3) begin

        T0 = Chi * Chi / 2 * (1 - Chi / 3 * (1 - Chi / 4 * (1 - Chi / 5))) ;
        T1 = Chi * (1 - Chi / 2 * (1 - Chi / 3 * (1 - Chi / 4))) ;
        T2 = Chib * Chib / 2 * (1 - Chib / 3 * (1 - Chib / 4 * (1 - Chib / 5))) ;
        T3 = Chib * (1 - Chib / 2 * (1 - Chib / 3 * (1 - Chib / 4))) ;
        fb = sqrt(T0 - T2) ;
        fb_dPss = beta * 0.5 * (T1 - phi_SOIb_dPss * T3) / fb ;
    end else begin
        //-------------------------------------------*
        //* zone-D3.  (phi_s0_SOI)
        //*-----------------//

        T0 = exp(-Chi) ;
        T1 = exp(-Chib) ;
        fb = sqrt(Chi - Chib + (T0 - T1)) ;
        fb_dPss = beta * 0.5 * (1 - T0 - phi_SOIb_dPss * (1 - T1)) / fb ;
    end // check nest level. ok. //if (abs(Chi) < 1E-8) begin

    if (flg_conv == 1 && Chi < 0.0) begin
        flg_zone = -1 ;
    end
    if (flg_zone == -1) begin
        WdSOI = 0 ;
    end else begin
        WdSOI = C_W_SOI * fb ;
    end

    if (WdSOI < `t_SOI*1.01) begin
        flg_depmode = 1 ; // PD //
    end else begin
        flg_depmode = 2 ; // FD //
    end

    Q_dep_SOI = q_Nsub * WdSOI ;

    if (Chi < 0) begin
        fs02 = -fb ;
        fs02_dPs0 = -fb_dPss ;
    end else if (Chi < 1E-7) begin
        fs02 = fb ;
        fs02_dPs0 = fb_dPss ;
    end else begin
        if ( Chi < `large_arg ) begin // avoid exp_Chi to become extremely large
            exp_Chi = exp( Chi ) ;
            fs01 = cfs1 * ( exp_Chi - (Chi + 1) ) ;
            fs01_dPs0 = cfs1 * beta * ( exp_Chi - 1 ) ;
        end else begin
            exp_bPs0 = exp( beta*phi_s0_SOI ) ;
            fs01 = cnst1SOI * ( exp_bPs0 - exp_bVbs * (Chi + 1) ) ;
            fs01_dPs0 = cnst1SOI * beta * ( exp_bPs0 - exp_bVbs ) ;
        end
        fs02 = sqrt(fb * fb + fs01) ;
        fs02_dPs0 = 0.5 * (2 * fb_dPss * fb + fs01_dPs0) / fs02 ;
    end

    // Revised Fs0 //
    Fs0 = - Vgp + phi_s0_SOI + fac1 * fs02 - C_fox_inv * Qhs ;
    Fs0_dPs0 = 1.0 + fac1 * fs02_dPs0 ;
    if ( flg_conv == 1 ) begin
        lp_s0 = lp_s0_max+1 ; // break
    end else begin
        dPs0 = - Fs0 / Fs0_dPs0 ;

        //-------------------------------------------*
        //* Update Ps0 .
        //* - clamped to Vbcs_cl if Ps0 < Vbcs_cl .
        //*-----------------//
        dPlim = 0.5*`dP_max*(1.0 + `Fn_Max(1.0e0,abs(phi_s0_SOI))) ;
        if ( abs( dPs0 ) > dPlim ) dPs0 = dPlim * `Fn_Sgn( dPs0 ) ;
        phi_s0_SOI = phi_s0_SOI + dPs0 ;

        //-------------------------------------------*
        //* Check convergence.
        //* NOTE: This condition may be too rigid.
        //*-----------------//
        if ( abs( dPs0 ) <= `ps_conv && abs( Fs0 ) <= `gs_conv ) begin
            flg_conv = 1 ;
        end

    end
end // end of phi_s0_SOI Newton loop //

// Reduce loop count to exclude the sweep for derivative calculation //
lp_s0 = lp_s0 - 1 ;

//-------------------------------------------*
//* Procedure for diverged case.
//*-----------------//
Q_depS0 = Q_dep_SOI ;
Q_dep0 = Q_depS0 ;
Ps0 = phi_s0_SOI ;

flg_conv_0 = flg_conv ; // for Ps0 only

//-----------------------------------*
//* Xi0
//*-----------------//
Q_depS0_SOI_o_cnst0SOI = Q_depS0 / cnst0SOI ;
Xi0 = `Fn_Sqr(Q_depS0_SOI_o_cnst0SOI) + `epsm10 ;
T1 = 2 * Q_depS0_SOI_o_cnst0SOI ;
Xi0p12 = Q_depS0_SOI_o_cnst0SOI + `epsm10 ;

//-----------------------------------------------------------*
//* Qb0 : Qb at source side.
//* Qn0 : Qi at source side.
//*-----------------//
Qb0 = cnst0SOI * Xi0p12 ;
T1 = 1.0 / ( fs02 + Xi0p12 ) ;
Qn0 = cnst0SOI * fs01 * T1 ;
Q_n0 = -Qn0 ;

//---------------------------------------------------*
//* VgVt : Vgp - Vth_qi. ( Vth_qi is Vth for Qi evaluation. )
//*-----------------//
VgVt = Qn0 * C_fox_inv ;

//-----------------------------------------------------------*
//* make Qi=Qd=Ids=0 if VgVt <= VgVt_Small
//*-----------------//
if ( flg_zone == -1 || VgVt <= `VgVt_Small ) begin
    flg_zone = 4 ;
    flg_noqi = 1 ;
    T2 = ( Vgp - Ps0 ) ;
    Qbu = C_fox * T2 ;
    T0 = -weffcv_nf * Leff_cv ; // 20180717 affects accumulation region
    Qb = T0 * Qbu ;
    Qi = 0.0 ;
    Qd = 0.0 ;
    T2 = -area_bt_n  * Qbu ; // adding BT area * Qbu

    Qbody_bt_n_sud = T2 * Qdrat;
    Qbody_bt_n_sus = T2 - Qbody_bt_n_sud ;
    Qbody_bt_n_iud = 0.0  ;
    Qbody_bt_n_ius = 0.0  ;
    Ids = 0.0 ;
    VgVt = 0.0 ;
    flg_noqi = 1 ;
    phi_sL_SOI = phi_s0_SOI ;
    Psl = Ps0 ;
    Psdl = Psl ;
    end_of_part_1 = 1 ;
end

if (end_of_part_1 == 0) begin

    //-----------------------------------------------------------*
    //* Start point of Psl(= Ps0 + Pds) calculation.(label)
    //*-----------------//
    // start_of_Psl:

    // Vdseff(begin) //
    begin : SetVdseffBT
        real T1, T2, T3, T4, T6, T7, T10;

        Vdsorg = Vds ;
        T10 = `Small ;
        T2 = qnsub_esi / (C_fox * C_fox) ;
        T4 = 1.0e0 + 2.0e0 / T2 * ( Vgp -  T10 ) ;
        T5 = 1.0e0 + 2.0e0 / T2 ;
        `Fn_SL_CP( T4 , T4 , 0, T5 , 4 )
        T3 = sqrt(T4) ;
        T10 = Vgp + T2 * ( 1.0 - T3 )  ;
        `Fn_SZtemp(T10, T10, 0.01)
        Vdsat = T10 ;
        T1 = Vds / T10 ;
        T2 = `Fn_Pow(T1, DDLTe - 1.0e0) ;
        T7 = T2 * T1 ;
        T3 = 1.0 + T7 ;
        T4 = `Fn_Pow(T3, 1.0 / DDLTe - 1.0) ;
        T6 = T4 * T3 ;
        Vdseff = Vds / T6 ;
        Vds = Vdseff  ;
    end // SetVdseff
    // Vdseff(end) //
    exp_bVbsVds = exp( beta * ( Vbcs_cl - Vds ) ) ;

    //---------------------------------------------------*
    //* Skip Psl calculation when Vds is very Small.
    //*-----------------//
    if ( Vds <= 0.0 ) begin
        Pds = 0.0 ;
        Psl = Ps0 ;
        flg_conv = 0 ;
    end else begin

        if ( flg_pprv >= 1 ) begin
            phi_sL_SOI  = Pssl_ini ;
            Pds_ini = Pssl_ini - Ps0 ;
        end
        if ( flg_pprv == 0 ) begin // ( flg_pprv == 0 )

            //-----------------------------------------------------------*
            //* Initial guess for Pds( = Psl - Ps0 ).
            //*-----------------//
            //---------------------------------------------------*
            //* Analytical initial guess.
            //*-----------------//
            Pds_max = `Fn_Max( Psl_lim - Ps0 , 0.0e0 ) ;
            `Fn_SUtemp( Pds_ini , Vds, (1.0e0 + `c_pslini_1) * Pds_max, `c_pslini_2 )
            Pds_ini = `Fn_Min( Pds_ini , Pds_max ) ;

        end // if ( flg_pprv == 0 )

        if ( Pds_ini < 0.0 ) Pds_ini = 0.0 ;
        else if ( Pds_ini > Vds ) Pds_ini = Vds ;

        //---------------------------------------------------*
        //* Assign initial guess.
        //*-----------------//
        Pds = Pds_ini ;
        Psl = Ps0 + Pds ;
        //---------------------------------------------------*
        //* Calculation of Psl by solving Poisson eqn.
        //* (beginning of Newton loop)
        //* - Fsl : Fsl = 0 is the equation to be solved.
        //* - dPsl : correction value.
        //*-----------------//
        flg_conv = 0 ;

    end // end of start_of_loop_Psl

    //---------------------------------------------------*
    //* start of Psl calculation. (label)
    //*-----------------//
    // start_of_loop_Psl:
    phi_sL_SOI = Psl ;

    for ( lp_sl = 1 ; lp_sl <= lp_sl_max + 1 ; lp_sl = lp_sl + 1 ) begin
        phi_SOIL = phi_sL_SOI - Vbcs_cl ;
        Chi = beta * phi_SOIL ;

        TY = c_sb * (phi_SOIL - dphi_sb) ;
        if ( TY < `large_arg ) begin
            T1 = exp(TY) ;
            T0 = exp(- c_sb * dphi_sb) ;
            T2 = T1 - T0 ;
            phi_SOIb = ln(1 + T2) / c_sb ;
            phi_SOIb_dPss = T1 / (1 + T2) ;
        end else begin
            phi_SOIb = phi_SOIL - dphi_sb ;
            phi_SOIb_dPss = 1 ;
        end
        Chib = beta * phi_SOIb ;

        if (abs(Chi) < 1E-16) begin
            T0 = sqrt((1 - phi_SOIb_dPss * phi_SOIb_dPss) / 2) ;
            fb = Chi * T0 ;
            fb_dPss = beta * T0 ;
            if (Chi < 0) begin
                fb = -fb ;
                fb_dPss = -fb_dPss ;
            end
        end else if (abs(Chi) < 5E-3) begin
            //
            //-------------------------------------------*
            //* zone-D1/D2.  (phi_sL_SOI)
            //* - Qb0 is approximated to 5-degree polynomial.
            //*-----------------//

            T0 = Chi * Chi / 2 * (1 - Chi / 3 * (1 - Chi / 4 * (1 - Chi / 5))) ;
            T1 = Chi * (1 - Chi / 2 * (1 - Chi / 3 * (1 - Chi / 4))) ;
            T2 = Chib * Chib / 2 * (1 - Chib / 3 * (1 - Chib / 4 * (1 - Chib / 5))) ;
            T3 = Chib * (1 - Chib / 2 * (1 - Chib / 3 * (1 - Chib / 4))) ;
            fb = sqrt(T0 - T2) ;
            fb_dPss = beta * 0.5 * (T1 - phi_SOIb_dPss * T3) / fb ;
        end else begin
            //-------------------------------------------*
            //* zone-D3.  (phi_sL_SOI)
            //*-----------------//

            T0 = exp(-Chi) ;
            T1 = exp(-Chib) ;
            fb = sqrt(Chi - Chib + (T0 - T1)) ;
            fb_dPss = beta * 0.5 * (1 - T0 - phi_SOIb_dPss * (1 - T1)) / fb ;
        end

        if (flg_zone == -1) begin
            WdSOI = 0 ;
        end else begin
            WdSOI = C_W_SOI * fb ;
        end
        Q_dep_SOI = q_Nsub * WdSOI ;

        if (Chi < 0) begin
            fsl2 = -fb ;
            fsl2_dPsl = -fb_dPss ;
        end else if (Chi < 1E-7) begin
            fsl2 = fb ;
            fsl2_dPsl = fb_dPss ;
        end else begin
            Rho = beta * ( phi_sL_SOI - Vds ) ;
            exp_Rho = exp( Rho ) ;
            fsl1 = cnst1SOI * ( exp_Rho - exp_bVbsVds * (Chi + 1) ) ;
            fsl1_dPsl = cnst1SOI * beta * ( exp_Rho - exp_bVbsVds ) ;
            fsl2 = sqrt(fb * fb + fsl1) ;
            fsl2_dPsl = 0.5 * (2 * fb_dPss * fb + fsl1_dPsl) / fsl2 ;
        end

        // Revised Fsl //
        //         Fsl = - Vgp + phi_sL_SOI + fac1 * fsl2 ;
        Fsl = - Vgp + phi_sL_SOI + fac1 * fsl2 - C_fox_inv * Qhs ;
        Fsl_dPsl = 1.0 + fac1 * fsl2_dPsl ;
        if ( flg_conv == 1 && lp_sl > 3) begin
            lp_sl = lp_sl_max+1 ; // break
        end else begin
            dPsl = - Fsl / Fsl_dPsl ;

            //-------------------------------------------*
            //* Update phi_sL_SOI .
            //* - clamped to Vbcs_cl if Psl < Vbcs_cl .
            //*-----------------//
            dPlim = 0.5*`dP_max*(1.0 + `Fn_Max(1.0e0,abs(phi_sL_SOI))) ;
            if ( abs( dPsl ) > dPlim ) dPsl = dPlim * `Fn_Sgn( dPsl ) ;
            phi_sL_SOI = phi_sL_SOI + dPsl ;

            //-------------------------------------------*
            //* Check convergence.
            //* NOTE: This condition may be too rigid.
            //*-----------------//
            if ( abs( dPsl ) <= `ps_conv && abs( Fsl ) <= `gs_conv ) begin
                flg_conv = 1 ;
            end
        end
    end // end of phi_sL_SOI Newton loop //

    // Reduce loop count to exclude derivative calculation sweep //
    lp_sl = lp_sl - 1 ;

    //-------------------------------------------*
    //* Procedure for diverged case.
    //*-----------------//
    Q_depSL = Q_dep_SOI ; // bugfixed //
    Q_depL = Q_depSL ;
    Psl = phi_sL_SOI ;

    flg_conv_L = flg_conv ; // for Psl only

    //-----------------------------------*
    //* Xil
    //*-----------------//
    Q_depSL_SOI_o_cnst0SOI = Q_depSL / cnst0SOI ;
    Xilp12 = Q_depSL_SOI_o_cnst0SOI + `epsm10 ;

    //-----------------------------------------------------------*
    //* Qb0 : Qb at source side.
    //* Q_nL : Qi at source side.
    //*-----------------//
    //    Qb0 = cnst0SOI * Xilp12 ;
    T1 = 1.0 / ( fsl2 + Xilp12 ) ;
    Q_nL = cnst0SOI * fsl1 * T1 ;
    Q_nL = -Q_nL ;
    Pds = Psl - Ps0 ;
    // Vdseff //
    Vds = Vdsorg ;

`ifndef DISABLE_COPPRV
    //Restore present values for next bias step
    //-----------------------------------------------------------*
    //Restore values for next calculation.
    //----------------//
    if ( COPPRV && ( flg_conv_0 + flg_conv_L == 2 )) begin
        //Activate COPPRV only when iteration has been successful on both sides (source and drain).
        // Confined biases //
        if ( called >= 1 ) begin
            vbsc_prv2 = vbsc_prv ;
            vdsc_prv2 = vdsc_prv ;
            vgsc_prv2 = vgsc_prv ;
            mode_prv2 = mode_prv ;
        end
        vbsc_prv = Vbsc ;
        vdsc_prv = Vdsc ;
        vgsc_prv = Vgsc ;
        mode_prv = mode ;
        flg_zone_prv = flg_zone ;
        // Surface potentials //
        pss0_prv = phi_s0_SOI ;
        pssl_prv = phi_sL_SOI ;

    end // (COPPRV)
`endif // COPPRV

    //-----------------------------------------------------------*
    //* Evaluate Idd .
    //* - Eta : substantial variable of QB'/Pds and Idd/Pds.
    //* - note: Eta   = 4 * GAMMA_beginhisim_0end
    //*-----------------//
    T1 = beta / Xi0 ;
    Eta = T1 * Pds ;

    // ( Eta + 1 )^n //
    Eta1 = Eta + 1.0e0 ;
    Eta1p12 = sqrt( Eta1 ) ;

    // 1 / ( ( Eta + 1 )^n + 1 ) //
    Zeta12 = 1.0e0 / ( Eta1p12 + 1.0e0 ) ;

    //---------------------------------------------------*
    //* F00 := PS00/Pds(n=1/2)
    //*-----------------//
    F00 = Zeta12 / Xi0p12 ;

    //---------------------------------------------------*
    //* F10 := PS10/Pds(n=3/2)
    //*-----------------//
    // if(flg_depmode <= 1) begin // accumulation & PD //
    //   T1 = 3.0e0 + Eta * ( 3.0e0 + Eta ) ;
    //   F10 = `C_2o3 * Xi0p12 * Zeta32 * T1 ;
    // end else begin // FD //
    F10 = 0.5 * (Q_depS0_SOI_o_cnst0SOI + Q_depSL_SOI_o_cnst0SOI) ;
    // end

    T1 = Vgp + beta_inv - 0.5e0 * ( 2.0e0 * Ps0 + Pds ) ;
    T2 = - F10 + F00 ;
    T3 = beta * C_fox ;
    T4 = beta * cnst0SOI ;
    Fdd = T3 * T1 + T4 * T2 ;

    //---------------------------------------------------*
    //*  Idd:
    //*-----------------//
    Ab = (Q_depL + Q_dep0) / 2;
    Ai = - (Q_nL + Q_n0) / 2;
    Db = Q_depL - Q_dep0;
    Di = - (Q_nL - Q_n0);
    C2 = cnst0SOI * cnst0SOI;
    if (flg_depmode <= 1) begin // accumulation & PD //
        Idd = Ai * beta * Pds - Di - Db * Db * Db / C2 / 6;
    end else begin
        Idd = Pds * Fdd ;
    end

    if (flg_info >= 1 && Idd < 0.0) begin
        $write("Warning: Idd = %e < 0  ", Idd) ;
        $write("Vds= %e Pds= %e ", Vds, Pds) ;
        $write("\n") ;
        Idd = 0.0 ;
    end

    //---------------------------------------------------*
    //* Qbu : -Qb in unit area.
    //*-----------------//
    if (flg_depmode <= 1) begin // accumulation & PD //
        if (abs(Pds) > 1e-6) begin
            Qbu = Ab * (Ai * beta * Pds - Di) + (Ai - 2 * Ab
                + C_fox / beta * (1 - 2 * Ab * Ab / C2 + Db * Db / C2 / 10))
                * Db * Db * Db / C2 / 6;
            Qbu = Qbu / Idd;
        end else begin
            Qbu = Ab;
        end
    end else begin // FD //
        Qbu = 0.5 * (Q_depL + Q_dep0) ;
    end

    //---------------------------------------------------*
    //* preparation for Qi and Qd.
    //* - DtPds: Delta * Pds ;
    //* - Achi: (1+Delta) * Pds ;
    //*-----------------//
    T1 = 2.0e0 * fac1 ;
    DtPds = T1 * ( F10 - Xi0p12 ) ;
    Achi = Pds + DtPds ;

    //-----------------------------------------------------------*
    //* Alpha : parameter to evaluate charges.
    //* - Achi: (1+Delta) * Pds ;
    //* - clamped to 0 if Alpha < 0.
    //*-----------------//
    T1 = 1.0 / VgVt ;
    T2 = Achi * T1 ;
    T3 = 1.0e0 - T2 ;
    TX = 1.0 - T3 ;
    `Fn_CP(TY, TX, 1.0, 4)
    Alpha = 1.0 - TY ;

    // End of hsmsoieval_btsolps.h //

    // start_of_charges:

    //-----------------------------------------------------------*
    //* Qiu : -Qi in unit area.
    //*-----------------//
    Qinm = 1.0 + Alpha * (1.0 + Alpha) ;
    Qidn = `Fn_Max(1.0 + Alpha, `epsm10) ;
    T1 = `C_2o3 * VgVt * Qinm / Qidn ;

    if (flg_depmode <= 1) begin // accumulation & PD //
        // BT device //
        if (abs(Pds) > 1e-6) begin
            Qiu = (Ai * Ai + Di * Di / 12) * beta * Pds - Ai * Di - (2 * Ai
                + C_fox / beta * Db * Db / C2 / 5) * Db * Db * Db / C2 / 6;
            Qiu = Qiu / Idd;
        end else begin
            Qiu = Ai;
        end
    end else begin // if (flg_depmode == 1)
        Qiu = -0.5 * (Q_n0 + Q_nL);
    end

    if (flg_conv_0 == 0) begin
        $write("*** warning(HiSIM_SOI): Went Over Iteration Maximum(%M:Ps0): \n") ;
    end
    if (flg_conv_L == 0) begin
        $write("*** warning(HiSIM_SOI): Went Over Iteration Maximum(%M:Psl): \n") ;
    end
    if (flg_conv_0+flg_conv_L < 1) begin
        $write( " Vbse   = %g Vdse = %g Vgse = %g \n" ,
            Vbse , Vdse , Vgse ) ;
    end

end // end if(end_of_part_1==0)
// ---- end `include "HSMSOI_BT_module.inc" ----
    end

    if (end_of_part_1 == 0) begin

        //-----------------------------------------------------------*
        //* Qdrat : Qd/Qi
        //*-----------------//
        Qdnm = 0.5 + Alpha ;
        Qddn = Qidn * Qinm ;
        Quot = 0.4 * Qdnm / Qddn ;
        Qdrat = 0.6 - Quot ;

        if (Qdrat > 0.5 + `dQdrat) begin
            if (flg_info >= 1) begin
                $write("Qdrat=%.16e 0.5 @ Vgs=%eV\n", Qdrat, Vgs) ;
            end
            Qdrat = 0.5 ;
        end
        Qdrat_noi = Qdrat ; // for Noise
        Qdrat = 0.5 ;       // for Capacitance

        //-----------------------------------------------------------*
        //* Skip CLM and integrated charges if zone==D1
        //*-----------------//
        if (flg_noqi == 0) begin

            //-----------------------------------------------------------*
            //* Channel Length Modulation. Lred: \Delta L
            //*-----------------//
            begin :CLMmodel
                real T0, T1, T2, T3, T4, T5, T6,T6w, T7, T8, T9, T10, T11, T11w, Wd;

                if (CLM2 < `epsm10 && CLM3 < `epsm10) begin
                    Lred = 0.0 ;
                    Psdl = Psl ;
                    if (Psdl > Ps0 + Vdsz - `epsm10) begin
                        Psdl = Ps0 + Vdsz - `epsm10 ;
                    end

                end else begin              //if( clm2 < epsm10 && clm3 < epsm10 )
                    Wd = ( COBCNODE == 1 ) ? `t_SOI : WdSOI_0 ;
                    T0 = 1.0 / Wd ;
                    T1 = Qn0 * T0 ;
                    T2 = CLM3 * T1 ;
                    T5 = UC_CLM2 * q_Nsub + T2 ;
                    T1 = 1.0 / T5 ;
                    T4 = `C_ESI * T1 ;
                    T1 = (1.0e0 - CLM1) ;
                    Psdl = CLM1 * (Vds + Ps0) + T1 * Psl ;
                    if (Psdl > Ps0 + Vdsz - `epsm10) begin
                        Psdl = Ps0 + Vdsz - `epsm10 ;
                    end
                    T6w = Psdl - Psl ;        // can be negative //
                    `Fn_SZtemp(T6, T6w, 1e-3)         // limited //
                    T3 = beta * Qn0 ;
                    T1 = 1.0 / T3 ;
                    T5 = Idd * T1 ;
                    if (T5 < beta_inv ) begin
                        T5 = beta_inv;
                    end
                    T10 = q_Nsub / `C_ESI ;
                    T1 = 1.0e5 * 1.0e4;
                    T2 = 1.0 / Leff ;
                    T11w = (2.0 * T5 + 2.0 * T10 * T6 * T4 + T1 * T4) * T2 ;
                    T7 = T11w * T4 ;
                    T11 = 4.0 * (2.0 * T10 * T6 + T1) ;
                    T8 = T11 * T4 * T4 ;
                    T9 = sqrt(T7 * T7 + T8) ;        // can be nan if Psdl < Psl //

                    //---------------------------------------------------*
                    //* Modify Lred for symmetry.
                    //*-----------------//
                    Lred = FMDVDS * ( 0.5 * (-T7 + T9) ) ;
                end                //if( clm2 < epsm10 && clm3 < epsm10 )

                // CLM5 & CLM6 //
                Lred = Lred * clmmod ;
            end  // CLMmodel
            //-------------------------------------------*
            //End point of CLM. (label)
            //----------------//
        end // end_of_CLM:

        //---------------------------------------------------*
        //    Lch: actual chnnel length
        //    ----------------//
        Lch = Leff - Lred ;
        Lch_cv = Leff_cv - Lred ;
        if (Lch < 1.0e-9) begin
            Lch = 1.0e-9 ;
            $write("*** warning(HiSIM_SOI): actual channel length is too Small. (Lch=%e[m])\n", Lch) ;
            $write("                       CLM5 and/or CLM6 might be too large.\n") ;
        end

        //----------------------------------------------------------*
        //* Evaluate integrated charges in unit [C].
        //*----------------------//
        T1 = -weffcv_nf * Leff_cv ;
        Qb = T1 * Qbu ;
        Qi = T1 * Qiu ;
        Qd = Qi * Qdrat ;
        if ( COBCNODE == 0 ) begin
            Qd_FB = Qb * `C_QBRAT ;
            Qs_FB = Qb * (1.0 - `C_QBRAT) ;
            //----------------------------------------------------------*
            //* Evaluate substrate charge.
            //*----------------------//
            Qsub = 0.5 * (Q_s0_bulk + Q_sL_bulk) * Leff_cv * weffcv_nf ;
        end

        //-----------------------------------------------------------*
        //* Modified potential for symmetry.
        //*----------------- from HiSIM 2.5.1 //
        begin : ModifiedPotentialForSymmetry
            real T1;

            T1 = (Vds - Pds) / 2 ;
            `Fn_SymAdd(Pzadd, T1, PZADD0)
            if (Pzadd < `epsm10) begin
                Pzadd = `epsm10 ;
            end
            Ps0z = Ps0 + Pzadd ;
        end

        //-----------------------------------------------------------*
        //Evaluate universal mobility.
        //----------------//
        begin : EvaluateUniversalMobility
            real T1, T2, T0, T4, T5, T3, T8, T7, T6, CGS_ESI, CGS_Qbu, CGS_Qiu;
            CGS_ESI = `C_ESI / `C_m2cm;
            CGS_Qbu = Qbu / `C_m2cm_p2;
            CGS_Qiu = Qiu / `C_m2cm_p2;

            T1 = NDEP / CGS_ESI ;
            T2 = NINV / CGS_ESI ;
            T0 = NINVD ;
            T4 = 1.0 + (Psl - Ps0) * T0 ;
            T5 = T1 * CGS_Qbu + T2 * CGS_Qiu ;
            T3 = T5 / T4 ;
            Eeff = T3 ;

            `Fn_SZtemp(T0, Eeff, 3.0e3)
            T5 = pow(T0, MUEPH0 - 1.0e0) ;
            T8 = T5 * T0 ;
            T7 = pow(T0, muesr - 1.0e0) ;
            T6 = T7 * T0 ;
            Rns = CGS_Qiu / `C_QE ;

            T1 = 1.0e0 / (MUECB0 + MUECB1 * Rns / 1.0e11)
                    + CGS_mphn0 * T8 + T6 / MUESR1 ;
            Muun = 1.0e0 / T1 ;
            Muun = Muun * `C_cm2m_p2;
        end  // EvaluateUniversalMobility
        //-----------------------------------------------------------*
        //    Mu : mobility
        //    (transplanted from HiSIM_HV_1_0)
        //    -------------- --//
        begin : EvaluateMobility
            real T2,T1,TY,Em,T3,T4,T5,T6;

            T2 = beta *  Qn0 * Lch ;
            `Fn_SZtemp(T2, T2, `Small )
            T1 = 1.0e0 / T2 ;
            TY = Idd * T1 ;
            T2 = 0.2 * Vmaxe / Muun ;
            Ey = sqrt(TY * TY + T2 * T2) ;
            Em = Muun * Ey ;
            T1 = Em / Vmaxe ;
            // note: bb = 2 (electron) ;1 (hole) //
            if (1.0e0 - `epsm10 <= BB && BB <= 1.0e0 + `epsm10) begin
                T3 = 1.0e0 ;
            end else if (2.0e0 - `epsm10 <= BB && BB <= 2.0e0 + `epsm10) begin
                T3 = T1 ;
            end else begin
                T3 = pow(T1, BB - 1.0e0) ;
            end
            T2 = T1 * T3 ;
            T4 = 1.0e0 + T2 ;
            if (1.0e0 - `epsm10 <= BB && BB <= 1.0e0 + `epsm10) begin
                T5 = 1.0 / T4 ;
                // T6 = T5 / T4 ;
            end else if (2.0e0 - `epsm10 <= BB && BB <= 2.0e0 + `epsm10) begin
                T5 = 1.0 / sqrt(T4) ;
                // T6 = T5 / T4 ;
            end else begin
                T6 = pow(T4, (-1.0e0 / BB - 1.0e0)) ;
                T5 = T4 * T6 ;
            end
            // T7 = Muun / Vmaxe * T6 * T3 ;
            Mu = Muun * T5 ;
        end  // EvaluateMobility
        // end_of_mobility : ; //

        //-----------------------------------------------------------*
        //    Ids: channel current.
        //    ----------------//

        betaWL = weff_nf * beta_inv / (Leff - Lred) ;
        Ids0 = betaWL * Idd * Mu ;

        //-----------------------------------------------------------*
        //* Adding parasitic components to the channel current.
        //*-----------------//
        begin : AddingParasiticChannelCurrent
            real T1, T0, T3, T9, T4, T5, T6, T8, T2;

            IdsPT = 0.0 ;
            if (COPT>0 && PTL != 0) begin
                T1 = 0.5 * (Vds - Pds) ;
                `Fn_SymAdd(T6, T1, 0.01)
                T1 = 1.1 - (Ps0 + T6) ;
                `Fn_SZtemp(T2, T1, 0.05)
                T0 = beta * ptl0 ;
                T3 = C_fox * T0 ;
                T0 = pow(T2, PTP) ;
                T9 = T3 * T0 ;
                T4 = 1.0 + Vdsz * PT2 ;
                T0 = pt40 ;
                if (SUBVERSION < 3 || COBCNODE == 1) begin
                    T5 = Ps0 + T6 - Vbsz ;
                end else begin
                    T5 = Ps0 + T6 - phi_b0_SOI ;
                end
                T4 = T4 + Vdsz * T0 * T5 ;
                T6 = T9 * T4 ;
                T9 = T6 ;
            end else begin
                T9 = 0.0 ;
            end
            if (GDL != 0) begin
                T1 = beta * gdl0 ;
                T2 = C_fox * T1 ;
                T8 = T2 * Vdsz ;
            end else begin
                T8 = 0.0 ;
            end
            if ((T9 + T8) > 0.0) begin
                Idd1 = Pds * (T9 + T8) ;
                IdsPT = betaWL * Idd1 * Mu ;
            end
        end
        Ids = Ids0 + IdsPT ;
        IdsPT0 = IdsPT ;

        //-----------------------------------------------------------*
        //* STI
        //* ----------------//
        begin :SetdVthSCSTI
            real T1,T1w, T2, T3, T4, T5, T10, TX,TY;

            if ( COISTI != 0 ) begin
                //---------------------------------------------------*
                //* dVthSCSTI : Short-channel effect induced by Vds(STI).
                //*-----------------//
                //       T1 = `C_ESI * C_fox_inv ;
                T2 = wdpl ;
                T3 =  lgatesm - PARL2 ;
                T4 = 1.0 / (T3 * T3) ;
                T5 = 2.0 * (VBI - Pb20b) *(`C_ESI * C_fox_inv ) * T2 * T4 ;
                dVth0 = T5 * sqrt_Pbsum ;
                T1w = SCSTI1 + (SCSTI2 * Vdsz) ;
                dVthSCSTI = dVth0 * T1w ;
                T1 = VTHSTI - VDSTI * Vds ;
                Vgssti = Vgsz - Vfb + T1 + dVthSCSTI ;

                costi3 = costi0_p2 * C_fox_inv * C_fox_inv ;
                costi4 = costi3 * beta * 0.5 ;
                costi5 = costi4 * beta * 2.0 ;
                T10 = beta_inv - costi3 * (beta * 0.25) + Vfb - VTHSTI - dVthSCSTI + `Small ;
                T1 = Vgsz - T10 - `psisti_dlt ;
                T0 = `Fn_Sgn(T10) ;
                T2 = sqrt (T1 * T1 + T0 * 4.0 * T10 * `psisti_dlt) ;
                T3 = T10 + 0.5 * (T1 + T2) - Vfb + VTHSTI + dVthSCSTI - Vbspz ;
                T4 = beta * T3 - 1.0 ;
                T5 = 4.0 / costi5 ;
                T1w = 1.0 + T4 * T5 ;
                `Fn_SZtemp( T1 , T1w, 1.0e-2)
                costi6 = sqrt (T1 + `Small) ;
                Psasti = Vgssti + (costi4 * (1.0 - costi6)) ;

                T0 = 1.0 / (beta + 2.0 / (Vgssti + `Small)) ;
                Psbsti = ln (1.0 / costi1 / costi3 * (Vgssti * Vgssti)) * T0 ;
                T3 = Psbsti / (Vgssti + `Small) ;
                Psab = Psbsti - Psasti - `sti2_dlt ;
                T0 = sqrt (Psab * Psab + 4.0 * `sti2_dlt * Psbsti) ;
                Psti = Psbsti - 0.5 * (Psab + T0) ;
                T1 = 1.0 / T0 ;
                T0 = costi1 * exp (beta * Psti) ;
                T1w = beta * (Psti - Vbspz) - 1.0 + T0 ;
                `Fn_SZtemp( T1 , T1w, 1.0e-2)
                sq1sti = sqrt (T1 + `epsm10);
                T1w = beta * (Psti - Vbspz) - 1.0;
                `Fn_SZtemp( T1 , T1w, 1.0e-2)
                sq2sti = sqrt (T1 + `epsm10);
                Qn0sti = costi0 * (sq1sti - sq2sti) ;

                // T1: Vdsatsti //
                T1w = Psasti - Psti ;
                `Fn_SZtemp( T1 , T1w , 1.0e-1 )
                TX = Vds / (T1 + `epsm10) ;
                `Fn_CP( TY , TX , 1.0 , 4 )
                costi7 = 2.0 * UC_WSTI * NF * beta_inv ;
                Idssti = costi7 * Mu * Qn0sti * TY / Lch;
                Ids = Ids + Idssti ;
            end
        end
        // end_of_STI: //

        //----------------------------------------------------------*
        //* induced gate noise. ( Part 1/3 )
        //*---------------------- from HiSIM 2.5.1 2010.05.21 //
        if (COIGN != 0 && COTHRML != 0) begin
            kusai00 = VgVt * VgVt ;
            kusaidd = 2.0e0 * beta_inv * C_fox_inv * Idd ;
            kusaiL = kusai00 - kusaidd ;
            `Fn_SZtemp(kusai00, kusai00, 1.0e-3)
            `Fn_SZtemp(kusaiL, kusaiL, 1.0e-3)
            kusai00L = kusai00 - kusaiL ;
            if (Qn0 < `epsm10 || kusai00L < `epsm10)
                flg_ign = 0 ;
            else flg_ign = 1 ;
        end

        //-----------------------------------------------------------*
        //End of PART-1. (label)
        //----------------//
    end // end if(end_of_part_1==0)

`ifndef DISABLE_COPPRV
        flg_zone_prv = flg_zone ;
        called = called + 1 ;
`endif // COPPRV

    // end // End of COPPRV_model

    //-----------------------------------------------------------*
    //* Adding punchthrough current.
    //*-----------------//
    Idsorg = Ids ;
    IdsPT1 = 0.0 ;
    if (COPT > 0 && MUPT > 0.0) begin
// ---- begin `include "HSMSOI_eval_newPT.inc" ----
/***********************************************************************

 HiSIM (Hiroshima University STARC IGFET Model)
 Copyright (C) 2000-2016 Hiroshima University and STARC
 Copyright (C) 2016-2021 Hiroshima University
 HiSIM_SOI (Silicon-On-Insulator Model)
 Copyright (C) 2012-2016 Hiroshima University and STARC
 Copyright (C) 2016-2021 Hiroshima University

 MODEL NAME : HiSIM_SOI
 ( VERSION : 1  SUBVERSION : 5  REVISION : 0 )
 Model Parameter 'VERSION' : 1.50
 FILE : HSMSOI_eval_newPT.inc

 Date : 2021.10.08

 released by Hiroshima University

***********************************************************************/
//
////////////////////////////////////////////////////////////////
//
//
//Licensed under the Educational Community License, Version 2.0
//(the "License"); you may not use this file except in
//compliance with the License.
//
//You may obtain a copy of the License at:
//
//      http://opensource.org/licenses/ECL-2.0
//
//Unless required by applicable law or agreed to in writing,
//software distributed under the License is distributed on an
//"AS IS" BASIS, WITHOUT WARRANTIES OR CONDITIONS OF ANY KIND,
//either express or implied. See the License for the specific
//language governing permissions and limitations under the
//License.
//
//
//The HiSIM_SOI standard has been supported by the members of
//Silicon Integration Initiative's Compact Model Coalition. A
//link to the most recent version of this standard can be found
//at:
//
//http://www.si2.org/cmc
//
////////////////////////////////////////////////////////////////
//

begin : HSMSOI_eval_newPT
    // Use this module when COPT > 0 and MUPT > 0.0.
`define C_PHI__MINIMUM (1e-7)

    real dphi_vds , wk , Vbs , phim , UC_WK_NJUNC ;
    real Vbipn , Leff , Ec , T1w ;
    real Ps0 , t_SOI , Vgp , wk_Vth ;       // protect external Ps0 and beta
    real WK_XJ , WK_Mu , WK_JNPT_A ;
    real conpt00 , conpt0 ;
    real sq1npt  , Qn0npt ;

    real wfactor; // accounts for diminished influence exerted by gate; in aid of depletion width
    real wQbu, Wdep, delta;    // depletion width in association with Ps0//
    real T5sign, T5y; // 20190507

    Leff  = Lgleff ;
    t_SOI = `t_SOI ;
    Vgp   = Vgs - Vfb + dVth - dPpg - VFBPT ; // 20180221
    wk_Vth = Vth + VFBPT ;                    // 20180221
    WK_Mu = MUPT ;
    WK_XJ = XJPT ;
    UC_WK_NJUNC = MKS_NJUNC ;
    Vbipn = beta_inv* ln(UC_WK_NJUNC/Nin * Nsub/Nin); //  All conc here in 1/m^3.
    Vbs  = (COBCNODE == 1) ? Vbsz2 : phi_b0_SOI ;  // for SOI

    Ec = sqrt( 2 * `C_QE * (Vbipn - Vbs)/`C_ESI* Nsub * UC_WK_NJUNC/(Nsub+UC_WK_NJUNC)); //
    // Potential build-up (lowering potential barrier seen from source) due to Vds.
    wk   = Ec * Leff;                      // [V]  positive
    dphi_vds = -0.25 * wk*wk / (Vds + wk); // [V] negative

// ---- begin `include "HSMSOI_analyticalPs0.inc" ----
/***********************************************************************

 HiSIM (Hiroshima University STARC IGFET Model)
 Copyright (C) 2000-2016 Hiroshima University and STARC
 Copyright (C) 2016-2021 Hiroshima University
 HiSIM_SOI (Silicon-On-Insulator Model)
 Copyright (C) 2012-2016 Hiroshima University and STARC
 Copyright (C) 2016-2021 Hiroshima University

 MODEL NAME : HiSIM_SOI
 ( VERSION : 1  SUBVERSION : 5  REVISION : 0 )
 Model Parameter 'VERSION' : 1.50
 FILE : HSMSOI_analyticalPss.inc

 Date : 2021.10.08

 released by Hiroshima University

***********************************************************************/
//
////////////////////////////////////////////////////////////////
//
//
//Licensed under the Educational Community License, Version 2.0
//(the "License"); you may not use this file except in
//compliance with the License.
//
//You may obtain a copy of the License at:
//
//      http://opensource.org/licenses/ECL-2.0
//
//Unless required by applicable law or agreed to in writing,
//software distributed under the License is distributed on an
//"AS IS" BASIS, WITHOUT WARRANTIES OR CONDITIONS OF ANY KIND,
//either express or implied. See the License for the specific
//language governing permissions and limitations under the
//License.
//
//
//The HiSIM_SOI standard has been supported by the members of
//Silicon Integration Initiative's Compact Model Coalition. A
//link to the most recent version of this standard can be found
//at:
//
//http://www.si2.org/cmc
//
////////////////////////////////////////////////////////////////
//

begin : HSMSOI_analyticalPs0

    real Vbs , Vth ; // different from outside
    Vbs = dphi_vds ;
    Vth = wk_Vth ;

    //-----------------------------------------------------------*
    //* Initial guess for Ps0. (start)
    //*-----------------//
    //---------------------------------------------------*
    //* Ps0_iniA: solution of subthreshold equation assuming zone-D1/D2.
    //*-----------------//
    TX = 1.0e0 + 4.0e0 * ( beta * ( Vgp - Vbs ) - 1.0e0 ) / ( fac1p2 * beta2 ) ;
    TX = `Fn_Max( TX , `epsm10 ) ;
    Ps0_iniA = Vgp + fac1p2 * beta * 0.5 * ( 1.0e0 - sqrt( TX ) ) ;

    // use analytical value in subthreshold region. //
    if ( Vgs <( Vfb + Vth ) * 0.5 ) begin
        flg_pprv = 0 ;
    end

    if ( flg_pprv == 0 || 1) begin

        //---------------------------------------------------*
        //* Analytical initial guess.
        //*-----------------//
        //-------------------------------------------*
        //* Common part.
        //*-----------------//
        Chi = beta * ( Ps0_iniA - Vbs ) ;
        if ( Chi < `znbd3 ) begin
            //-----------------------------------*
            //* zone-D1/D2
            //* - Ps0_ini is the analytical solution of Qs=Qb0 with
            //*   Qb0 being approximated to 3-degree polynomial.
            //*-----------------//
            TY = beta * ( Vgp - Vbs ) ;
            T1 = 1.0e0 / ( `cn_nc3 * beta * fac1 ) ;
            T2 = 81.0 + 3.0 * T1 ;
            T3 = -2916.0 - 81.0 * T1 + 27.0 * T1 * TY ;
            T4 = 1458.0 - 81.0 * ( 54.0 + T1 ) + 27.0 * T1 * TY ;
            T4 = T4 * T4 ;
            T5 = `Fn_Pow( T3 + sqrt( 4 * T2 * T2 * T2 + T4 ) , `C_1o3 ) ;
            TX = 3.0 - ( `C_2p_1o3 * T2 ) / ( 3.0 * T5 )
              + 1.0 / ( 3.0 * `C_2p_1o3 ) * T5 ;
            Ps0_iniA = TX * beta_inv + Vbs ;
            Ps0_ini = Ps0_iniA ;
        end else if ( Vgs - shift <= Vth ) begin
            //-----------------------------------*
            //* Accumulation & Weak inversion zone.
            //*-----------------//
            if (COBCNODE==0) begin
                T0 = 1.0 / C_fox ;
                T1 = t_SOI / `C_ESI ;
                T2 = 1.0 / C_box ;
                T3 = 1.0 / (T0 + T1 + T2) ;
                T4 = T3 * (Vgp - Vbsbiz + (T2 + 0.5 * T1) * (-Q_s0_dep_ini)) ;
                Ps0_iniA = Vgp - T4 / C_fox ;
            end
            Ps0_ini = Ps0_iniA ;
        end else begin
            //-----------------------------------*
            //* Strong inversion zone.
            //* - Ps0_iniB : upper bound.
            //*-----------------//
            T1 = 1.0 / cnst1SOI / cnstC_foxi ;
            T2 = T1 * (Vgp - shift) * (Vgp - shift) ;
            T3 = beta + 2.0 / (Vgp - shift) ;
            Ps0_iniB = ln ( T2 ) / T3 + PSLIMPT ;
            `Fn_SUtemp( Ps0_ini , Ps0_iniA, Ps0_iniB, `c_ps0ini_2)
        end

        if (COBCNODE==0) begin
            if ( Vgs - shift <= Vth ) begin
                //-----------------------------------*
                //* Accumulation & Weak inversion zone.
                //*-----------------//
                T0 = 1.0 / C_fox ;
                T1 = t_SOI / `C_ESI ;
                T2 = 1.0 / C_box ;
                T3 = 1.0 / (T0 + T1 + T2) ;
                T4 = T3 * (Vgp - Vbsbiz + (T2 + 0.5 * T1) * (-Q_s0_dep_ini)) ;
                Ps0_iniA = Vgp - T4 / C_fox ;
                Ps0_ini = Ps0_iniA ;
            end else begin
                //---------------------------------------------------*
                //* Ps0_iniA: solution of subthreshold equation assuming zone-D1/D2.
                //*-----------------//
                // begin
                T0 = 1.0 / C_fox ;
                T1 = t_SOI / `C_ESI ;
                T2 = 1.0 / C_box ;
                T3 = 1.0 / (T0 + T1 + T2) ;
                T4 = T3 * (Vgp - Vbsbiz + (T2 + 0.5 * T1) * (-Q_s0_dep_ini)) ;
                Ps0_iniA = Vgp - T4 / C_fox ;
                // end
                Ps0_ini = Ps0_iniA ;

                if ( Vgp - shift > 0 ) begin // for smoothing
                    //---------------------------------------------------*
                    //* Analytical initial guess.
                    //*-----------------//
                    //-------------------------------------------*
                    //* Common part.
                    //*-----------------//
                    T1 = 1.0 / cnst1SOI / cnstC_foxi ;
                    T2 = T1 * (Vgp - shift) * (Vgp - shift) ;
                    T3 = beta + 2.0 / (Vgp - shift) ;
                    Ps0_iniB = ln (T2) / T3 + PSLIMPT ;
                    `Fn_SU_CP(Ps0_ini, Ps0_iniA, Ps0_iniB * 0.98 , 0.4 , 2)
                end // End of smoothing
            end // End of FD
        end // COBCNODE==0
    end // Vgs <( Vfb + Vth ) * 0.5
    TX = Vbs + `ps_conv / 2 ;
    if ( Ps0_ini < TX ) Ps0_ini = TX ;

    //---------------------------------------------------*
    //* Assign initial guess.
    //*-----------------//
    Ps0 = Ps0_ini ;
    Psl_lim = Ps0_iniA ;

    if ( 0 ) begin
        Pds_max = `Fn_Max( Ps0_iniA - Ps0 , 0.0e0 ) ;
        `Fn_SUtemp( Pds_ini , PSLIMPT , (1.0e0 + `c_pslini_1) * Pds_max, `c_pslini_2 )
        Pds_ini = `Fn_Min( Pds_ini , Pds_max ) ;
        if ( Pds_ini < 0.0 ) Pds_ini = 0.0 ;
        else if ( Pds_ini > Vds ) Pds_ini = Vds ;
        Psl_lim = Ps0 + Pds_ini  ;
    end

    // Initial guess for Ps0. (end) //

end // block: newPunchAnalyticalPs0
// ---- end `include "HSMSOI_analyticalPs0.inc" ----
    if (COPSPT==1) begin
        Ps0_ini = Ps0 ;
// ---- begin `include "HSMSOI_iterativePs0.inc" ----
/***********************************************************************

 HiSIM (Hiroshima University STARC IGFET Model)
 Copyright (C) 2000-2016 Hiroshima University and STARC
 Copyright (C) 2016-2021 Hiroshima University
 HiSIM_SOI (Silicon-On-Insulator Model)
 Copyright (C) 2012-2016 Hiroshima University and STARC
 Copyright (C) 2016-2021 Hiroshima University

 MODEL NAME : HiSIM_SOI
 ( VERSION : 1  SUBVERSION : 5  REVISION : 0 )
 Model Parameter 'VERSION' : 1.50
 FILE : HSMSOI_iterativePs0.inc

 Date : 2021.10.08

 released by Hiroshima University

***********************************************************************/
//
////////////////////////////////////////////////////////////////
//
//
//Licensed under the Educational Community License, Version 2.0
//(the "License"); you may not use this file except in
//compliance with the License.
//
//You may obtain a copy of the License at:
//
//      http://opensource.org/licenses/ECL-2.0
//
//Unless required by applicable law or agreed to in writing,
//software distributed under the License is distributed on an
//"AS IS" BASIS, WITHOUT WARRANTIES OR CONDITIONS OF ANY KIND,
//either express or implied. See the License for the specific
//language governing permissions and limitations under the
//License.
//
//
//The HiSIM_SOI standard has been supported by the members of
//Silicon Integration Initiative's Compact Model Coalition. A
//link to the most recent version of this standard can be found
//at:
//
//http://www.si2.org/cmc
//
////////////////////////////////////////////////////////////////
//

begin : HSMSOI_iterativePs0

    real Vbcs_cl , phi_s0_SOI ;

    //-----------------------------------------------------------*
    //Solve Poisson's equation for BT devices
    //----------------//
    Vbcs_cl = dphi_vds ;

    // Start of hsmsoieval_btsolps.h //

    //-----------------------------------------------------------*
    //* Accumulation zone. (zone-A)
    //* - evaluate basic characteristics and exit from this part.
    //*-----------------//
    Vgs_fb = Vfb - dVth + dPpg + Vbcs_cl + VFBPT ; // for BTSOI //
    if ( Vgs < Vgs_fb ) begin
        flg_zone = -1 ;

        //---------------------------------------------------*
        //* Evaluation of Ps0.
        //* - Psa : Analytical solution of
        //*             C_fox( Vgp - Psa ) = cnst0SOI * Qacc
        //*         where Qacc is the 3-degree series of(fdep)^{1/2}.
        //*         The unknown  is transformed to Chi=beta(Ps0-Vbs).
        //* - Ps0_min : |Ps0_min| when Vbs=0.
        //*-----------------//
        // Ps0_min: approx. solution of Poisson equation at Vgs_min //
        //          ( easy to improve, if necessary  )              //
        //    Ps0_min = Eg - Pb2 ;
        Ps0_min = 2.0 * beta_inv * ln (-Vgs_min/fac1) ;
        TX = beta * ( Vgp - Vbcs_cl ) ;
        T1 = 1.0 / ( beta * cnst0SOI ) ;
        TY = T1 * C_fox ;
        Ac41 = 2.0 + 3.0 * `C_SQRT_2 * TY ;
        Ac4 = 8.0 * Ac41 * Ac41 * Ac41 ;
        T4 = ( TX - 2.0 ) ;
        T5 = 9.0 * TY * T4 ;
        Ac31 = 7.0 * `C_SQRT_2 - T5 ;
        Ac3 = Ac31 * Ac31 ;
        if ( Ac4 < Ac3 * 1.0e-8 ) begin
            Ac1 = -7.0 * `C_SQRT_2 + Ac31 + 0.5 * Ac4 / Ac31 + T5 ;
        end else begin
            Ac2 = sqrt( Ac4 + Ac3 ) ;
            Ac1 = -7.0 * `C_SQRT_2 + Ac2 + T5 ;
        end
        Acd = `Fn_Pow( Ac1 , `C_1o3 ) ;
        Acn = -4.0 * `C_SQRT_2 - 12.0 * TY + 2.0 * Acd + `C_SQRT_2 * Acd * Acd ;
        T1 = 1.0 / Acd ;
        Chi = Acn * T1 ;
        Psa = Chi * beta_inv + Vbcs_cl ;
        T1 = Psa - Vbcs_cl ;
        T2 = T1 / Ps0_min ;
        T3 = sqrt( 1.0 + ( T2 * T2 ) ) ;
        Ps0 = T1 / T3 + Vbcs_cl ;

    end else begin //if( Vgs < Vgs_fb ) begin

        //---------------------------------------------------*
        //* Calculation of Ps0. (beginning of Newton loop)
        //* - Fs0 : Fs0 = 0 is the equation to be solved.
        //* - dPs0 : correction value.
        //*-----------------//
        exp_bVbsVds = exp( beta * ( Vbcs_cl - PSLIMPT ) ) ;
        flg_conv = 0 ;

        phi_s0_SOI = Ps0_ini ;

        dphi_sb = q_Nsub * `t_SOI * `t_SOI / 2.0 / `C_ESI ;
        T0 = sqrt(2.0 * beta * dphi_sb) ;
        T1 = (exp(T0) + exp(-T0)) / 2 ;
        c_sb = ln(T1) / dphi_sb ;

        for ( lp_s0 = 1 ; lp_s0 <= lp_s0_max + 1 ; lp_s0 = lp_s0 + 1 ) begin
            phi_SOI0 = phi_s0_SOI - Vbcs_cl ;
            Chi = beta * phi_SOI0 ;

            TY = c_sb * (phi_SOI0 - dphi_sb) ;
            if ( TY < `large_arg ) begin
                T1 = exp(TY) ;
                T0 = exp(- c_sb * dphi_sb) ;
                T2 = T1 - T0 ;
                phi_SOIb = ln(1 + T2) / c_sb ;
                phi_SOIb_dPss = T1 / (1 + T2) ;
            end else begin
                phi_SOIb = phi_SOI0 - dphi_sb ;
                phi_SOIb_dPss = 1 ;
            end
            Chib = beta * phi_SOIb ;

            if (abs(Chi) < 1E-16) begin
                T0 = sqrt((1 - phi_SOIb_dPss * phi_SOIb_dPss) / 2) ;
                fb = Chi * T0 ;
                fb_dPss = beta * T0 ;
                if (Chi < 0) begin
                    fb = -fb ;
                    fb_dPss = -fb_dPss ;
                end
            end else if (abs(Chi) < 5E-3) begin

                T0 = Chi * Chi / 2 * (1 - Chi / 3 * (1 - Chi / 4 * (1 - Chi / 5))) ;
                T1 = Chi * (1 - Chi / 2 * (1 - Chi / 3 * (1 - Chi / 4))) ;
                T2 = Chib * Chib / 2 * (1 - Chib / 3 * (1 - Chib / 4 * (1 - Chib / 5))) ;
                T3 = Chib * (1 - Chib / 2 * (1 - Chib / 3 * (1 - Chib / 4))) ;
                fb = sqrt(T0 - T2) ;
                fb_dPss = beta * 0.5 * (T1 - phi_SOIb_dPss * T3) / fb ;
            end else begin
                //-------------------------------------------*
                //* zone-D3.  (phi_s0_SOI)
                //*-----------------//

                T0 = exp(-Chi) ;
                T1 = exp(-Chib) ;
                fb = sqrt(Chi - Chib + (T0 - T1)) ;
                fb_dPss = beta * 0.5 * (1 - T0 - phi_SOIb_dPss * (1 - T1)) / fb ;
            end // check nest level. ok. //if (abs(Chi) < 1E-8) begin

            if (flg_conv == 1 && Chi < 0.0) begin
                flg_zone = -1 ;
            end

            if (Chi < 0) begin
                fs02 = -fb ;
                fs02_dPs0 = -fb_dPss ;
            end else if (Chi < 1E-7) begin
                fs02 = fb ;
                fs02_dPs0 = fb_dPss ;
            end else begin
                Rho = beta * ( phi_s0_SOI - PSLIMPT ) ;
                exp_Rho = exp( Rho ) ;
                fs01 = cnst1SOI * ( exp_Rho - exp_bVbsVds * (Chi + 1) ) ;
                fs01_dPs0 = cnst1SOI * beta * ( exp_Rho - exp_bVbsVds ) ;
                fs02 = sqrt(fb * fb + fs01) ;
                fs02_dPs0 = 0.5 * (2 * fb_dPss * fb + fs01_dPs0) / fs02 ;
            end

            // Revised Fs0 //
            Fs0 = - Vgp + phi_s0_SOI + fac1 * fs02 ;
            Fs0_dPs0 = 1.0 + fac1 * fs02_dPs0 ;
            if ( flg_conv == 1 ) begin
                lp_s0 = lp_s0_max+1 ; // break
            end else begin
                dPs0 = - Fs0 / Fs0_dPs0 ;

                //-------------------------------------------*
                //* Update Ps0 .
                //* - clamped to Vbcs_cl if Ps0 < Vbcs_cl .
                //*-----------------//
                dPlim = 0.5*`dP_max*(1.0 + `Fn_Max(1.0e0,abs(phi_s0_SOI))) ;
                if ( abs( dPs0 ) > dPlim ) dPs0 = dPlim * `Fn_Sgn( dPs0 ) ;
                phi_s0_SOI = phi_s0_SOI + dPs0 ;

                //-------------------------------------------*
                //* Check convergence.
                //* NOTE: This condition may be too rigid.
                //*-----------------//
                if ( abs( dPs0 ) <= `ps_conv && abs( Fs0 ) <= `gs_conv ) begin
                    flg_conv = 1 ;
                end

            end
        end // end of phi_s0_SOI Newton loop //

        Ps0 = phi_s0_SOI ;
        //     $write("Ps0_ini %g Vbcs_cl %g flg_conv %d Ps0 %g \n",
        //     Ps0_ini,Vbcs_cl,flg_conv,Ps0);

    end // end of if( Vgs < Vgs_fb )

end //  Ps0_newPT
// ---- end `include "HSMSOI_iterativePs0.inc" ----
    end

    // From Ps0 here, depletion width will be estimated.
    T5 = -beta *(Ps0 - dphi_vds);

    T5sign= ( T5 >= 0.0 ?  1.0 : -1.0); // 20190507
    T5y=  T5sign * T5; // positive         20190507

    T6 = exp(T5);
    T7= T6 - 1.0 - T5;

    if (T5 > `C_PHI__MINIMUM) begin                                                     // 20190507
        Qbu = -cnst0SOI*sqrt(T7); // sign inverted; accumulation side                    // 20190507
    end else if (T5y >`C_PHI__MINIMUM)  begin                                           // 20190507
        Qbu =  cnst0SOI*sqrt(T7); // sign inverted; depletion, inversion side            // 20190507
    end else begin // avoid loss of accuracy                                                  // 20190507
        Qbu = -T5sign * T5y * `C_SQRT_2inv * sqrt(1.0+ T5y*`C_1o3*(1.0+0.25*T5y)); // 20190507
    end

    //org      if (T5 >= `C_PHI__MINIMUM) begin
    //org         Qbu = -cnst0SOI*sqrt(T7); // sign inverted; accumulation side
    //org      end else begin
    //org         Qbu =  cnst0SOI*sqrt(T7); // sign inverted; depletion, inversion side
    //org      end
    `Fn_SZtemp(wQbu, Qbu, 1e-6)
    Wdep = wQbu / (`C_QE * Nsub) ;
    T1 = Wdep - WK_XJ ;
    delta = Wdep*0.01;
    `Fn_SZtemp(T2, T1, delta)  // protection against negative T1 ( i.e. Wdep < WK_XJ)
    wfactor = T2/Wdep*T2/Wdep; // area ratio between small and large triangles

    phim = (Ps0 - dphi_vds) * wfactor + dphi_vds; // measured from source
    TY = exp(beta*phim) - exp(beta*(phim-Vds));   // 20180215

    conpt00 = sqrt (2.0 * `C_QE * UC_WK_NJUNC * `C_ESI );
    conpt0 = conpt00 * sqrt(beta_inv) ;
    T1w = beta * (phim - dphi_vds) ;
    `Fn_SL_CP( T1 , T1w , 0 , 0.2*beta , 1 )
    sq1npt = sqrt (T1 + `epsm10);
    Qn0npt = conpt0 * sq1npt ;
    WK_JNPT_A = 2.0 * beta_inv / Leff * Qn0npt ;

    IdsPT1 = WK_JNPT_A * WK_Mu * weff_nf * TY ;
    Ids   = Idsorg + IdsPT1 ;

end // newPT_model
// ---- end `include "HSMSOI_eval_newPT.inc" ----
    end //

    IdsPT = IdsPT0 + IdsPT1 ;

    //*++++++++++++++++++++++++++++++++++++++++++++++++++++++++++++//
    //* PART-2: Substrate / gate / leak currents
    //*++++++++++++++++++++++++++++++++++++++++++++++++++++++++++++//

    if ( COBCNODE == 1 || COISUBFB == 1 ) begin
        //-----------------------------------------------------------*
        //* Isub : substrate current induced by impact ionization.
        //*-----------------//
        begin : IsubModel
            real T1, T2, T3, T4, T5, T6,T6w, T7, T8, T9;
            real Psislsat, Psisubsat;

            if ( flg_noqi == 1 || COISUB == 0 ) begin
                // Accumulation zone or nonconductive case, in which Ids==0. //
                Isub = 0.0e0 ;
            end else begin
                //-------------------------------------------*
                //* Conductive case.
                //*-----------------//
                if (SUB1 <= 0.0 || MKS_VMAX <= 0.0) begin
                    Isub = 0.0 ;
                end else begin
                    Vgpsub = Vgsz - vfbsub0 + dVth - dPpg + DVGPSUB ;
                    if ( COSUBSCALE <= 0 ) begin //version 1.4.0:
                        T1 = Vgpsub ;
                        T7 = C_fox * C_fox ;
                        T8 = qnsub_esi ;
                        T3 = T8 / T7 ;
                        T9 = 2.0 / T8 ;
                        T4 = T9 * T7 ;
                        T5 = T1 - beta_inv - `X_vbs * Vbspz ;
                        dVbssub = DVBSSUB * Qhs / C_soi ;
                        T5 = T5 - `X_vbs * dVbssub ;
                        T6w = 1.0 + T4 * T5 ;
                        `Fn_SZtemp(T6, T6w, 1.0e-3)
                        T6 = T6 + `Small ;
                        T6 = sqrt(T6) ;
                        Psislsat = T1 * `X_vgs + T3 * (1.0 - T6) ;
                        Psisubsat = `X_vds * Vdsz + Ps0z - `X_slg * `Z_vgs * Psislsat ;
                        `Fn_SZtemp(Psisubsat, Psisubsat, 1.0e-2)  // delta can be 1e-3 //
                    end else begin //version 1.5.0:
                        T1 = vg2const * Vgpsub ;
                        T3 = qnsub_esi / (C_fox * C_fox) ;
                        T4 = 2.0 / qnsub_esi * (C_fox * C_fox) ;
                        T5 = T1 - beta_inv - xvbs * Vbspz ;
                        dVbssub = DVBSSUB * Qhs / C_soi ;
                        T5 = T5 - xvbs * dVbssub ;
                        T6 = 1.0 + T4 * T5 ;
                        T7 = 2.0 * ( 1.0 + T4 ) ;
                        `Fn_SL_CP( T6 , T6 , `Small, T7 , 4 )
                        T6 = (T6 <=0 ) ? 0.0 : sqrt( T6 ) ;
                        Psislsat = T1 + T3 * ( 1.0 - T6 ) ;
                        T2 = LGLE / (xgate + LGLE) ;
                        Psisubsat = SVDS * Vdsz + Ps0z - T2 * Psislsat ;
                        `Fn_SZtemp(Psisubsat, Psisubsat, 1.0e-3)
                    end
                    Psisubsat = Psisubsat + `Small ;
                    T2 = exp(-`X_sub2 / Psisubsat) ;
                    Isub = `X_sub1 * Psisubsat * Ids * T2 ;

                end              // end of !if( sub1 < 0 || vmax < 0 )  //
            end
        end  // IsubModel
    end

    if (COISUB == 1 && COFBE == 2 && COBCNODE == 1) begin
        //---------------------------------------------------------//
        // @@@  Qh vs Isub Calculation // 20201030
        begin : QHSmodel
            real T1, T2, T4, T5, T6, T7, T8, T9;

            // The following values should not be hard-coded. //
            T1 = `C_QE * `t_SOI * weff_nf * exp(-beta * QHE2) ;  // Vbi => qhe2
            T2 = `Lp * `Dn * `Nd + `Ln * `Dp * `N_sub_SOI ;
            T4 = `Lp * `Ln / (T1 * T2) ;
            nume = (Isub ) * T4 ;
            T5 = QHE1 * beta_inv * log1p(nume) ; // qhe1 : fitting param
            `Fn_SUtemp( T5, T5, Pb2, Pb2*0.01 )
            OP_DVBS_FBE = T5; // 20201013 probing

            // Qb(Vb=Vbody) - Qb(Vb=0) //
            T6 = sqrt(2 * `C_ESI * `C_QE * `N_sub_SOI * beta_inv) ;
            T7 = expm1(-beta * (Ps0z - T5)) + beta * (Ps0z - T5) ;
            T7 = (T7 > 0) ? sqrt(T7) : - sqrt(-T7) ;
            T8 = sqrt(expm1(-beta * Ps0z) + beta * Ps0z) ;
            T9 = -T6 * (T7 - T8) ;
            `Fn_SUtemp( Qhs, T9, QHSMAX, QHSMAX*0.01 )

            //             Rsb = HIST1 / (Isub + HIST2) ;
            T1  = (HIST1 > 0) ? HIST1 : 1 ;
            Rsb = T1 / (Isub + HIST2) ;
            tauh = Rsb * C_fox ;
            Qhs_prev = Qhs ;
            Qhs_hist = `NQS_CAP * V(nqs_qhs) ;
            Qhs      =  Qhs_hist ;
            Iqh_nqs  = (Qhs_hist - Qhs_prev) / tauh ;

        end // QHSmodel
    end // COFBE==2

    //---------------------------------------------------*
    //* Impact-Ionization Induced Bulk Potential Change(IBPC)
    //*-----------------//
    begin : ImpactIonizationInducedBulkPotentialChange
        real T0, dVbsIBPC, Xi0, Xi0p12, Xi0p32, Xil, Xilp12, Xilp32, T10, T2, dG3, dG4, dIdd;

        if (flg_noqi == 0 && Isub > 0e0 && IBPC1 != 0e0) begin

            if ( SUBVERSION < 3 ) begin
                Vbs0 = 0.0 ; VbsL = 0.0 ;
            end else begin
                Vbs0= (COBCNODE == 1) ? Vbs : phi_b0_SOI ;
                VbsL= (COBCNODE == 1) ? Vbs : phi_bL_SOI ;
            end
            // delta Vbs //
            T0 = 1e0 + IBPC2 * dVth ;
            dVbsIBPC = IBPC1 * T0 * Isub ;
            // 081127 //
            Xi0 = beta * (Ps0 - Vbs0) - 1.0 ;
            `Fn_SZtemp(Xi0, Xi0, 1e-1)
            Xi0p12 = sqrt(Xi0) ;
            Xi0p32 = Xi0 * Xi0p12 ;
            Xil = beta * (Psl - VbsL) - 1.0 ;
            `Fn_SZtemp(Xil, Xil, 1e-1)
            Xilp12 = sqrt(Xil) ;
            Xilp32 = Xil * Xilp12 ;

            // dG3 & dG4 //
            T10 = 1e0 / Xi0 ;
            T1 = beta * dVbsIBPC * T10 ;
            T10 = 1e0 / Xil ;
            T2 = beta * dVbsIBPC * T10 ;
            dG3 = cnst0SOI * ( Xilp32 * T2 - Xi0p32 * T1 ) ;
            dG4 = cnst0SOI * 0.5 * ( - Xilp12 * T2 + Xi0p12 * T1 ) ;

            // Add IBPC current into Ids //
            dIdd = dG3 + dG4 ;

            IdsIBPC = betaWL * dIdd * Mu ;

        end // End if(IBPC) //
    end // ImpactIonizationInducedBulkPotentialChange

    begin : COIIGS_model
        real TX, T0, T1, T2, T3, T4, T5, T6, T7, T9, T10;
        real Etun, Psdlz;
        real CGS_Tfox0, CGS_C_fox, CGS_Leff, CGS_weff_nf, CGS_Ey, CGS_Qiu, CGS_cnst0SOI;

        CGS_Tfox0 = Tfox0 * `C_m2cm;
        CGS_C_fox = C_fox / `C_m2cm_p2;
        CGS_Leff  = Leff * `C_m2cm;
        CGS_weff_nf =  weff_nf * `C_m2cm;
        CGS_Ey = Ey / `C_m2cm;
        CGS_Qiu = Qiu / `C_m2cm_p2;
        CGS_cnst0SOI = cnst0SOI / `C_m2cm_p2;

        //-----------------------------------------------------------*
        //* Igate : Gate current induced by tunneling.
        //*----------------- from HiSIM 2.5.1 2010.05.21 //
        if (COIIGS == 0) begin
            Igate = 0.0 ;
            Igs = 0.0 ;
            Igd = 0.0 ;
            Igb = 0.0 ;
            GLPART1 = 0.0 ;
        end else begin

            // Igate //
            if (flg_noqi == 0) begin
                Psdlz = Ps0z + Vdsz - `epsm10 ;
                T1 = Vgsz - Vfb + GLEAK4 * (dVth - dPpg) * CGS_Leff - Psdlz * GLEAK3 ;

                T3 = 1.0 / CGS_Tfox0 ;
                T2 = T1 * T3 ;
                T3 = 1.0 / GLEAK5 ;
                T7 = 1.0 + CGS_Ey * T3 ;
                Etun = T2 * T7 ;
                `Fn_SZtemp(Etun, Etun, `igate_dlt)
                `Fn_SZtemp(T3, Vgsz, 1.0e-3)
                T3 = T3 - VZADD0 ;
                TX = T3 / `cclmmdf ;
                T2 = 1.0 + TX * TX ;
                T1 = 1.0 - 1.0 / T2 ;
                Etun = Etun * T1 ;
                T0 = CGS_Leff * CGS_weff_nf ;
                T7 = GLEAK7 / (GLEAK7 + T0) ;
                T6 = GLEAK6 ;
                T9 = T6 / (T6 + Vdsz) ;
                T4 = 1.0 / (Etun + `Small ) ;
                T1 = - GLEAK2 * Egp32 * T4 ;
                if (T1 < -`EXP_THR) begin
                    Igate = 0.0 ;
                end else begin
                    T2 = exp(T1) ;
                    T3 = GLEAK1 / Egp12 * `C_QE * T0 ;
                    T5 = 1.0 / CGS_cnst0SOI ;
                    T6 =  sqrt ((CGS_Qiu + CGS_C_fox * `VgVt_Small )* T5 ) ;
                    T4 =  T2 * T3 * T6 ;
                    T10 = T4 * Etun * Etun ;
                    Igate = T7 * T9 * T10 ;
                end
            end else begin
                Igate = 0.0 ;
            end

            // Igs //
            T0 = -GLKSD2 * Vgs + GLKSD3 ;
            T2 = exp(CGS_Tfox0 * T0) ;
            T0 = Vgs / CGS_Tfox0 / CGS_Tfox0 ;
            T3 = Vgs * T0 ;
            T4 = GLKSD1 / 1.0e6 * CGS_weff_nf ;
            Igs = T4 * T2 * T3 ;
            if (Vgs >= 0.0e0) begin
                Igs = Igs * -1.0 ;
            end

            // Igd //
            T1 = Vgs - Vds ;
            T0 = -GLKSD2 * T1 + GLKSD3 ;
            T2 = exp(CGS_Tfox0 * T0) ;
            T0 = T1 / CGS_Tfox0 / CGS_Tfox0 ;
            T3 = T1 * T0 ;
            T4 = GLKSD1 / 1.0e6 * CGS_weff_nf ;
            Igd = T4 * T2 * T3 ;
            if (T1 >= 0.0e0) begin
                Igd = Igd * -1.0 ;
            end

            // Igb //
            Etun = (-Vgs + Vbsp + Vfb + GLKB3) / CGS_Tfox0 ;
            `Fn_SZtemp(Etun, Etun, `igate_dlt)
            Etun = Etun + `Small ;
            T1 = -GLKB2 / Etun ;
            if (T1 < -`EXP_THR) begin
                Igb = 0.0 ;
            end else begin
                T2 = exp(T1) ;
                T3 = GLKB1 * CGS_weff_nf * CGS_Leff ;
                Igb = T3 * Etun * Etun * T2 ;
            end
            GLPART1 = 0.5 ;
        end                // if( coiigs == 0 ) //
    end  // COIIGS_model

    begin : COGIDL_model
        real T1, T2, E1, T3, T0, T5;
        real Vdb;

        //-----------------------------------------------------------*
        //* Igidl : GIDL
        //*----------------- from HiSIM 2.5.1 2010.05.21 //
        if (COGIDL == 0) begin
            Igidl = 0.0e0 ;
        end else begin
            T1 = GIDL3 * (Vds + GIDL4) - Vgs + (dVthSC + dVthLP) * GIDL5 ;
            T2 = 1.0 / Tfox0 ;
            E1 = T1 * T2 ;
            `Fn_SZtemp(Egidl, E1, `eef_dlt)
            T3 = 1.0 / (Egidl + `Small) ;
            T0 = - GIDL2 * Egp32 * T3 ;
            if (T0 < -`EXP_THR) begin
                Igidl = 0.0 ;
            end else begin
                T1 = exp(T0) ;
                T2 = GIDL1 / Egp12 * `C_QE * weff_nf ;
                Igidl = T2 * Egidl * Egidl * T1 ;
            end
            Vdb = Vds - Vbsp ;
            if (Vdb > 0.0) begin
                T2 = Vdb * Vdb ;
                T4 = T2 * Vdb ;
                //T0 = T4 + `C_gidl_delta ;
                T0 = T4 + GIDLVB ; // 20190606 Vb dep.
                T5 = T4 / T0 ;
                Igidl = Igidl * T5 ;
            end else begin
                Igidl = 0.0 ;
            end

        end
    end // COGIDL_model

    //-----------------------------------------------------------*
    //* Igisl : GISL
    //*----------------- from HiSIM 2.5.1 2010.05.21 //
    begin : COGISL_model
        real T1, T2, E1, T3, T0, T5;
        real Vsb ;

        if (COGIDL == 0) begin
            Igisl = 0.0e0 ;
        end else begin
            T1 = GIDL3 * (-Vds + GIDL4)
                 - (Vgs - Vds) + (dVthSC + dVthLP) * GIDL5 ;
            T2 = 1.0 / Tfox0 ;
            E1 = T1 * T2 ;
            `Fn_SZtemp(Egisl, E1, `eef_dlt)
            T3 =  1  / (Egisl + `Small) ;
            T0 = - GIDL2 * Egp32 * T3 ;
            if (T0 < -`EXP_THR) begin
                Igisl = 0.0 ;
            end else begin
                T1 = exp(T0) ;
                T3 = 1.0 / Egp12 ;
                T2 = GIDL1 * T3 * `C_QE * weff_nf ;
                Igisl = T2 * Egisl * Egisl * T1 ;
            end
            Vsb = -Vbsp ;
            if (Vsb > 0.0) begin
                T2 = Vsb * Vsb ;
                T4 = T2 * Vsb ;
                //T0 = T4 + `C_gidl_delta ;
                T0 = T4 + GIDLVB ;
                T5 = T4 / T0 ;
                Igisl = Igisl * T5 ;
            end else begin
                Igisl = 0.0 ;
            end

        end
    end // COGISL_model

    //-----------------------------------------------------------*
    //End of PART-2. (label)
    //----------------//
    // end_of_part_2: ; //

    if ( COBCNODE == 1 ) begin

        //++++++++++++++++++++++++++++++++++++++++++++++++++++++++++++
        //PART-3:Parasitic charge                           2013.02.12
        // Intrinsic charge for parasitic MOSFET built over body-contact well
        // and Overlap charge for intrinsic MOSFET)
        //+++++++++++++++++++++++++++++++++++++++++++++++++++++++++++//

        //Begin of include ---Intrinsic charge for parasitic MOSFET built over body-contact well---
        begin : IntrinsicChargeForMOSFEToverBodyContact
            real    T0, T1, T2, T3, T5,  T10, T11;
            real    TX, TY;
            real    Cox0, Cox0_inv;
            real    flg_ovloops, flg_ovloopd; //changed from integer for VAMPyRE WARNING//
            integer flg_overs, flg_overd, lcover, flg_ovzone, flg_conv;
            integer lp_ld, lbt;
            real    Vxbgmt, Vxbgmtcl;
            real    Vbsgmt, Vdsgmt, Vgsgmt, Vgdgmt, Vdbgmt, Vsbgmt, Vgbgmt;
            real    cnst0over;
            real    fac1, fac1p2, VgpLD, Pb2over, Vgb_fb_LD;
            real    Ac41, Ac4, Ps0_min, Ac31, Ac3, Ac2, Ac1, Acd, Acn, Chi, Psa, Ps0LD, Ps0_iniA;
            real    Ta, Tb, Tc, Td, Tq, Tp, Tu, Tv;
            real    VgpLD_shift, cnst1over, gammaChi, psi, Chi_1, Chi_B, Chi_A;
            real    exp_bVbs, fi, fi_dChi, fs01, fs01_dPs0, fb, fb_dChi, fs02, fs02_dPs0;
            real    cfs1, exp_bPs0, Fs0, Fs0_dPs0, dPlim;
            real    Xi0, Xi0p12;
            // Some constants to be used here.
            Cox0 = C_fox0;
            Cox0_inv = 1.0 / Cox0 ;

            fs01 = 0.0;
            fb   = 0.0;
            fs02 = 0.0;

            T2 = -area_bt_n  ; // adding BT area
            T3 = T2 * Qiu ;
            T4 = T3 + T2 * Qbu ;
            Qbody_bt_n_iud = T3 * Qdrat ;
            Qbody_bt_n_ius = T3 - Qbody_bt_n_iud ;
            Qbody_bt_n_sud = T4 * Qdrat ;
            Qbody_bt_n_sus = T4 - Qbody_bt_n_sud ;

            /* Calc Voltage depends cap for body contact */
            if ( COADOV ) begin
                UC_NSUBBTTUB = Nsub;

                for ( lbt = 1 ; lbt <= 1 ; lbt = lbt +1 ) begin
                    //     lbt : 1 ( P+Poly ) , 2 ( N+Poly )
                    CBTB_GIVEN = 0 ;
                    case (lbt)
                        1 : begin // ( P+Poly )
                            UC_AREABT = area_bt_p * 0.5 ;
                            UC_VFBBT  = VFBBTP ;
                            CBTB_GIVEN = CBTBP_GIVEN ;
                        end
                        2 : begin // ( N+Poly )
                            UC_AREABT = area_bt_n * 0.5 ;
                            UC_VFBBT  = VFBC ;
                            CBTB_GIVEN = CBTBN_GIVEN ;
                            CBTB_GIVEN = 1 ;
                        end
                    endcase // case (lbt)
                    //

                    if ( CBTB_GIVEN == 0 ) begin
                        //
                        cnst0over = cnst0SOI * sqrt(UC_NSUBBTTUB / Nsub ) ;
                        // Following for-loop construct was intended for surface-potential based overlap charge used somewhere else;
                        // now recycled for MOSFET built in body contact tub.
                        // If charge partition to S and D does matter, activate for-loop counting twice.
                        for ( lcover = -1 ; lcover <= +1 ; lcover = lcover + 2 ) begin  // source side only

                            flg_ovloops = ( 1 - lcover ) / 2.0 ; // 1 in Source overlap calc. // //for VAMPyRE WARNING//
                            flg_ovloopd = ( 1 + lcover ) / 2.0 ; // 1 in Drain overlap calc. // //for VAMPyRE WARNING//
                            //-------------------------------------------*
                            //* Qover(G/D overlap charge)  |  note: _dVxs means _dVxse
                            //*------------------------//
                            Vbsgmt = ModeNML * Vbs + ModeRVS * ( Vbs - Vds ) ;
                            Vdsgmt = ModeNML * Vds + ModeRVS * ( - Vds ) ;
                            Vgsgmt = ModeNML * Vgs + ModeRVS * ( Vgs - Vds ) ;
                            Vgdgmt = ModeRVS * Vgs + ModeNML * ( Vgs - Vds ) ;
                            Vdbgmt = Vdsgmt - Vbsgmt ;
                            Vsbgmt = - Vbsgmt ;
                            flg_overs = flg_ovloops * ModeNML + flg_ovloopd * ModeRVS ; // geometrical source //
                            flg_overd = flg_ovloops * ModeRVS + flg_ovloopd * ModeNML ; // geometrical drain //
                            Vgbgmt = flg_overs * Vgsgmt + flg_overd * Vgdgmt ;
                            Vxbgmt = flg_overs * Vsbgmt + flg_overd * Vdbgmt + `epsm10 ;

                            //---------------------------------------------------*
                            //* Clamp -Vxbgmt.
                            //*-----------------//
                            T0 = - Vxbgmt;
                            if ( T0 > Vbs_bnd ) begin
                                T1 =    T0   - Vbs_bnd;
                                T2 =    Vbs_max    - Vbs_bnd;
                                `Fn_SUPoly4( TY, T1, T2, T11 )
                                T10 = Vbs_bnd + TY ;
                            end  else begin
                                T10 = T0 ;
                                T11 = 1.0 ;
                            end
                            Vxbgmtcl = - T10 - `Small2 ;
                            fac1 = cnst0over * Cox0_inv ;
                            fac1p2 = fac1 * fac1 ;
                            VgpLD =  Vgbgmt - UC_VFBBT;

                            T0 =  UC_NSUBBTTUB / Nin;

                            Pb2over = 2.0 / beta * ln ( T0 ) ;
                            Vgb_fb_LD =  - Vxbgmtcl ;

                            //-----------------------------------*
                            //* QsuLD: total charge = Accumulation | Depletion+inversion
                            //*-----------------//
                            if (   VgpLD  < Vgb_fb_LD ) begin
                                //---------------------------*
                                //* Accumulation
                                //*-----------------//
                                flg_ovzone = -1 ;
                                T1 = 1.0 / ( beta * cnst0over ) ;
                                TY = T1 * Cox0 ;
                                Ac41 = 2.0 + 3.0 * `C_SQRT_2 * TY ;
                                Ac4 = 8.0 * Ac41 * Ac41 * Ac41 ;
                                Ps0_min = Eg - Pb2over ;
                                TX = beta * ( VgpLD + Vxbgmtcl ) ;
                                Ac31 = 7.0 * `C_SQRT_2 - 9.0 * TY * ( TX - 2.0 ) ;
                                Ac3 = Ac31 * Ac31 ;
                                if ( Ac4 < Ac3 * 1.0e-8 ) begin
                                    Ac1 = -7.0 * `C_SQRT_2 + Ac31 + 0.5 * Ac4 / Ac31 + 9.0 * TY * ( TX - 2.0 ) ;
                                end else begin
                                    Ac2 = sqrt( Ac4 + Ac3 ) ;
                                    Ac1 = -7.0 * `C_SQRT_2 + Ac2 + 9.0 * TY * ( TX - 2.0 ) ;
                                end
                                Acd = pow( Ac1 , `C_1o3 ) ;
                                Acn = -4.0 * `C_SQRT_2 - 12.0 * TY + 2.0 * Acd + `C_SQRT_2 * Acd * Acd ;
                                Chi = Acn / Acd ;
                                Psa = Chi * beta_inv - Vxbgmtcl ;
                                T1 = Psa + Vxbgmtcl ;
                                T2 = T1 / Ps0_min ;
                                T3 = sqrt( 1.0 + ( T2 * T2 ) ) ;
                                Ps0LD = T1 / T3 - Vxbgmtcl ;
                                T2 = ( VgpLD - Ps0LD ) ;
                                QsuLD = Cox0 * T2 ;
                                QbuLD = QsuLD ;
                            end else begin

                                //---------------------------*
                                //* Depletion and inversion
                                //*-----------------//

                                // initial value for a few fixpoint iterations
                                //to get Ps0_iniA from simplified Poisson equation: //
                                flg_ovzone = 2 ;
                                Chi = `znbd3 ;
                                Ps0_iniA= Chi/beta - Vxbgmtcl ;

                                // 1 .. 2 relaxation steps should be sufficient //
                                for ( lp_ld = 1; lp_ld <= 2; lp_ld = lp_ld + 1 ) begin
                                    TY = exp(-Chi);
                                    TX = 1.0e0 + 4.0e0 * ( beta * ( VgpLD + Vxbgmtcl ) - 1.0e0 + TY ) / ( fac1p2 * beta2 ) ;
                                    if ( TX < `epsm10) begin
                                        TX = `epsm10;
                                    end
                                    Ps0_iniA = VgpLD + fac1p2 * beta / 2.0e0 * ( 1.0e0 - sqrt( TX ) ) ;
                                    Chi = beta * ( Ps0_iniA + Vxbgmtcl ) ;
                                end // End of iteration //
                                if ( Chi < `znbd3 ) begin
                                    flg_ovzone = 1 ;

                                    //-----------------------------------*
                                    //* zone-D1
                                    //* - Ps0_iniA is the analytical solution of QovLD=Qb0 with
                                    //*   Qb0 being approximated by 3-degree polynomial.
                                    //*
                                    //*   new: Inclusion of exp(-Chi) term at right border
                                    //*-----------------//
                                    Ta =  1.0/(9.0*`C_SQRT_2) - (5.0+7.0*`c_expm3) / (54.0*sqrt(2.0+`c_expm3));
                                    Tb = (1.0+`c_expm3) / (2.0*sqrt(2.0+`c_expm3)) - `C_SQRT_2 / 3.0;
                                    Tc =  1.0/`C_SQRT_2 + 1.0/(beta*fac1);
                                    Td = - (VgpLD + Vxbgmtcl) / fac1;
                                    Tq = Tb*Tb*Tb / (27.0*Ta*Ta*Ta) - Tb*Tc/(6.0*Ta*Ta) + Td/(2.0*Ta);
                                    Tp = (3.0*Ta*Tc-Tb*Tb)/(9.0*Ta*Ta);
                                    T5      = sqrt(Tq*Tq + Tp*Tp*Tp);
                                    Tu = pow(-Tq + T5,`C_1o3);
                                    Tv = -pow(Tq + T5,`C_1o3);
                                    TX      = Tu + Tv - Tb/(3.0*Ta);
                                    Ps0_iniA = TX * beta_inv - Vxbgmtcl ;
                                    Chi = beta * ( Ps0_iniA + Vxbgmtcl ) ;
                                end

                                //-----------------------------------*
                                //          * - Ps0_iniB : upper bound.
                                //          *-----------------//
                                flg_ovzone = flg_ovzone + 2;
                                VgpLD_shift = VgpLD + Vxbgmtcl + 0.1;
                                exp_bVbs = exp( beta * - Vxbgmtcl ) + `Small ;
                                T0 = Nin / UC_NSUBBTTUB;
                                cnst1over = T0 * T0;
                                gammaChi = cnst1over * exp_bVbs ;
                                T0    = beta2 * fac1p2;
                                psi = beta*VgpLD_shift;
                                Chi_1      = ln (gammaChi*T0 + psi*psi) - ln (cnst1over*T0) + beta*Vxbgmtcl;
                                `Fn_SU2( Chi_1, Chi_1, psi, 1.0, T1, T2 )

                                // 1 fixpoint step for getting more accurate Chi_B //
                                psi = psi - Chi_1 ;
                                psi = psi + beta*0.1 ;
                                Chi_B = ln (gammaChi*T0 + psi*psi) - ln (cnst1over*T0) + beta*Vxbgmtcl;
                                //*
                                //* Limiting is done for Chi rather than for Ps0LD, to avoid shifting
                                //* for Fn_SU2 //
                                Chi_A = Chi;
                                `Fn_SU2( Chi, Chi_A, Chi_B, `c_ps0ini_2*75.00, T1, T2 ) // org: 50 //

                                // updating Ps0LD //
                                Ps0LD = Chi/beta - Vxbgmtcl ;
                                T1    = Chi - 1.0 + exp(-Chi);
                                if (T1 < `epsm10) begin
                                    T1 = `epsm10 ;
                                end
                                T2 = sqrt(T1);
                                QbuLD = cnst0over * T2 ;

                                //-----------------------------------------------------------*
                                //* QsuLD : Qovs or Qovd in unit area.
                                //* note: QsuLD = Qdep+Qinv.
                                //*-----------------//
                                QsuLD = Cox0 * ( VgpLD - Ps0LD ) ;

                                if ( COQBDSM == 1 ) begin // take initial values from analytical model

                                    //---------------------------------------------------*
                                    //* Calculation of Ps0LD. (beginning of Newton loop)
                                    //* - Fs0 : Fs0 = 0 is the equation to be solved.
                                    //* - dPs0 : correction value.
                                    //*-----------------//

                                    // initial value too close to flat band should not be used //
                                    exp_bVbs = exp( beta * - Vxbgmtcl ) ;
                                    T0 = Nin / UC_NSUBBTTUB;
                                    cnst1over = T0 * T0;
                                    cfs1 = cnst1over * exp_bVbs ;
                                    flg_conv = 0 ;
                                    for ( lp_s0 = 1 ; lp_s0 <= 2*`lp_s0_max + 1 ; lp_s0 = lp_s0 + 1 ) begin
                                        fb = 0.0 ;
                                        Chi = beta * ( Ps0LD + Vxbgmtcl ) ;
                                        if ( Chi < `znbd5 ) begin
                                            //-------------------------------------------*
                                            //* zone-D1/D2. (Ps0LD)
                                            //*-----------------//
                                            fi = Chi * Chi * Chi
                                            * ( `cn_im53 + Chi * ( `cn_im54 + Chi * `cn_im55 ) ) ;
                                            fi_dChi = Chi * Chi
                                                 * ( 3 * `cn_im53 + Chi * ( 4 * `cn_im54 + Chi * 5 * `cn_im55 ) ) ;
                                            fs01 = cfs1 * fi * fi ;
                                            fs01_dPs0 = cfs1 * beta * 2 * fi * fi_dChi ;

                                            fb = Chi * ( `cn_nc51
                                                    + Chi * ( `cn_nc52
                                                              + Chi * ( `cn_nc53
                                                                        + Chi * ( `cn_nc54 + Chi * `cn_nc55 ) ) ) ) ;
                                            fb_dChi = `cn_nc51
                                                 + Chi * ( 2 * `cn_nc52
                                                           + Chi * ( 3 * `cn_nc53
                                                                     + Chi * ( 4 * `cn_nc54 + Chi * 5 * `cn_nc55 ) ) ) ;
                                            fs02 = sqrt( fb * fb + fs01 + `Small ) ;
                                            fs02_dPs0 = ( beta * fb_dChi * 2 * fb + fs01_dPs0 ) / ( fs02 + fs02 ) ;
                                        end else begin
                                            //-------------------------------------------*
                                            //* zone-D3. (Ps0LD)
                                            //*-----------------//
                                            if ( Chi < `large_arg ) begin // avoid exp_Chi to become extremely large //
                                                exp_Chi = exp( Chi ) ;
                                                fs01 = cfs1 * ( exp_Chi - 1.0e0 ) ;
                                                fs01_dPs0 = cfs1 * beta * ( exp_Chi ) ;
                                            end else begin
                                                exp_bPs0 = exp( beta*Ps0LD ) ;
                                                fs01     = cnst1over * ( exp_bPs0 - exp_bVbs ) ;
                                                fs01_dPs0 = cnst1over * beta * exp_bPs0 ;
                                            end
                                            fs02 = sqrt( Chi - 1.0 + fs01 ) ;
                                            fs02_dPs0 = ( beta + fs01_dPs0 ) / fs02 * 0.5 ;

                                        end // end of if( Chi  ... ) block //
                                        //-----------------------------------------------------------*
                                        //* Fs0
                                        //*-----------------//
                                        Fs0 = VgpLD - Ps0LD - fac1 * fs02 ;
                                        Fs0_dPs0 = - 1.0e0 - fac1 * fs02_dPs0 ;
                                        if ( flg_conv == 1 ) begin
                                            lp_s0 = 2*`lp_s0_max+1 ; // break
                                        end else begin
                                            dPs0 = - Fs0 / Fs0_dPs0 ;

                                            //-------------------------------------------*
                                            //* Update Ps0LD .
                                            //*-----------------//
                                            dPlim = 0.5*`dP_max*(1.0 + `Fn_Max(1.0e0,abs(Ps0LD))) ;
                                            if ( abs( dPs0 ) > dPlim ) dPs0 = dPlim * `Fn_Sgn( dPs0 ) ;
                                            Ps0LD = Ps0LD + dPs0 ;

                                            //-------------------------------------------*
                                            //* Check convergence.
                                            //*-----------------//
                                            if ( abs( dPs0 ) <= `ps_conv && abs( Fs0 ) <= `gs_conv ) begin
                                                flg_conv = 1 ;
                                            end

                                        end
                                    end // end of Ps0LD Newton loop //

                                    //-------------------------------------------*
                                    //* Procedure for diverged case.
                                    //*-----------------//
                                    if ( flg_conv == 0 ) begin
                                        $write( "*** warning(HiSIM_SOI): Went Over Iteration Maximum(%M:Ps0LD)\n" ) ;
                                        $write(" -Vxbgmtcl = %e   Vgbgmt = %e\n" , -Vxbgmtcl , Vgbgmt ) ;
                                    end

                                    if ( Chi < `znbd5 ) begin
                                        //-------------------------------------------*
                                        //* zone-D1/D2. (Ps0LD)
                                        //*-----------------//
                                        if ( Chi < `znbd3 ) begin
                                            flg_ovzone = 1;
                                        end
                                        else begin
                                            flg_ovzone = 2;
                                        end
                                        Xi0 = fb * fb + `epsm10 ;
                                        Xi0p12 = fb + `epsm10 ;
                                    end else begin
                                        //-------------------------------------------*
                                        //* zone-D3. (Ps0LD)
                                        //*-----------------//
                                        flg_ovzone = 3 ;
                                        Xi0 = Chi - 1.0e0 ;
                                        Xi0p12 = sqrt( Xi0 ) ;
                                    end // end of if( Chi  ... ) block //

                                    //-----------------------------------------------------------*
                                    //* QbuLD and QiuLD
                                    //*-----------------//
                                    QbuLD = cnst0over * Xi0p12 ;
                                    T1 = 1.0 / ( fs02 + Xi0p12 ) ;
                                    QiuLD = cnst0over * fs01 * T1 ;

                                    //-----------------------------------------------------------*
                                    //* Total overlap charge
                                    //*-----------------//
                                    QsuLD = QbuLD + QiuLD;

                                end // end of COQBDSM branches //

                            end // end of Vgbgmt region blocks //

                            // inversion charge = total - depletion //
                            QiuLD = QsuLD - QbuLD  ;

                            //As this block turns back positive inversion charge (as in pMOSFET),
                            // take `-' sign for nMOSFET.
                            case (lbt)
                                1: begin // ( P+Poly)
                                    // Qbody_bt_n_plus
                                    if (flg_ovloops) begin
                                        Qbody_bt_p_sus = - UC_AREABT * QsuLD ;
                                        Qbody_bt_p_ius = - UC_AREABT * QiuLD ;
                                    end
                                    if (flg_ovloopd) begin
                                        Qbody_bt_p_sud = - UC_AREABT * QsuLD ;
                                        Qbody_bt_p_iud = - UC_AREABT * QiuLD ;
                                    end
                                end
                                2: begin // ( N+Poly)
                                    // Qbody_bt_n_plus
                                    if (flg_ovloops) begin
                                        Qbody_bt_n_sus = - UC_AREABT * QsuLD ;
                                        Qbody_bt_n_ius = - UC_AREABT * QiuLD ;
                                    end
                                    if (flg_ovloopd) begin
                                        Qbody_bt_n_sud = - UC_AREABT * QsuLD ;
                                        Qbody_bt_n_iud = - UC_AREABT * QiuLD ;
                                    end
                                end
                            endcase
                        end // end of lcover loop //
                    end // end of if( UC_WBT > 0.0 && UC_NSUBBTTUB == 0.0 ) //
                end // end of lbt loop //
            end /* COADOV=1 */
        end  // IntrinsicChargeForMOSFEToverBodyContact
        //---End of Intrinsic charge for parasitic MOSFET built over body-contact well---

    end

    //-------------------------------------------*
    //Calculation of Psdl for cases of flg_noqi==1.
    //----------------//
    begin : OverlapCharge_CalculationOfPsdl
        real T1,T2;

        Aclm = CLM1 ;
        if (flg_noqi != 0) begin
            T2 = Vds + Ps0 ;
            Psdl = Aclm * T2 + (1.0e0 - Aclm) * Psl ;
            if (XQY !=0) begin
                Ec = 0.0 ;
            end
            if (Psdl > Ps0 + Vds - `epsm10) begin
                Psdl = Ps0 + Vds - `epsm10 ;
            end
        end else begin
            // Ec is removed from Lred calc. part //
            if (XQY !=0) begin
                if ( Idd < `C_IDD_MIN ) begin
                    Ec = 0.0e0 ;
                end else begin
                    T1 =  beta_inv / Leff ;
                    T2 = 1.0 / Qn0 ;
                    Ec = Idd * T1 * T2 ;
                end
            end
        end
    end // Overlapcharge_CalculationOfPsdl

    // Surface-potential based Qover
    begin : OverlapCharge
        real    T0, T1, T2, T3, T4, T5,  T9, T10, T11;
        real    TX, TY;
        real    Cox0, Cox0_inv, Lov, cov_slp, cov_mag, covvg;
        real    flg_ovloops, flg_ovloopd; //changed from integer for VAMPyRE WARNING//
        integer flg_overs, flg_overd, lcover, flg_ovzone, flg_conv;
        integer lp_ld;
        real    Vxbgmt, Vxbgmtcl;
        real    Vbsgmt, Vdsgmt, Vgsgmt,  Vdbgmt, Vsbgmt, Vgbgmt;
        real    cnst0over;
        real    fac1, fac1p2, VgpLD, Pb2over, Vgb_fb_LD;
        real    Ac41, Ac4, Ps0_min, Ac31, Ac3, Ac2, Ac1, Acd, Acn, Chi, Psa, Ps0LD, Ps0_iniA;
        real    Ta, Tb, Tc, Td, Tq, Tp, Tu, Tv;
        real    VgpLD_shift, cnst1over, gammaChi, psi, Chi_1, Chi_B, Chi_A;
        real    exp_bVbs, fi, fi_dChi, fs01, fs01_dPs0, fb, fb_dChi, fs02, fs02_dPs0;
        real    cfs1, exp_bPs0, Fs0, Fs0_dPs0, dPlim;
        real    Xi0, Xi0p12;

        //-------------------------------------------*
        //* Overlap charges: Qgod, Qgos, and Qover
        //*-----------------//
        // Some constants to be used here.
        Cox0 = C_fox0;
        Cox0_inv = 1.0 / Cox0 ;
        Vgbgmt= 0.0;

        fb   = 0.0;
        fs01 = 0.0;
        fs02 = 0.0;

        if ( COADOV ) begin

            if ( COOVLP >= 1 && LOVER > 0.0 ) begin
                cov_slp = OVSLP;
                cov_mag = OVMAG ;
                covvg = Vgs ;
                Lov = LOVER ;
                if ( MKS_NOVER == 0.0 && LOVER > 0.0 ) begin
                    T1= ( COBCNODE == 1 ) ? W_dioscv * Cox0 : weffcv_nf * Cox0 ;
                    T4 = cov_slp * T1 * ( cov_mag + covvg ) ;
                    T5 = Lov * T1 ;
                    TX = Ps0 ;
                    T9 = 1.2e0 - TX ;
                    Qgos = Vgs * T5 - T9 * T4 ;
                    T4 = cov_slp * T1 * ( cov_mag + covvg - Vds ) ;
                    TX = Psl - Vds ;
                    T9 = 1.2e0 - TX ;
                    Qgod = (Vgs - Vds) * T5 - T4 * T9 ;
                end else begin
                    cnst0over = cnst0SOI * sqrt(MKS_NOVER / Nsub ) ;
                    for ( lcover = -1 ; lcover <= +1 ; lcover = lcover + 2 ) begin
                        flg_ovloops = ( 1 - lcover ) / 2.0 ; // 1 in Source overlap calc. // //for VAMPyRE WARNING//
                        flg_ovloopd = ( 1 + lcover ) / 2.0 ; // 1 in Drain overlap calc. // //for VAMPyRE WARNING//
                        //-------------------------------------------*
                        //* Qover(G/D overlap charge)  |  note: _dVxs means _dVxse
                        //*------------------------//
                        if ( COBCNODE == 1 ) begin
                            Vbsgmt = ModeNML * Vbs + ModeRVS * ( Vbs - Vds ) ;
                            Vdsgmt = ModeNML * Vds + ModeRVS * ( - Vds ) ;
                            Vgsgmt = ModeNML * Vgs + ModeRVS * ( Vgs - Vds ) ;
                            Vdbgmt = Vdsgmt - Vbsgmt ;
                            Vgbgmt = Vgsgmt - Vbsgmt ;
                            Vsbgmt = - Vbsgmt ;
                            flg_overs = flg_ovloops * ModeNML + flg_ovloopd * ModeRVS ; // geometrical source //
                            flg_overd = flg_ovloops * ModeRVS + flg_ovloopd * ModeNML ; // geometrical drain //
                            Vxbgmt = flg_overs * Vsbgmt + flg_overd * Vdbgmt + `epsm10 ;
                        end else begin
                            flg_overs = flg_ovloops * ModeNML + flg_ovloopd * ModeRVS ; // geometrical source //
                            flg_overd = flg_ovloops * ModeRVS + flg_ovloopd * ModeNML ; // geometrical drain //
                            if (flg_ovloops) Vgbgmt = ModeNML * Vgs + ModeRVS * ( Vgs - Vds ) ;
                            if (flg_ovloopd) Vgbgmt = ModeRVS * Vgs + ModeNML * ( Vgs - Vds ) ;
                            Vxbgmt = 0.0 ;
                        end

                        //---------------------------------------------------*
                        //* Clamp -Vxbgmt.
                        //*-----------------//
                        T0 = - Vxbgmt;
                        if ( T0 > Vbs_bnd ) begin
                            T1 =    T0   - Vbs_bnd;
                            T2 =    Vbs_max    - Vbs_bnd;
                            `Fn_SUPoly4( TY, T1, T2, T11 )
                            T10 = Vbs_bnd + TY ;
                        end  else begin
                            T10 = T0 ;
                            T11 = 1.0 ;
                        end
                        Vxbgmtcl = - T10 - `Small2 ;
                        fac1 = cnst0over * Cox0_inv ;
                        fac1p2 = fac1 * fac1 ;
                        VgpLD = - Vgbgmt + UC_VFBOVER;
                        T0 = MKS_NOVER / Nin ;
                        Pb2over = 2.0 / beta * ln ( T0 ) ;
                        Vgb_fb_LD =  - Vxbgmtcl ;

                        //-----------------------------------*
                        //* QsuLD: total charge = Accumulation | Depletion+inversion
                        //*-----------------//
                        if (   VgpLD  < Vgb_fb_LD ) begin
                            //---------------------------*
                            //* Accumulation
                            //*-----------------//
                            flg_ovzone = -1 ;
                            T1 = 1.0 / ( beta * cnst0over ) ;
                            TY = T1 * Cox0 ;
                            Ac41 = 2.0 + 3.0 * `C_SQRT_2 * TY ;
                            Ac4 = 8.0 * Ac41 * Ac41 * Ac41 ;
                            Ps0_min = Eg - Pb2over ;
                            TX = beta * ( VgpLD + Vxbgmtcl ) ;
                            Ac31 = 7.0 * `C_SQRT_2 - 9.0 * TY * ( TX - 2.0 ) ;
                            Ac3 = Ac31 * Ac31 ;
                            if ( Ac4 < Ac3 * 1.0e-8 ) begin
                                Ac1 = -7.0 * `C_SQRT_2 + Ac31 + 0.5 * Ac4 / Ac31 + 9.0 * TY * ( TX - 2.0 ) ;
                            end else begin
                                Ac2 = sqrt( Ac4 + Ac3 ) ;
                                Ac1 = -7.0 * `C_SQRT_2 + Ac2 + 9.0 * TY * ( TX - 2.0 ) ;
                            end
                            Acd = pow( Ac1 , `C_1o3 ) ;
                            Acn = -4.0 * `C_SQRT_2 - 12.0 * TY + 2.0 * Acd + `C_SQRT_2 * Acd * Acd ;
                            Chi = Acn / Acd ;
                            Psa = Chi * beta_inv - Vxbgmtcl ;
                            T1 = Psa + Vxbgmtcl ;
                            T2 = T1 / Ps0_min ;
                            T3 = sqrt( 1.0 + ( T2 * T2 ) ) ;
                            Ps0LD = T1 / T3 - Vxbgmtcl ;
                            T2 = ( VgpLD - Ps0LD ) ;
                            QsuLD = Cox0 * T2 ;
                            QbuLD = QsuLD ;
                        end else begin

                            //---------------------------*
                            //* Depletion and inversion
                            //*-----------------//

                            // initial value for a few fixpoint iterations
                            //to get Ps0_iniA from simplified Poisson equation: //
                            flg_ovzone = 2 ;
                            Chi = `znbd3 ;
                            Ps0_iniA= Chi/beta - Vxbgmtcl ;

                            // 1 .. 2 relaxation steps should be sufficient //
                            for ( lp_ld = 1; lp_ld <= 2; lp_ld = lp_ld + 1 ) begin
                                TY = exp(-Chi);
                                TX = 1.0e0 + 4.0e0 * ( beta * ( VgpLD + Vxbgmtcl ) - 1.0e0 + TY ) / ( fac1p2 * beta2 ) ;
                                if ( TX < `epsm10) begin
                                    TX = `epsm10;
                                end
                                Ps0_iniA = VgpLD + fac1p2 * beta / 2.0e0 * ( 1.0e0 - sqrt( TX ) ) ;
                                Chi = beta * ( Ps0_iniA + Vxbgmtcl ) ;
                            end // End of iteration //
                            if ( Chi < `znbd3 ) begin
                                flg_ovzone = 1 ;

                                //-----------------------------------*
                                //* zone-D1
                                //* - Ps0_iniA is the analytical solution of QovLD=Qb0 with
                                //*   Qb0 being approximated by 3-degree polynomial.
                                //*
                                //*   new: Inclusion of exp(-Chi) term at right border
                                //*-----------------//
                                Ta =  1.0/(9.0*`C_SQRT_2) - (5.0+7.0*`c_expm3) / (54.0*sqrt(2.0+`c_expm3));
                                Tb = (1.0+`c_expm3) / (2.0*sqrt(2.0+`c_expm3)) - `C_SQRT_2 / 3.0;
                                Tc =  1.0/`C_SQRT_2 + 1.0/(beta*fac1);
                                Td = - (VgpLD + Vxbgmtcl) / fac1;
                                Tq = Tb*Tb*Tb / (27.0*Ta*Ta*Ta) - Tb*Tc/(6.0*Ta*Ta) + Td/(2.0*Ta);
                                Tp = (3.0*Ta*Tc-Tb*Tb)/(9.0*Ta*Ta);
                                T5      = sqrt(Tq*Tq + Tp*Tp*Tp);
                                Tu = pow(-Tq + T5,`C_1o3);
                                Tv = -pow(Tq + T5,`C_1o3);
                                TX      = Tu + Tv - Tb/(3.0*Ta);
                                Ps0_iniA = TX * beta_inv - Vxbgmtcl ;
                                Chi = beta * ( Ps0_iniA + Vxbgmtcl ) ;
                            end
                            if ( COQOVSM > 0 ) begin
                                //-----------------------------------*
                                //          * - Ps0_iniB : upper bound.
                                //          *-----------------//
                                flg_ovzone = flg_ovzone + 2;
                                VgpLD_shift = VgpLD + Vxbgmtcl + 0.1;
                                exp_bVbs = exp( beta * - Vxbgmtcl ) + `Small ;
                                T0 = Nin / MKS_NOVER;
                                cnst1over = T0 * T0;
                                gammaChi = cnst1over * exp_bVbs ;
                                T0    = beta2 * fac1p2;
                                psi = beta*VgpLD_shift;
                                Chi_1      = ln (gammaChi*T0 + psi*psi) - ln (cnst1over*T0) + beta*Vxbgmtcl;
                                `Fn_SU2( Chi_1, Chi_1, psi, 1.0, T1, T2 )

                                // 1 fixpoint step for getting more accurate Chi_B //
                                psi = psi - Chi_1 ;
                                psi = psi + beta*0.1 ;
                                Chi_B = ln (gammaChi*T0 + psi*psi) - ln (cnst1over*T0) + beta*Vxbgmtcl;
                                //*
                                //* Limiting is done for Chi rather than for Ps0LD, to avoid shifting
                                //* for Fn_SU2 //
                                Chi_A = Chi;
                                `Fn_SU2( Chi, Chi_A, Chi_B, `c_ps0ini_2*75.00, T1, T2 ) // org: 50 //

                            end

                            // updating Ps0LD //
                            Ps0LD = Chi/beta - Vxbgmtcl ;
                            T1    = Chi - 1.0 + exp(-Chi);
                            if (T1 < `epsm10) begin
                                T1 = `epsm10 ;
                            end
                            T2 = sqrt(T1);
                            QbuLD = cnst0over * T2 ;

                            //-----------------------------------------------------------*
                            //* QsuLD : Qovs or Qovd in unit area.
                            //* note: QsuLD = Qdep+Qinv.
                            //*-----------------//
                            QsuLD = Cox0 * ( VgpLD - Ps0LD ) ;

                            if ( COQOVSM == 1 ) begin // take initial values from analytical model //

                                //---------------------------------------------------*
                                //* Calculation of Ps0LD. (beginning of Newton loop)
                                //* - Fs0 : Fs0 = 0 is the equation to be solved.
                                //* - dPs0 : correction value.
                                //*-----------------//

                                // initial value too close to flat band should not be used //
                                exp_bVbs = exp( beta * - Vxbgmtcl ) ;
                                T0 = Nin / MKS_NOVER;
                                cnst1over = T0 * T0;
                                cfs1 = cnst1over * exp_bVbs ;
                                flg_conv = 0 ; fs01 = 0.0 ; fs02 = 0.0 ;
                                for ( lp_s0 = 1 ; lp_s0 <= 2*`lp_s0_max + 1 ; lp_s0 = lp_s0 + 1 ) begin
                                    fb = 0.0 ;
                                    Chi = beta * ( Ps0LD + Vxbgmtcl ) ;
                                    if ( Chi < `znbd5 ) begin
                                        //-------------------------------------------*
                                        //* zone-D1/D2. (Ps0LD)
                                        //*-----------------//
                                        fi = Chi * Chi * Chi
                                         * ( `cn_im53 + Chi * ( `cn_im54 + Chi * `cn_im55 ) ) ;
                                        fi_dChi = Chi * Chi
                                              * ( 3 * `cn_im53 + Chi * ( 4 * `cn_im54 + Chi * 5 * `cn_im55 ) ) ;
                                        fs01 = cfs1 * fi * fi ;
                                        fs01_dPs0 = cfs1 * beta * 2 * fi * fi_dChi ;

                                        fb = Chi * ( `cn_nc51
                                                 + Chi * ( `cn_nc52
                                                           + Chi * ( `cn_nc53
                                                                     + Chi * ( `cn_nc54 + Chi * `cn_nc55 ) ) ) ) ;
                                        fb_dChi = `cn_nc51
                                              + Chi * ( 2 * `cn_nc52
                                                        + Chi * ( 3 * `cn_nc53
                                                                  + Chi * ( 4 * `cn_nc54 + Chi * 5 * `cn_nc55 ) ) ) ;
                                        fs02 = sqrt( fb * fb + fs01 + `Small ) ;
                                        fs02_dPs0 = ( beta * fb_dChi * 2 * fb + fs01_dPs0 ) / ( fs02 + fs02 ) ;
                                    end else begin
                                        //-------------------------------------------*
                                        //* zone-D3. (Ps0LD)
                                        //*-----------------//
                                        if ( Chi < `large_arg ) begin // avoid exp_Chi to become extremely large //
                                            exp_Chi = exp( Chi ) ;
                                            fs01 = cfs1 * ( exp_Chi - 1.0e0 ) ;
                                            fs01_dPs0 = cfs1 * beta * ( exp_Chi ) ;
                                        end else begin
                                            exp_bPs0 = exp( beta*Ps0LD ) ;
                                            fs01     = cnst1over * ( exp_bPs0 - exp_bVbs ) ;
                                            fs01_dPs0 = cnst1over * beta * exp_bPs0 ;
                                        end
                                        fs02 = sqrt( Chi - 1.0 + fs01 ) ;
                                        fs02_dPs0 = ( beta + fs01_dPs0 ) / fs02 * 0.5 ;

                                    end // end of if( Chi  ... ) block //
                                    //-----------------------------------------------------------*
                                    //* Fs0
                                    //*-----------------//
                                    Fs0 = VgpLD - Ps0LD - fac1 * fs02 ;
                                    Fs0_dPs0 = - 1.0e0 - fac1 * fs02_dPs0 ;
                                    if ( flg_conv == 1 ) begin
                                        lp_s0 = 2*`lp_s0_max+1 ;  // break
                                    end else begin
                                        dPs0 = - Fs0 / Fs0_dPs0 ;

                                        //-------------------------------------------*
                                        //* Update Ps0LD .
                                        //*-----------------//
                                        dPlim = 0.5*`dP_max*(1.0 + `Fn_Max(1.0e0,abs(Ps0LD))) ;
                                        if ( abs( dPs0 ) > dPlim ) dPs0 = dPlim * `Fn_Sgn( dPs0 ) ;
                                        Ps0LD = Ps0LD + dPs0 ;

                                        //-------------------------------------------*
                                        //* Check convergence.
                                        //*-----------------//
                                        if ( abs( dPs0 ) <= `ps_conv && abs( Fs0 ) <= `gs_conv ) begin
                                            flg_conv = 1 ;
                                        end

                                    end
                                end // end of Ps0LD Newton loop //

                                //-------------------------------------------*
                                //* Procedure for diverged case.
                                //*-----------------//
                                if ( flg_conv == 0 ) begin
                                    $write( "*** warning(HiSIM_SOI): Went Over Iteration Maximum(%M:Ps0LD)\n" ) ;
                                    $write(" -Vxbgmtcl = %e   Vgbgmt = %e\n" , -Vxbgmtcl , Vgbgmt ) ;
                                end

                                if ( Chi < `znbd5 ) begin
                                    //-------------------------------------------*
                                    //* zone-D1/D2. (Ps0LD)
                                    //*-----------------//
                                    if ( Chi < `znbd3 ) begin
                                        flg_ovzone = 1;
                                    end
                                    else begin
                                        flg_ovzone = 2;
                                    end
                                    Xi0 = fb * fb + `epsm10 ;
                                    Xi0p12 = fb + `epsm10 ;
                                end else begin
                                    //-------------------------------------------*
                                    //* zone-D3. (Ps0LD)
                                    //*-----------------//
                                    flg_ovzone = 3 ;
                                    Xi0 = Chi - 1.0e0 ;
                                    Xi0p12 = sqrt( Xi0 ) ;
                                end // end of if( Chi  ... ) block //

                                //-----------------------------------------------------------*
                                //* QbuLD and QiuLD
                                //*-----------------//
                                QbuLD = cnst0over * Xi0p12 ;
                                T1 = 1.0 / ( fs02 + Xi0p12 ) ;
                                QiuLD = cnst0over * fs01 * T1 ;

                                //-----------------------------------------------------------*
                                //* Total overlap charge
                                //*-----------------//
                                QsuLD = QbuLD + QiuLD;

                            end // end of COQOVSM branches //

                        end // end of Vgbgmt region blocks //

                        // inversion charge = total - depletion //
                        QiuLD = QsuLD - QbuLD  ;

                        // assign final outputs of Qover model //
                        // note: Qovs and Qovd are exchanged in reverse mode //
                        T4 = ( COBCNODE == 1 ) ? W_dioscv * Lov : weffcv_nf * Lov ;
                        if ( (flg_overs && COBCNODE == 0) || (flg_ovloops && COBCNODE == 1)) begin
                            Qovs =  T4 * QsuLD ;
                            QbsLD = T4 * QbuLD ;
                        end
                        if ( (flg_overd && COBCNODE == 0) || (flg_ovloopd && COBCNODE == 1)) begin
                            Qovd =  T4 * QsuLD ;
                            QbdLD = T4 * QbuLD ;
                        end

                    end // end of lcover loop }//

                end // end of if( MKS_NOVER == 0.0 )} //

                //-----------------------------------*
                //* Additional constant capacitance model
                //*-----------------//
                flg_overgiven = ( ModeRVS * CGSO_GIVEN
                                    + ModeNML * CGDO_GIVEN  ) ;
                if ( flg_overgiven ) begin
                    Cgdoe  = ModeRVS * CGSO + ModeNML * CGDO ;
                    if ( COBCNODE == 1 ) begin
                        T1    = ModeRVS * W_dioscv + ModeNML * W_diodcv ;
                        Cgdoe = Cgdoe *  - T1 ;
                    end else begin
                        Cgdoe = Cgdoe * ( - weffcv_nf ) ;
                    end

                    Qgod = Qgod + - Cgdoe * (Vgs - Vds) ;
                end

                flg_overgiven = ( ModeNML * CGSO_GIVEN
                                    + ModeRVS * CGDO_GIVEN ) ;
                if (flg_overgiven) begin
                    Cgsoe  = ModeNML * CGSO + ModeRVS * CGDO ;
                    if ( COBCNODE == 1 ) begin
                        T1    = ModeNML * W_dioscv + ModeRVS * W_diodcv ;
                        Cgsoe = Cgsoe *  - T1 ;
                    end else begin
                        Cgsoe = Cgsoe * ( - weffcv_nf ) ;
                    end
                    Qgos = Qgos + - Cgsoe * Vgs ;
                end

            end else begin // else case of if( coovlp >= 1 ) //
                if ((mode == `HiSIM_NORMAL_MODE && !CGDO_GIVEN) ||
                     (mode != `HiSIM_NORMAL_MODE && !CGSO_GIVEN) ) begin
                    if ( COBCNODE == 1 ) begin
                        Cgdoe = - Cox0 * LOVER * W_diodcv ;
                    end else begin
                        Cgdoe = - Cox0 * LOVER * weffcv_nf ;
                    end

                end else begin
                    Cgdoe  = ModeRVS * CGSO + ModeNML * CGDO ;
                    if ( COBCNODE == 1 ) begin
                        T1    = ModeRVS * W_dioscv + ModeNML * W_diodcv ;
                        Cgdoe = Cgdoe * - T1 ;
                    end else begin
                        Cgdoe = Cgdoe * ( - weffcv_nf ) ;
                    end
                end
                Qgod = - Cgdoe * (Vgs - Vds) ;

                if ((mode == `HiSIM_NORMAL_MODE && !CGSO_GIVEN) ||
                     (mode != `HiSIM_NORMAL_MODE && !CGDO_GIVEN) ) begin
                    if ( COBCNODE == 1 ) begin
                        Cgsoe = - Cox0 * LOVER * W_dioscv ;
                    end else begin
                        Cgsoe = - Cox0 * LOVER * weffcv_nf ;
                    end
                end else begin
                    Cgsoe  = ModeNML * CGSO + ModeRVS * CGDO ;
                    if ( COBCNODE == 1 ) begin
                        T1     = ModeNML * W_dioscv + ModeRVS * W_diodcv ;
                        Cgsoe = Cgsoe * - T1 ;
                    end else begin
                        Cgsoe = Cgsoe * ( - weffcv_nf ) ;
                    end
                end
                Qgos = - Cgsoe * Vgs ;
            end // end of if( coovlp >= 1 ) //

        end // (COADOV == 1)
    end // OverlapCharge
    //End of include

    //-----------------------------------------------------------*
    //End of PART-3. (label)
    //----------------//
    // end_of_part_3: ; //

    //++++++++++++++++++++++++++++++++++++++++++++++++++++++++++++
    //PART-4: Substrate-source/drain junction diode.
    //+++++++++++++++++++++++++++++++++++++++++++++++++++++++++++//
    if ( COBCNODE == 1 ) begin
        begin : JunctionDiodeModel
            real T0, T1, T2, T3;
            real Qbs_max, Qbd_max, dlt_Qbs, dlt_Qbd;
            real Xp_max;
            real czbd, czbs, czbdsw, czbssw, czbdswg, czbsswg;
            real Vbdj, Vbsj;
            real js, js2;
            real Nvtm;
            real vbdt, vbst;
            real isbd, isbs, isbd2, isbs2;
            real arg, sarg;

            //-----------------------------------------------------------*
            //Cbsj, Cbdj: node-base S/D biases. (CMI seems require them.)
            //----------------//

            begin             // pn junction diode current {
                Vbdj = vbcd ;
                Vbsj = vbcs ;

                // Diode Current : Ibd,Ibs //
                js =  JS0 * exp((egtnom * betatnom - Eg * beta + XTI * ln(TTEMP / UC_TNOM)) / NJ) ;
                js2 = JS0 * exp((egtnom * betatnom - Eg * beta + XTI2 * ln(TTEMP / UC_TNOM)) / NJ) ;
                isbd  = W_diod * `t_SOI * js ;
                isbd2 = W_diod * `t_SOI * js2 ;
                isbs  = W_dios * `t_SOI * js ;
                isbs2 = W_dios * `t_SOI * js2 ;

                T1 = TTEMP / UC_TNOM ;
                T0 = T1 * T1 ;
                T2 = isbd + `Small ;
                T3 = isbs + `Small ;
                vbdt = NJ / beta * log1p( VDIFFJ * T0 / T2 ) ;
                vbst = NJ / beta * log1p( VDIFFJ * T0 / T3 ) ;

                Nvtm = NJ * beta_inv ;

                // ibd //
                if (Vbdj < vbdt) begin
                    T1 = exp(Vbdj / Nvtm) ;
                    Ibd = isbd * (T1 - 1.0) ;
                end else begin
                    T1 = exp(vbdt / Nvtm) ;
                    Ibd = isbd * (T1 - 1.0) + isbd / Nvtm * T1 * (Vbdj - vbdt) ;
                end
                Ibd = Ibd + DIVX * Vbdj * isbd2 ;

                // ibs //
                if (Vbsj < vbst) begin
                    T1 = exp(Vbsj / Nvtm) ;
                    Ibs = isbs * (T1 - 1.0) ;
                end else begin
                    T1 = exp(vbst / Nvtm) ;
                    Ibs = isbs * (T1 - 1.0)
                       + isbs / Nvtm * T1 * (Vbsj - vbst) ;
                end
                Ibs = Ibs + DIVX * Vbsj * isbs2 ;
                Ibd = Ibd + Gjmin * Vbdj ;
                Ibs = Ibs + Gjmin * Vbsj ;
            end                      // end pn junction diode current}

            //-----------------------------------------------------------*
            //Charges and Capacitances.
            //----------------//
            //  charge storage elements
            //*  bulk-drain and bulk-source depletion capacitances
            //*  czbd : zero bias drain junction capacitance
            //*  czbs : zero bias source junction capacitance
            //*  czbdsw:zero bias drain junction sidewall capacitance
            //*  czbssw:zero bias source junction sidewall capacitance
            ////
            czbd = CJ * AD ;
            czbs = CJ * AS ;
            Xp_max = `t_SOI - XJ ;

            if (Xp_max <= 0) begin    // "=" is added to avoid FPE issues in the
                //                         junction capacitance model. //
                czbd = 0.0 ;
                czbs = 0.0 ;
            end

            // Source Bulk Junction //
            if (PS > W_dioscv) begin
                czbssw  = CJSW * (PS - W_dioscv) ;
                czbsswg = CJSWG * W_dioscv ;
                if (Vbsj < 0.0) begin
                    if (czbs > 0.0) begin
                        arg = 1.0 - Vbsj / PB ;
                        if (MJ == 0.5) begin
                            sarg = 1.0 / sqrt(arg) ;
                        end else begin
                            sarg = `Fn_Pow(arg, -MJ) ;
                        end
                        Qbs = PB * czbs * (1.0 - arg * sarg) / (1.0 - MJ) ;
                    end else begin
                        Qbs = 0.0 ;
                    end
                    if (czbssw > 0.0) begin
                        arg = 1.0 - Vbsj / PBSW ;
                        if (MJSW == 0.5) sarg = 1.0 / sqrt(arg) ;
                        else sarg = `Fn_Pow(arg, -MJSW) ;
                        Qbs = Qbs + PBSW * czbssw * (1.0 - arg * sarg) / (1.0 - MJSW) ;
                    end
                    if (czbsswg > 0.0) begin
                        arg = 1.0 - Vbsj / PBSWG ;
                        if (MJSWG == 0.5) sarg = 1.0 / sqrt(arg) ;
                        else sarg = `Fn_Pow(arg, -MJSWG) ;
                        Qbs = Qbs + PBSWG * czbsswg * (1.0 - arg * sarg) / (1.0 - MJSWG) ;
                    end
                end else begin
                    T1 = czbs + czbssw + czbsswg ;
                    T2 = czbs * MJ / PB
                          + czbssw * MJSW / PBSW +
                          czbsswg * MJSWG / PBSWG ;
                    Qbs = Vbsj * (T1 + Vbsj * 0.5 * T2) ;
                end
            end else begin
                czbsswg = CJSWG * PS ;
                if (Vbsj < 0.0) begin
                    if (czbs > 0.0) begin
                        arg = 1.0 - Vbsj / PB ;
                        if (MJ == 0.5) sarg = 1.0 / sqrt(arg) ;
                        else sarg = `Fn_Pow(arg, -MJ) ;
                        Qbs = PB * czbs * (1.0 - arg * sarg) / (1.0 - MJ) ;
                    end else begin
                        Qbs = 0.0 ;
                    end
                    if (czbsswg > 0.0) begin
                        arg = 1.0 - Vbsj / PBSWG ;
                        if (MJSWG == 0.5) sarg = 1.0 / sqrt(arg) ;
                        else sarg = `Fn_Pow(arg, -MJSWG) ;
                        Qbs = Qbs + PBSWG * czbsswg * (1.0 - arg * sarg) / (1.0 - MJSWG) ;
                    end
                end else begin
                    T1 = czbs + czbsswg ;
                    T2 = czbs * MJ / PB + czbsswg * MJSWG / PBSWG ;
                    Qbs = Vbsj * (T1 + Vbsj * 0.5 * T2) ;
                end
            end

            // Drain Bulk Junction //
            if (PD > W_diodcv) begin
                czbdsw  = CJSW * (PD - W_diodcv) ;
                czbdswg = CJSWG * W_diodcv ;
                if (Vbdj < 0.0) begin
                    if (czbd > 0.0) begin
                        arg = 1.0 - Vbdj / PB ;
                        if (MJ == 0.5) begin
                            sarg = 1.0 / sqrt(arg) ;
                        end else begin
                            sarg = `Fn_Pow(arg, -MJ) ;
                        end
                        Qbd = PB * czbd * (1.0 - arg * sarg) / (1.0 - MJ) ;
                    end else begin
                        Qbd = 0.0 ;
                    end
                    if (czbdsw > 0.0) begin
                        arg = 1.0 - Vbdj / PBSW ;
                        if (MJSW == 0.5) sarg = 1.0 / sqrt(arg) ;
                        else sarg = `Fn_Pow(arg, -MJSW) ;
                        Qbd = Qbd + PBSW * czbdsw * (1.0 - arg * sarg) / (1.0 - MJSW) ;
                    end
                    if (czbdswg > 0.0) begin
                        arg = 1.0 - Vbdj / PBSWG ;
                        if (MJSWG == 0.5) sarg = 1.0 / sqrt(arg) ;
                        else sarg = `Fn_Pow(arg, -MJSWG) ;
                        Qbd = Qbd + PBSWG * czbdswg * (1.0 - arg * sarg) / (1.0 - MJSWG) ;
                    end
                end else begin
                    T1 = czbd + czbdsw + czbdswg ;
                    T2 = czbd * MJ / PB
                          + czbdsw * MJSW / PBSW +
                          czbdswg * MJSWG / PBSWG ;
                    Qbd = Vbdj * (T1 + Vbdj * 0.5 * T2) ;
                end
            end else begin
                czbdswg = CJSWG * PD ;
                if (Vbdj < 0.0) begin
                    if (czbd > 0.0) begin
                        arg = 1.0 - Vbdj / PB ;
                        if (MJ == 0.5) sarg = 1.0 / sqrt(arg) ;
                        else sarg = `Fn_Pow(arg, -MJ) ;
                        Qbd = PB * czbd * (1.0 - arg * sarg) / (1.0 - MJ) ;
                    end else begin
                        Qbd = 0.0 ;
                    end
                    if (czbdswg > 0.0) begin
                        arg = 1.0 - Vbdj / PBSWG ;
                        if (MJSWG == 0.5) sarg = 1.0 / sqrt(arg) ;
                        else sarg = `Fn_Pow(arg, -MJSWG) ;
                        Qbd = Qbd + PBSWG * czbdswg * (1.0 - arg * sarg) / (1.0 - MJSWG) ;
                    end
                end else begin
                    T1 = czbd + czbdswg ;
                    T2 = czbd * MJ / PB + czbdswg * MJSWG / PBSWG ;
                    Qbd = Vbdj * (T1 + Vbdj * 0.5 * T2) ;
                end
            end

            // Limiting the bottom-junction depletion charges in the SOI layer //
            if (czbs > 0.0) begin
                Qbs_max = -`C_QE * `N_sub_SOI * Xp_max * AS ;
                dlt_Qbs = 1e-3 * (-Qbs_max) ;
                `Fn_SUtemp(Qbs, -Qbs, -Qbs_max, dlt_Qbs)
                Qbs = Qbs * -1 ;
            end
            if (czbd > 0.0) begin
                Qbd_max = -`C_QE * `N_sub_SOI * Xp_max * AD ;
                dlt_Qbd = 1e-3 * (-Qbd_max) ;
                `Fn_SUtemp(Qbd, -Qbd, -Qbd_max, dlt_Qbd)
                Qbd = Qbd * -1 ;
            end

        end // JunctionDiodeModel }
    end // end COBCNODE == 1

    //-----------------------------------------------------------*
    //End of PART-4. (label)
    //----------------//
    // end_of_part_4: ; //

    //++++++++++++++++++++++++++++++++++++++++++++++++++++++++++++
    //PART-5: NQS Model.
    //---------------- from HiSIM 2.5.1 //
    begin : NQSmodel
        real T10, T11, T12, T1, T2;

        if (flg_nqs) begin
            if (flg_noqi == 0) begin
                T10 = DLY1 ;
                T11 = DLY2 ;
                T12 = Lch ;
                T1 = T10 * T11 * T12 * T12 ;
                T2 = Mu * VgVt * T10 + T11 * T12 * T12 + `Small ;
                tau = T1 / T2 ;
            end else begin
                tau = DLY1 + `Small ;
            end
            T1 = DLY3 ;
            taub = T1 * C_fox ;
        end
    end // NQSmodel

    //-----------------------------------------------------------*
    //End of PART-5. (label)
    //-----------------//
    //   end_of_part_5: //

    //++++++++++++++++++++++++++++++++++++++++++++++++++++++++++++
    //PART-6: Noise Calculation. from HiSIM 2.5.1 2010.05.21
    //++++++++++++++++++++++++++++++++++++++++++++++++++++++++++++//

    //-----------------------------------------------------------*
    //* 1/f noise.
    //*-----------------//
    begin : OneOverFnoiseModel
        real T1, T2, T3, T4, NFalpe, NFtrpe, Cite;

        if (COFLICK != 0 && !flg_noqi) begin
            NFalpe = MKS_NFALP ;
            NFtrpe = MKS_NFTRP ;
            Cite = MKS_CIT ;
            T1 = Qn0 / `C_QE ;
            T2 = (C_fox + Qn0 / (Ps0 - Vbsz2) + Cite) * beta_inv / `C_QE ;
            T3 = -2.0E0 * Qi / `C_QE / Lch_cv / weffcv_nf - T1 ;
            if ( abs(T3 - T1) > `epsm10 ) begin
                T4 = 1.0E0 / (T1 + T2) / (T3 + T2) + 2.0E0 * NFalpe * Ey * Mu / (T3 - T1)
                    * ln((T3 + T2) /(T1 + T2)) + NFalpe * Ey * Mu * NFalpe * Ey * Mu ;
            end else begin
                //series expansion for ln(1+(T3-T1)/(T1+T2)) about the point T3=T1:
                T4 = 1.0 / (T1 + T2) / (T3 + T2) + 2.0 * NFalpe * Ey * Mu / (T1 + T2)
                    + NFalpe * Ey * Mu * NFalpe * Ey * Mu ;
            end
            Nflic = Ids * Ids * NFtrpe / (Lch * beta * weff_nf) * T4 ;
        end else begin
            Nflic = 0.0 ;
        end
    end // OneOverFnoiseModel

    //-----------------------------------------------------------*
    //* thermal noise.
    //*-----------------//
    begin : ThermalNoiseModel
        real Eyd, T12, T7, T8, T9, T10, T11, T0,  Mu_Ave;
        real T2, T3, T4, T5, T10w, T7w;
        real gds0_h2, GAMMA;

        if (COTHRML != 0 && !flg_noqi) begin
            Eyd = (Psdl - Ps0) / Lch ;
            T12 = Muun * Eyd / 1.0e5 ;
            // note: bb = 2 (electron) ;1 (hole) //
            if (1.0e0 - `epsm10 <= BB && BB <= 1.0e0 + `epsm10) begin
                T7 = 1.0e0 ;
            end else if (2.0e0 - `epsm10 <= BB && BB <= 2.0e0 + `epsm10) begin
                T7 = T12 ;
            end else begin
                T7 = `Fn_Pow(T12, BB - 1.0e0) ;
            end
            T8 = T12 * T7 ;
            T9 = 1.0e0 + T8 ;
            T10 = `Fn_Pow(T9, (-1.0e0 / BB - 1.0e0)) ;
            T11 = T9 * T10 ;
            Mud_hoso = Muun * T11 ;
            Mu_Ave = (Mu + Mud_hoso) / 2.0 ;
            T0 = Alpha * Alpha ;
            Nthrml = weff_nf * C_fox * VgVt * Mu
                        * ((1e0 + 3e0 * Alpha + 6e0 * T0) * Mud_hoso * Mud_hoso
                           + (3e0 + 4e0 * Alpha + 3e0 * T0) * Mud_hoso * Mu + (6e0 + 3e0 * Alpha + T0) * Mu * Mu)
                          / (15e0 * Lch * (1e0 + Alpha) * Mu_Ave * Mu_Ave) ;
        end else begin
            Nthrml = 0e0 ;
        end

        //----------------------------------------------------------*
        //* induced gate noise. ( Part 2/3 )
        //*----------------------//
        if (COIGN != 0 && COTHRML != 0 && flg_ign == 1 && !flg_noqi) begin
            sqrtkusaiL = sqrt(kusaiL) ;
            T2 = VgVt + sqrtkusaiL ;
            T3 = kusai00 * kusai00 ;
            T4 = kusaiL * kusaiL ;
            T5 = 42.0e0 * kusai00 * kusaiL ;
            T5 = T5 + 4.0e0 * (T3 + T4) ;
            T5 = T5 + 20.0e0 * sqrtkusaiL * VgVt * (kusai00 + kusaiL) ;
            T10w = T2 * T2 ;
            T10 = T10w * T10w ;
            kusai_ig = T5 / (T10 * T2) ;     // Induced Gate Noise parameter //
            gds0_ign = weff_nf / Lch * Mu * C_fox ;
            gds0_h2 = gds0_ign * VgVt ;
            GAMMA = Nthrml / gds0_h2 ;
            T7w = kusai00 + 4.0e0 * VgVt * sqrtkusaiL + kusaiL ;
            // cross-correlation coefficient(= Sigid/sqrt(Sig*Sid) ) //
            crl_f = `c_sqrt_15 * kusai00L * T7w / (6.0e0 * T2 * sqrt(GAMMA * T2 * VgVt * T5)) ;
        end

    end // ThermalNoiseModel

    //-----------------------------------------------------------*
    //End of PART-6. (label)
    //-----------------//
    //   end_of_part_6: //

    //-------------------------------------------*
    //* Add IdsIBPC to Ids.  090110
    //*-----------------//
    Ids = Ids + IdsIBPC ;

    //---------------------------------------------------*
    //Constant capacitance.
    //----------------//
    if ( COBCNODE == 1 ) begin
        Cgbe = Cbtp + Cbtn ;
        if (CGBO_GIVEN) begin
            Cgbe = Cgbe - CGBO * Lgleff ;
        end
        Qgob = - Cgbe * (Vgs - Vbsp) ;
        //---------------------------------------------------*
        //Fringing capacitance.
        //----------------//
        Cfu = `C_EOX / (`C_Pi/ 2.0e0)* log1p(TPOLY / Tfox0) ;
        Cfd = Cfu * NF * ( Wgate + UC_PDBCP );
        Cfs = Cfu * NF * ( Wgate + UC_PSBCP );
        Qfd = Cfd * (Vgs - Vds) ;
        Qfs = Cfs * Vgs ;
        Qfbc = Cfu * LBT*NF * (Vgs- Vbsp);  // for body contact
        //---------------------------------------------------*
        //Add fringing charge/capacitance to overlap.
        //----------------//
        Qgod = Qgod + Qfd ;
        Qgos = Qgos + Qfs ;
        Qgob = Qgob + Qfbc ;
    end else begin
        if (CGBO_GIVEN) begin
            Cgbe = - CGBO * Lgleff ;
            Qgob = - Cgbe * (Vgs -Vbsp) ;
        end else begin
            Cgbe = 0.0 ;
            Qgob = 0.0 ;
        end
        //---------------------------------------------------*
        //Fringing capacitance.
        //----------------//
        Cf = `C_EOX / (`C_Pi / 2.0e0) * Wgate * NF * log1p(TPOLY / Tfox0) ;
        Cfd = Cf ;
        Cfs = Cf ;
        Qfd = Cfd * (Vgs - Vds) ;
        Qfs = Cfs * Vgs ;
        //---------------------------------------------------*
        //Add fringing charge/capacitance to overlap.
        //----------------//
        Qgod = Qgod + Qfd ;
        Qgos = Qgos + Qfs ;
    end

    //-----------------------------------------------------------*
    //Assign outputs.
    //----------------//

    //---------------------------------------------------*
    //Channel current and conductances.
    //----------------//
    idse = Mfactor * Ids ;

    //---------------------------------------------------*
    //Intrinsic charges/capacitances.
    //----------------//
    if (flg_nqs) begin // for flat handling of NQS: the NQS charges are added
        qde = 0.0 ;
        qge = 0.0 ;
        if ( COBCNODE == 1 ) begin
            qse = 0.0 ;
            Xd = Qdrat ;
            Qb_qs = Mfactor * Qb ;
            Qi_qs = Mfactor * Qi ;
        end else begin
            qbe = 0.0 ;
            Qb_qs = Mfactor * Qsub ;
            Qd_qs = Mfactor * (     Qd + Qd_FB) ;
            Qs_qs = Mfactor * (Qi - Qd + Qs_FB) ;
        end
    end else begin             // QS //
        if ( COBCNODE == 1 ) begin
            qge = Mfactor * (-Qb - Qi ) ;
            qde = Mfactor * (     Qd )   ;
            qse = Mfactor * (Qi - Qd )   ;
        end else begin
            qge = Mfactor * (-Qsub - Qi - Qs_FB - Qd_FB) ;
            qde = Mfactor * (     Qd + Qd_FB) ;
            qse = Mfactor * (Qi - Qd + Qs_FB) ;
        end
    end

    //---------------------------------------------------*
    //Overlap capacitances.
    //----------------//

    //---------------------------------------------------*
    //Lateral-field-induced capacitance.
    //----------------//
    begin : LateralFieldInducedCapacitance
        real Pslk, T1, T10, T3, T2;

        if (XQY == 0) begin
            Qy = 0e0 ;
        end else begin
            Pslk = Ec * Leff + Ps0 ;
            if (Pslk > Psdl) begin
                Pslk = Psdl ;
            end
            T1 = Aclm * (Vds + Ps0) + (1.0e0 - Aclm) * Pslk ;
            T10 = sqrt(2.0e0 * `C_ESI / q_Nsub) ;
            T3 = T10 * 1.3 ;
            T2 = `C_ESI * weffcv_nf * T3 ;
            Qy = ((Ps0 + Vds - T1) / XQY - Ec) * T2 ;
        end
        if ( XQY1 != 0.0 ) begin
            Qy = Qy + cqyb0 * Vbsp ;
        end
    end // LateralFieldInducedCapacitance

    //---------------------------------------------------*
    //Add S/D overlap charges/capacitances to intrinsic ones.
    //- NOTE: This function depends on coadov, a control option.
    //----------------//
    if (COADOV == 1) begin
        if ( COBCNODE == 1 ) begin
            q_bt_ge = - Qbody_bt_p_sus - Qbody_bt_p_sud - Qbody_bt_n_sus - Qbody_bt_n_sud ;
            q_bt_de =   Qbody_bt_p_iud + Qbody_bt_n_iud ;
            q_bt_se =   Qbody_bt_p_ius + Qbody_bt_n_ius ;
            qge = qge + Mfactor * ( Qgod + Qgos + Qgob - Qy - Qovs - Qovd + q_bt_ge ) ;
            qde = qde + Mfactor * (-Qgod + Qy + QbdLD + q_bt_de ) ;
            qse = qse + Mfactor * (-Qgos      + QbsLD + q_bt_se ) ;
        end else begin
            qge = qge + Mfactor * ( Qgod + Qgos + Qgob - Qy - Qovs - Qovd) ;
            qde = qde + Mfactor * (-Qgod + Qy + QbdLD) ;
            qse = qse + Mfactor * (-Qgos      + QbsLD) ;
        end
    end

    //---------------------------------------------------*
    //Von, Vdsat,
    //----------------//
    vone = Vth ;
    vdsate = Vdsat ;

    if ( COBCNODE == 1 ) begin
        //Junction diode.
        //----------------//
        ibsb = Mfactor * Ibs ;
        ibdb = Mfactor * Ibd ;

        qbd_s0 = Mfactor * Qbd ;
        qbs_s0 = Mfactor * Qbs ;
    end else begin
        ibsb   = 0.0 ;
        ibdb   = 0.0 ;
        qbd_s0 = 0.0 ;
        qbs_s0 = 0.0 ;
    end

    //---------------------------------------------------*
    //Substrate/gate/leak currents.
    //----------------//
    if (COISUB != 1) begin
        isube = 0.0 ;
    end else begin
        isube = Mfactor * Isub ;
    end

    igbe = Mfactor * -Igb ;
    if (mode == `HiSIM_NORMAL_MODE) begin
        igde = Mfactor * (GLPART1 * Igate - Igd) ;
    end else begin
        igde = Mfactor * ((1.0 - GLPART1) * Igate - Igs) ;
    end
    if (mode == `HiSIM_NORMAL_MODE) begin
        igse = Mfactor * ((1.0 - GLPART1) * Igate - Igs) ;
    end else begin
        igse = Mfactor * (GLPART1 * Igate - Igd) ;

    end
    igidle = (mode == `HiSIM_NORMAL_MODE) ? Mfactor * Igidl : Mfactor * Igisl ;
    igisle = (mode == `HiSIM_NORMAL_MODE) ? Mfactor * Igisl : Mfactor * Igidl ;

    //-----------------------------------------------------------*
    //* Noise.
    //*-----------------//
    noiflick = Mfactor * Nflic ;
    noithrml = Mfactor * Nthrml ;

    cgdbd = ddx(qge,V(dp)) ;
    cgdbd = TYPE * cgdbd ;  // quantity obtained from ddx
    cgsbd = ddx(qge,V(sp)) ;
    cgsbd = TYPE * cgsbd ;  // quantity obtained from ddx
    cgsb  = (mode > 0) ? cgsbd : cgdbd ;
    //cgsb  = - C_fox * weffcv_nf * Leff_cv * Mfactor ;  //possible solution for VAMPyRE ERROR//

    //----------------------------------------------------------*
    //* induced gate noise. ( Part 3/3 )
    //*---------------------- from HiSIM 2 //
    begin : InducedGateNoise_3of3
        real T0, T1, Nign0, MuModA, MuModB,correct_w1;

        if (COIGN != 0 && COTHRML != 0 && flg_ign == 1 && !flg_noqi) begin
            T0 = `C_fox_Small * C_fox * weffcv_nf * Leff_cv ;
            T1 = cgsb / Mfactor ;
            Nign0 = `c_16o135 * `C_QE * beta_inv * T1 * T1 / gds0_ign ;
            if (kusai00L > `epsm10 && Vds > `epsm10) begin
                MuModA = Muun / Mu ;
                MuModB = (Muun / Mud_hoso - MuModA) / Vds ;
                correct_w1 = MuModA + `C_2o3 * MuModB * (kusai00 + VgVt * sqrtkusaiL + kusaiL)
                    / (VgVt + sqrtkusaiL) ;
            end else begin
                correct_w1 = Muun / Mud_hoso ;
            end
            noiigate = Mfactor * Nign0 * kusai_ig * correct_w1 ;
            noicross = crl_f ;
            noiigate = ( - T1 > T0 && noiigate > 0 ) ? noiigate : 0.0 ;
            noicross = ( - T1 > T0 ) ? noicross : 0.0 ;
        end else begin
            noiigate = 0.0e0 ;
            noicross = 0.0e0 ;
        end
    end // InducedGateNoise_3of3

    //++++++++++++++++++++++++++++++++++++++++++++++++++++++++++++++++++++
    //* PART of New Drift Resistance Model.
    //*+++++++++++++++++++++++++++++++++++++++++++++++++++++++++++++++++++//
    Rdde = 0.0 ;
    Rsde = 0.0 ;
    drainConductance = 0.0 ;
    sourceConductance = 0.0 ;
    if ( CORS == 1 ) begin
        rdmod = 1;
        begin : HSMHV_eval_rdrifrs
// ---- begin `include "HSMSOI_eval_rdrift.inc" ----
/***********************************************************************

 HiSIM (Hiroshima University STARC IGFET Model)
 Copyright (C) 2000-2016 Hiroshima University and STARC
 Copyright (C) 2016-2021 Hiroshima University
 HiSIM_SOI (Silicon-On-Insulator Model)
 Copyright (C) 2012-2016 Hiroshima University and STARC
 Copyright (C) 2016-2021 Hiroshima University

 MODEL NAME : HiSIM_SOI
 ( VERSION : 1  SUBVERSION : 5  REVISION : 0 )
 Model Parameter 'VERSION' : 1.50
 FILE : vaFiles/HSOI_eval_rdrift.inc

 Date : 2021.10.08

 released by Hiroshima University

***********************************************************************/
//
////////////////////////////////////////////////////////////////
//
//
//Licensed under the Educational Community License, Version 2.0
//(the "License"); you may not use this file except in
//compliance with the License.
//
//You may obtain a copy of the License at:
//
//      http://opensource.org/licenses/ECL-2.0
//
//Unless required by applicable law or agreed to in writing,
//software distributed under the License is distributed on an
//"AS IS" BASIS, WITHOUT WARRANTIES OR CONDITIONS OF ANY KIND,
//either express or implied. See the License for the specific
//language governing permissions and limitations under the
//License.
//
//
//The HiSIM_SOI standard has been supported by the members of
//Silicon Integration Initiative's Compact Model Coalition. A
//link to the most recent version of this standard can be found
//at:
//
//http://www.si2.org/cmc
//
////////////////////////////////////////////////////////////////
//

//begin : HSMHV_eval_rdrif

// Input instance parameters : NRD , NRS , NF ;
// Input model parameters : RSH , XLD , LDRIFT , LDRIFTS ;
// -- RDRMUE  , RDRVMAX  , RDRMUETMP , RDRVTMP  , RDRDJUNC ;
// -- RDRMUES , RDRVMAXS ;
// Input variables : Weff , TTEMP , UC_TNOM , NOVER , NOVERS ;
real Rdrmuele , Rdrvmaxwe , Rdrvmaxle ;
real MKS_RDRMUE , MKS_RDRVMAX , RRDRBB ;
real Rsd0 , Vrdr , Tratio ;
real Ldrifte, Nover, Mu0, Vmaxe, Edri, Vdri;
real Mu, Xov, GD, Weff_nf ;

if ( rdmod == 1 ) begin
    // source resistance
    Nover = NOVERS   / `C_cm2m_p3; //"cm^-3"
    MKS_RDRMUE  = RDRMUES ;
    MKS_RDRVMAX = RDRVMAXS ;
    RRDRBB      = RDRBBS ;
    Rsd0 = (RSH > 0.0 ) ? RSH * NRS : 0.0 ;
    Ldrifte = LDRIFTS ;
    Vrdr  = TYPE * V(BRsps);  // get bias
end else begin
    // drain resistance
    Nover = NOVER    / `C_cm2m_p3; //"cm^-3"
    MKS_RDRMUE  = RDRMUE ;
    MKS_RDRVMAX = RDRVMAX ;
    RRDRBB      = RDRBB ;
    Rsd0 = (RSH > 0.0 ) ? RSH  * NRD : 0.0 ;
    Ldrifte = LDRIFT  ;
    Vrdr  = TYPE * V(BRddp);  // get bias
end
Xov  = sqrt( RDRDJUNC * RDRDJUNC + XLD * XLD ) ;
Weff_nf = Weff * NF ;

//-----------------------------------------------------------*
//* Change units into MKS.
//*-----------------//
MKS_RDRMUE  = MKS_RDRMUE   / `C_m2cm_p2 ;
MKS_RDRVMAX = MKS_RDRVMAX  / `C_m2cm ;

//-----------------------------------------------------------*
//* Temperature dependent constants.
//*-----------------//
Tratio = TTEMP / UC_TNOM ;

// Phonon Scattering(temperature-dependent part) //
T1 =  `Fn_Pow( Tratio, RDRMUETMP ) ;
Mu0 = MKS_RDRMUE / T1 ;

// Velocity Temperature Dependence //
T0 = 1.8 + 0.4 * Tratio + 0.1 * Tratio * Tratio - RDRVTMP * ( 1.0 - Tratio ) ;
Vmaxe = MKS_RDRVMAX / T0 ;

//Toshiba model //
RRDRBB = RRDRBB + RDRBBTMP * (TTEMP-UC_TNOM) ;

// LW dependence of RDRMUE and RDRVMAX
Rdrmuele  = 1.0e0 + (RDRMUEL  / pow( LGLE, RDRMUELP )) ;
Rdrvmaxle = 1.0e0 + (RDRVMAXL / pow( LGLE, RDRVMAXLP)) ;
Rdrvmaxwe = 1.0e0 + (RDRVMAXW / pow( WG  , RDRVMAXWP)) ;
Mu0   = Mu0   * Rdrmuele ;
Vmaxe = Vmaxe * Rdrvmaxwe * Rdrvmaxle + `Small ;

`ifdef __DEBUG_RDRIFTS__
    $write(" RDRMUEL %g RDRMUELP %g LGLE  %g Rdrmuele %g Mu0 %g \n", RDRMUEL,RDRMUELP,LGLE,Rdrmuele,Mu0);
    $write(" RDRVMAXL %g RDRVMAXLP %g RDRVMAXW %g RDRVMAXWP %g LGLE %g WG %g Rdrvmaxle %g Rdrvmaxwe %g Vmaxe %g\n",
    RDRVMAXL,RDRVMAXLP,RDRVMAXW,RDRVMAXWP,LGLE,WG,Rdrvmaxle,Rdrvmaxwe,Vmaxe );

    $write("debug_eval_rdrifts_0[ %g %g %g %g ]\n",rdmod, Vmaxe, MKS_RDRVMAX, Mu0);
`endif

Edri  = Vrdr / Ldrifte ;
Vdri  = Mu0 * Edri ;
//-----------------------------------------------------------*
//* Mu : mobility
//*-----------------//
if ( Vrdr >= 0 ) begin
    T1    =   Vdri / Vmaxe ;
end else  begin
    T1    = - Vdri / Vmaxe ;
end
`ifdef __DEBUG_RDRIFTS__
    $write("debug_eval_rdrifts_a[ %g %g %g  %g %g ]\n", rdmod, Vdri, Vmaxe, Edri, Mu0);
`endif
if ( 1.0e0 - `epsm10 <= RRDRBB && RRDRBB <= 1.0e0 + `epsm10 ) begin
    T3 = 1.0e0 ;
end else if ( 2.0e0 - `epsm10 <= RRDRBB && RRDRBB <= 2.0e0 + `epsm10 ) begin
    T3 = T1 ;
end else  begin
    T3 = pow( T1 , RRDRBB - 1.0e0 ) ;  // if( T1 == 0.0 ) is removed because T1 is bias-dependent.
end
T2 = T1 * T3 ;
T4 = 1.0e0 + T2 ;
if ( 1.0e0 - `epsm10 <= RRDRBB && RRDRBB <= 1.0e0 + `epsm10 ) begin
    T5 = 1.0 / T4 ;
end else if ( 2.0e0 - `epsm10 <= RRDRBB && RRDRBB <= 2.0e0 + `epsm10 ) begin
    T5 = 1.0 / sqrt( T4 ) ;
end else  begin
    T6 = `Fn_Pow( T4 , ( - 1.0e0 / RRDRBB - 1.0e0 ) ) ;
    T5 = T4 * T6 ;
end
Mu   = Mu0 * T5 ;  // velocity saturation accounted
`ifdef __DEBUG_RDRIFTS__
    $write("debug_eval_rdrifts_b[ %g %g %g ]\n", Mu, Mu0, T5);
`endif

//-----------------------------------------------------------*
//* Rd : drift resistance
//*-----------------//
T1 = `C_QE / ( Ldrifte );
GD = T1 * Xov * Mu * Nover ;
`ifdef __DEBUG_RDRIFTS__
    $write("debug_eval_rdrifts_c[ %g %g %g %g %g  %g %g %g  %g ]\n", GD, T1, Xov, Mu, Nover, Mu0, Vdri, Vmaxe, Edri);
`endif

`ifdef REPLACE_CLIPPING_WITH_SMOOTHING //revised for continuity (Rsd)
    `Fn_SL_CP(GD, GD, 0, `Small, 2)
`else
    if ( GD <= 0 ) begin
        GD = `Small ;
    end
`endif

Rsd = 1.0 / GD ;
// Weff dependence of the resistances //
Rsd = Rsd  /  Weff_nf ;

// Sheet resistances are added. //
Rsd = Rsd + Rsd0 ;

// Re-stamps for hsmhvnoi.c //
Conductance =  ( Rsd > `Res_min && COTHRML != 0 ) ? Mfactor / Rsd : 0.0 ;

// Clamping to Res_min //
if (Rsd < `Res_min) begin
    Rsd = `Res_min ;
end

`ifdef __DEBUG_RDRIFTS__
    $write("debug_eval_rdrifts_d[ %g %g %g %g %g %g  ]\n", rdmod, GD, Rsd, Rsd0, Weff_nf, Conductance);
`endif

//end HSMHV_eval_rdrifrs

// ---- end `include "HSMSOI_eval_rdrift.inc" ----
        end //  HSMHV_eval_rdrifrs
        Rsde = Rsd / Mfactor ;
        sourceConductance = Conductance ;
    end // if( CORS == 1 )
    if ( CORD == 1 ) begin
        rdmod = 2;
        begin : HSMHV_eval_rdrifrd
// ---- begin `include "HSMSOI_eval_rdrift.inc" ----
/***********************************************************************

 HiSIM (Hiroshima University STARC IGFET Model)
 Copyright (C) 2000-2016 Hiroshima University and STARC
 Copyright (C) 2016-2021 Hiroshima University
 HiSIM_SOI (Silicon-On-Insulator Model)
 Copyright (C) 2012-2016 Hiroshima University and STARC
 Copyright (C) 2016-2021 Hiroshima University

 MODEL NAME : HiSIM_SOI
 ( VERSION : 1  SUBVERSION : 5  REVISION : 0 )
 Model Parameter 'VERSION' : 1.50
 FILE : vaFiles/HSOI_eval_rdrift.inc

 Date : 2021.10.08

 released by Hiroshima University

***********************************************************************/
//
////////////////////////////////////////////////////////////////
//
//
//Licensed under the Educational Community License, Version 2.0
//(the "License"); you may not use this file except in
//compliance with the License.
//
//You may obtain a copy of the License at:
//
//      http://opensource.org/licenses/ECL-2.0
//
//Unless required by applicable law or agreed to in writing,
//software distributed under the License is distributed on an
//"AS IS" BASIS, WITHOUT WARRANTIES OR CONDITIONS OF ANY KIND,
//either express or implied. See the License for the specific
//language governing permissions and limitations under the
//License.
//
//
//The HiSIM_SOI standard has been supported by the members of
//Silicon Integration Initiative's Compact Model Coalition. A
//link to the most recent version of this standard can be found
//at:
//
//http://www.si2.org/cmc
//
////////////////////////////////////////////////////////////////
//

//begin : HSMHV_eval_rdrif

// Input instance parameters : NRD , NRS , NF ;
// Input model parameters : RSH , XLD , LDRIFT , LDRIFTS ;
// -- RDRMUE  , RDRVMAX  , RDRMUETMP , RDRVTMP  , RDRDJUNC ;
// -- RDRMUES , RDRVMAXS ;
// Input variables : Weff , TTEMP , UC_TNOM , NOVER , NOVERS ;
real Rdrmuele , Rdrvmaxwe , Rdrvmaxle ;
real MKS_RDRMUE , MKS_RDRVMAX , RRDRBB ;
real Rsd0 , Vrdr , Tratio ;
real Ldrifte, Nover, Mu0, Vmaxe, Edri, Vdri;
real Mu, Xov, GD, Weff_nf ;

if ( rdmod == 1 ) begin
    // source resistance
    Nover = NOVERS   / `C_cm2m_p3; //"cm^-3"
    MKS_RDRMUE  = RDRMUES ;
    MKS_RDRVMAX = RDRVMAXS ;
    RRDRBB      = RDRBBS ;
    Rsd0 = (RSH > 0.0 ) ? RSH * NRS : 0.0 ;
    Ldrifte = LDRIFTS ;
    Vrdr  = TYPE * V(BRsps);  // get bias
end else begin
    // drain resistance
    Nover = NOVER    / `C_cm2m_p3; //"cm^-3"
    MKS_RDRMUE  = RDRMUE ;
    MKS_RDRVMAX = RDRVMAX ;
    RRDRBB      = RDRBB ;
    Rsd0 = (RSH > 0.0 ) ? RSH  * NRD : 0.0 ;
    Ldrifte = LDRIFT  ;
    Vrdr  = TYPE * V(BRddp);  // get bias
end
Xov  = sqrt( RDRDJUNC * RDRDJUNC + XLD * XLD ) ;
Weff_nf = Weff * NF ;

//-----------------------------------------------------------*
//* Change units into MKS.
//*-----------------//
MKS_RDRMUE  = MKS_RDRMUE   / `C_m2cm_p2 ;
MKS_RDRVMAX = MKS_RDRVMAX  / `C_m2cm ;

//-----------------------------------------------------------*
//* Temperature dependent constants.
//*-----------------//
Tratio = TTEMP / UC_TNOM ;

// Phonon Scattering(temperature-dependent part) //
T1 =  `Fn_Pow( Tratio, RDRMUETMP ) ;
Mu0 = MKS_RDRMUE / T1 ;

// Velocity Temperature Dependence //
T0 = 1.8 + 0.4 * Tratio + 0.1 * Tratio * Tratio - RDRVTMP * ( 1.0 - Tratio ) ;
Vmaxe = MKS_RDRVMAX / T0 ;

//Toshiba model //
RRDRBB = RRDRBB + RDRBBTMP * (TTEMP-UC_TNOM) ;

// LW dependence of RDRMUE and RDRVMAX
Rdrmuele  = 1.0e0 + (RDRMUEL  / pow( LGLE, RDRMUELP )) ;
Rdrvmaxle = 1.0e0 + (RDRVMAXL / pow( LGLE, RDRVMAXLP)) ;
Rdrvmaxwe = 1.0e0 + (RDRVMAXW / pow( WG  , RDRVMAXWP)) ;
Mu0   = Mu0   * Rdrmuele ;
Vmaxe = Vmaxe * Rdrvmaxwe * Rdrvmaxle + `Small ;

`ifdef __DEBUG_RDRIFTS__
    $write(" RDRMUEL %g RDRMUELP %g LGLE  %g Rdrmuele %g Mu0 %g \n", RDRMUEL,RDRMUELP,LGLE,Rdrmuele,Mu0);
    $write(" RDRVMAXL %g RDRVMAXLP %g RDRVMAXW %g RDRVMAXWP %g LGLE %g WG %g Rdrvmaxle %g Rdrvmaxwe %g Vmaxe %g\n",
    RDRVMAXL,RDRVMAXLP,RDRVMAXW,RDRVMAXWP,LGLE,WG,Rdrvmaxle,Rdrvmaxwe,Vmaxe );

    $write("debug_eval_rdrifts_0[ %g %g %g %g ]\n",rdmod, Vmaxe, MKS_RDRVMAX, Mu0);
`endif

Edri  = Vrdr / Ldrifte ;
Vdri  = Mu0 * Edri ;
//-----------------------------------------------------------*
//* Mu : mobility
//*-----------------//
if ( Vrdr >= 0 ) begin
    T1    =   Vdri / Vmaxe ;
end else  begin
    T1    = - Vdri / Vmaxe ;
end
`ifdef __DEBUG_RDRIFTS__
    $write("debug_eval_rdrifts_a[ %g %g %g  %g %g ]\n", rdmod, Vdri, Vmaxe, Edri, Mu0);
`endif
if ( 1.0e0 - `epsm10 <= RRDRBB && RRDRBB <= 1.0e0 + `epsm10 ) begin
    T3 = 1.0e0 ;
end else if ( 2.0e0 - `epsm10 <= RRDRBB && RRDRBB <= 2.0e0 + `epsm10 ) begin
    T3 = T1 ;
end else  begin
    T3 = pow( T1 , RRDRBB - 1.0e0 ) ;  // if( T1 == 0.0 ) is removed because T1 is bias-dependent.
end
T2 = T1 * T3 ;
T4 = 1.0e0 + T2 ;
if ( 1.0e0 - `epsm10 <= RRDRBB && RRDRBB <= 1.0e0 + `epsm10 ) begin
    T5 = 1.0 / T4 ;
end else if ( 2.0e0 - `epsm10 <= RRDRBB && RRDRBB <= 2.0e0 + `epsm10 ) begin
    T5 = 1.0 / sqrt( T4 ) ;
end else  begin
    T6 = `Fn_Pow( T4 , ( - 1.0e0 / RRDRBB - 1.0e0 ) ) ;
    T5 = T4 * T6 ;
end
Mu   = Mu0 * T5 ;  // velocity saturation accounted
`ifdef __DEBUG_RDRIFTS__
    $write("debug_eval_rdrifts_b[ %g %g %g ]\n", Mu, Mu0, T5);
`endif

//-----------------------------------------------------------*
//* Rd : drift resistance
//*-----------------//
T1 = `C_QE / ( Ldrifte );
GD = T1 * Xov * Mu * Nover ;
`ifdef __DEBUG_RDRIFTS__
    $write("debug_eval_rdrifts_c[ %g %g %g %g %g  %g %g %g  %g ]\n", GD, T1, Xov, Mu, Nover, Mu0, Vdri, Vmaxe, Edri);
`endif

`ifdef REPLACE_CLIPPING_WITH_SMOOTHING //revised for continuity (Rsd)
    `Fn_SL_CP(GD, GD, 0, `Small, 2)
`else
    if ( GD <= 0 ) begin
        GD = `Small ;
    end
`endif

Rsd = 1.0 / GD ;
// Weff dependence of the resistances //
Rsd = Rsd  /  Weff_nf ;

// Sheet resistances are added. //
Rsd = Rsd + Rsd0 ;

// Re-stamps for hsmhvnoi.c //
Conductance =  ( Rsd > `Res_min && COTHRML != 0 ) ? Mfactor / Rsd : 0.0 ;

// Clamping to Res_min //
if (Rsd < `Res_min) begin
    Rsd = `Res_min ;
end

`ifdef __DEBUG_RDRIFTS__
    $write("debug_eval_rdrifts_d[ %g %g %g %g %g %g  ]\n", rdmod, GD, Rsd, Rsd0, Weff_nf, Conductance);
`endif

//end HSMHV_eval_rdrifrs

// ---- end `include "HSMSOI_eval_rdrift.inc" ----
        end //  HSMHV_eval_rdrifrd
        Rdde = Rsd / Mfactor ;
        drainConductance = Conductance ;
    end // if( CORD == 1 )
    //-----------------------------------------------------------*
    //* End of New Drift Resistance Model.
    //*-----------------//

    // *-------------------------------------------------------------
    // * Actually load the device currents                 hsmsoild.c
    // *

    // in case of nqs: construct static contributions to the nqs equations(Iqi_nqs ; Iqb_nqs)       //
    //   and nqs charge contributions to inner drain ; gate and source node(Qd_nqs ; Qg_nqs ; Qs_nqs) //

    if ( COBCNODE == 1 ) begin
        if (flg_nqs) begin
            // .. tau ; taub must be > 0 //
            if (tau  < `tau_min) tau  = `tau_min ;
            if (taub < `tau_min) taub = `tau_min ;
            //
            Qdrat = (mode == 1) ? Xd : (1.0 - Xd) ;
            Iqi_nqs = (Qi_nqs - Qi_qs) / tau ;
            Iqb_nqs = (Qb_nqs - Qb_qs) / taub ;
            //
            Qd_nqs =  Qi_nqs * Qdrat + q_bt_se ;
            Qs_nqs =  Qi_nqs * (1.0 - Qdrat) + q_bt_se ;
            Qg_nqs = -Qi_nqs - Qb_nqs + q_bt_ge ;
        end else begin
            Iqi_nqs = 0.0 ;
            Iqb_nqs = 0.0 ;
            Qd_nqs  = 0.0 ;
            Qs_nqs  = 0.0 ;
            Qg_nqs = 0.0 ;
            Qb_nqs  = 0.0 ;
        end
    end else begin
        if (flg_nqs) begin
            // .. tau ; taub must be > 0 //
            if (tau  < `tau_min) tau  = `tau_min ;
            if (taub < `tau_min) taub = `tau_min ;
            Iqd_nqs = (Qd_nqs - Qd_qs) / tau ;
            Iqs_nqs = (Qs_nqs - Qs_qs) / tau ;
            Iqb_nqs = (Qb_nqs - Qb_qs) / taub ;
            Iqb_nqs = 0.0 ;
            Qg_nqs  = -Qd_nqs -Qs_nqs -Qb_nqs ;
        end else begin
            Iqd_nqs = 0.0 ;
            Iqs_nqs = 0.0 ;
            Iqb_nqs = 0.0 ;
            Qd_nqs  = 0.0 ;
            Qs_nqs = 0.0 ;
            Qg_nqs = 0.0 ;
            Qb_nqs  = 0.0 ;
        end
    end

    //----------------------------------------------new////
    Rdd = Rdde ;
    Rsd = Rsde ;
    if (mode == 1) begin
        Ids = idse ;
        Isub = isube ;
        Isubs = 0.0 ;
        Qg = qge + Qg_nqs;
        Qd = qde + Qd_nqs;
        Qs = qse + Qs_nqs;
        qbe = -(qge + qde + qse ) ;
        Qb = qbe + Qb_nqs;
    end else begin
        Ids = -idse ;
        Isubs = isube ;
        Isub = 0.0 ;
        Qg = qge + Qg_nqs;
        Qd = qse + Qs_nqs;
        Qs = qde + Qd_nqs;
        qbe = -(qge + qde + qse ) ;
        Qb = qbe + Qb_nqs ;
    end

    //---------------------------------------------------*
    // Igd, Igs, Igb, Igidl
    //*-----------------//
    Igd = igde ;
    Igs = igse ;
    Igb = igbe ;
    Igidl = igidle ;
    Igisl = igisle ;

    if ( COBCNODE == 1 ) begin
        //---------------------------------------------------*
        //* Junction diode.
        //*-----------------//
        Ibd = ibdb ;
        Qbd = qbd_s0 ;
        Ibs = ibsb ;
        Qbs = qbs_s0 ;
    end
    //---------------------------------------------------*
    //* Power current.
    //*-----------------//
    if (COSELFHEAT == 1 && MKS_RTH0 > 0.0) begin
        Rpower = Ids * Vds ;
        Cthe = cth ;
        Gth = 1.0 / rth ;
    end else begin
        Rpower = 0.0 ;
        Cthe = 0.0 ;
        Gth = 0.0 ;
    end

    //--print Op points--------*/
    idse    =  Ids  ;
    Isuba   =  TYPE * (Isub + Isubs) ;

    ggds    =  ddx(idse,V(dp)) ;
    ggds  = TYPE * ggds  ;
    ggdss   =  ddx(idse,V(sp)) ;
    ggdss = TYPE * ggdss ;

    if (mode != `HiSIM_NORMAL_MODE) begin
        ggds    = ggdss ;
    end

    ggm     =  ddx(idse,V(gp)) ;
    ggm   = TYPE * ggm   ;
    ggmbs   =  ddx(idse,V(bp)) ;
    ggmbs = TYPE * ggmbs ;
    ggmt    =  ddx(idse,V(temp)) ;

    cggbd   =  ddx(Qg,V(gp)) ;
    cggbd = TYPE * cggbd ;
    cgdbd   =  ddx(Qg,V(dp)) ;
    cgdbd = TYPE * cgdbd ;
    cgsbd   =  ddx(Qg,V(sp)) ;
    cgsbd = TYPE * cgsbd ;
    cgbbd   =  ddx(Qg,V(bp)) ;
    cgbbd = TYPE * cgbbd ;

    cdgbd   =  ddx(Qd,V(gp)) ;
    cdgbd = TYPE * cdgbd ;
    cddbd   =  ddx(Qd,V(dp)) ;
    cddbd = TYPE * cddbd ;
    cdsbd   =  ddx(Qd,V(sp)) ;
    cdsbd = TYPE * cdsbd ;
    cdbbd   =  ddx(Qd,V(bp)) ;
    cdbbd = TYPE * cdbbd ;

    cbgbd   =  ddx(Qb,V(gp)) ;
    cbgbd = TYPE * cbgbd ;
    cbdbd   =  ddx(Qb,V(dp)) ;
    cbdbd = TYPE * cbdbd ;
    cbsbd   =  ddx(Qb,V(sp)) ;
    cbsbd = TYPE * cbsbd ;
    cbbbd   =  ddx(Qb,V(bp)) ;
    cbbbd = TYPE * cbbbd ;

    csgbd   =  ddx(Qs,V(gp)) ;
    csgbd = TYPE * csgbd ;
    csdbd   =  ddx(Qs,V(dp)) ;
    csdbd = TYPE * csdbd ;
    cssbd   =  ddx(Qs,V(sp)) ;
    cssbd = TYPE * cssbd ;
    csbbd   =  ddx(Qs,V(bp)) ;
    csbbd = TYPE * csbbd ;

    if ( COBCNODE == 1 ) begin
        ibdb    =  TYPE * Ibd  ;
        ibsb    =  TYPE * Ibs  ;

        Gbd     =  ddx(ibdb,V(bp)) ;
        Gbs     =  ddx(ibsb,V(bp)) ;

        capbdb  =  ddx(Qbd,V(bp)) ;
        capbsb  =  ddx(Qbs,V(bp)) ;
    end else begin
        capbdb = 0.0 ;
        capbsb = 0.0 ;
    end

    // print all outputs ------------VV //
    begin : Print_INFO
        real ggbgs , ggbds , ggbbs ;

        ggbgs   =  ddx(Isuba,V(gp)) ;
        ggbds   =  ddx(Isuba,V(dp)) ;
        ggbbs   =  ddx(Isuba,V(bp)) ;

        // print all outputs ------------VV //
        if ( INFO >= 8 ) begin
            $write( "vone,vdsate = %18.10e %18.10e \n" , vone, vdsate ) ;
            $write( "Ids       = %18.10e \n" , idse ) ;
            $write( "gds       = %18.10e \n" , ggds ) ;
            $write( "gm        = %18.10e \n" , ggm  ) ;
            $write( "gmbs      = %18.10e \n" , ggmbs) ;
            $write( "gmt       = %18.10e \n" , ggmt) ;
            $write( "Qg        = %18.10e \n" , qge ) ;
            $write( "Qd        = %18.10e \n" , qde ) ;
            $write( "Qs        = %18.10e \n" , qse  ) ;
            $write( "Qfd,Cfd   = %18.10e %18.10e \n" , Qfd, Cfd ) ;
            $write( "Qfs,Cfs   = %18.10e %18.10e \n" , Qfs, Cfs ) ;
            $write( "cggb      = %18.10e \n" , cggbd ) ;
            $write( "cgsb      = %18.10e \n" , cgsbd ) ;
            $write( "cgdb      = %18.10e \n" , cgdbd ) ;
            $write( "cgbb      = %18.10e \n" , cgbbd ) ;
            $write( "cbgb      = %18.10e \n" , cbgbd ) ;
            $write( "cbsb      = %18.10e \n" , cbsbd ) ;
            $write( "cbdb      = %18.10e \n" , cbdbd ) ;
            $write( "cbbb      = %18.10e \n" , cbbbd ) ;
            $write( "cdgb      = %18.10e \n" , cdgbd ) ;
            $write( "cdsb      = %18.10e \n" , cdsbd ) ;
            $write( "cddb      = %18.10e \n" , cddbd ) ;
            $write( "cdbb      = %18.10e \n" , cdbbd ) ;
            if ( COBCNODE == 1 ) begin
                $write( "Ibd,Ibs   = %18.10e %18.10e\n" , ibdb , ibsb ) ;
                $write( "Gbd,Gbs   = %18.10e %18.10e\n" , Gbd  , Gbs  ) ;
                $write( "Cbd,Cbs   = %18.10e %18.10e\n" , capbdb , capbsb ) ;
                $write( "Qbd,Qbs   = %18.10e %18.10e\n" , qbd_s0 , qbs_s0 ) ;
            end
            $write( "Isub      = %18.10e \n" , Isuba ) ;
            $write( "gbgs      = %18.10e \n" , ggbgs ) ;
            $write( "gbds      = %18.10e \n" , ggbds ) ;
            $write( "gbbs      = %18.10e \n" , ggbbs ) ;
        end
        // print all outputs ------------AA //
    end // Print_INFO

    // Noise coeff. calculation
    whi_noise = 4.0 * `C_KB* TTEMP * `Kwhite ;
    // Drain Currents
    I(BRdpsp) <+  TYPE * Ids ;

    // Gate Leakage Currents
    if (COIIGS == 1) begin
        I(BRgpsp) <+  TYPE * Igs ;
        I(BRgpdp) <+  TYPE * Igd ;
        I(BRgpbp) <+  TYPE * Igb ;
    end

    // Source & Drain Resistance Currents
    if (CORS) I(BRsps ) <+ V(BRsps ) / Rsd; else V(BRsps ) <+ 0.0 ;
    if (CORD) I(BRddp ) <+ V(BRddp ) / Rdd; else V(BRddp ) <+ 0.0 ;

    // Inner Capacitance Currents
    I(BRgpsp) <+  TYPE * ddt(Qg) ;
    I(BRdpsp) <+  TYPE * ddt(Qd) ;
    I(BRbpsp) <+  TYPE * ddt(Qb) ;

    // Noise Currents
    Qdrat = Qdrat_noi ;
    I(BRdpsp) <+ flicker_noise(mode * noiflick * `Kflic , FALPH  , "iflick") ; //updated for Pnoise
    // Thermal & IG Noise
    sid    = whi_noise * noithrml;
    ci     = noicross;
    sigrat = (sid > 0.0 && noiigate > 0.0) ? sqrt(noiigate/sid) : 0.0 ;
    I(n)     <+ 1*V(n) ;
    I(n)     <+ white_noise(sid , "internal") ;
    I(BRdpsp) <+ white_noise((1.0-ci*ci)*sid , "ids") ;
    I(BRdpsp) <+ ci*V(n) ;  // ERROR (requires second derivatives)
    sigrat_s  = (mode > 0) ? sigrat*(1-Qdrat) : sigrat*   Qdrat ;
    sigrat_d  = (mode > 0) ? sigrat*   Qdrat  : sigrat*(1-Qdrat) ;
    I(BRgpsp) <+ ddt(V(n)*sigrat_s) ;  // ERROR (requires second derivatives)
    I(BRgpdp) <+ ddt(V(n)*sigrat_d) ;  // ERROR (requires second derivatives)
    //
    if (CORS) I(BRsps ) <+ white_noise(whi_noise * sourceConductance , "isource");
    if (CORD) I(BRddp ) <+ white_noise(whi_noise * drainConductance  , "idrain");

    //   Shot Noise
`define C_QE2     2.0 * `C_QE      //
    if (COIIGS == 1) begin
        I(BRgpdp) <+ white_noise(`C_QE2 * Igd , "iigd") ;
        I(BRgpsp) <+ white_noise(`C_QE2 * Igs , "iigs") ;
        I(BRgpbp) <+ white_noise(`C_QE2 * Igb , "iigb") ;
    end

    // Gate Resistance Currents
    if ( CORG ) begin
        I(BRggp) <+ grg * V(BRggp) ;
    end else begin
        V(BRggp) <+ 0.0 ;
    end

    // Thermal Node Currents with thermal dissipation
    if (COSELFHEAT > 0 && RTH0 > 0.0) begin //MKS_RTH0
        Itemp = Rpower ;
        I(temp) <+ V(temp) * Gth ;
        I(temp) <+ - Itemp ;
        I(temp) <+ V(temp) * `Gnqsmin ;
        I(temp) <+ ddt(Cthe*V(temp)) ;
    end else begin
        I(temp) <+ V(temp)*1e4 ;
    end

    if ( COBCNODE == 1 ) begin
        // Substrate ,  GIDL and GISL Currents
        I(BRdpbp) <+  TYPE * (Igidl + Isub ) ;
        I(BRspbp) <+  TYPE * (Igisl + Isubs) ;
        // Junction Diode Currents
        I(BRsbsp) <+  TYPE * (Ibs + ddt(Qbs)) ;
        I(BRdbdp) <+  TYPE * (Ibd + ddt(Qbd)) ;
        // Substrate Currents
        if (CORBULK) I(BRbcbp) <+ V(BRbcbp) / Rbulk; else V(BRbcbp) <+ 0.0 ;
        // Body Resistance Network
        if (CORBNET) begin
            I(BRsbbp) <+ grbpsb * V(BRsbbp); // sb, bp
            I(BRdbbp) <+ grbpdb * V(BRdbbp); // db, bp
        end else begin
            V(BRsbbp) <+ 0.0;
            V(BRdbbp) <+ 0.0;
        end
        // NQS Node Currents
        if (CONQS) begin
            I(nqs_qi) <+ Iqi_nqs ;
            I(nqs_qb) <+ Iqb_nqs ;
            I(nqs_qi) <+ V(nqs_qi)* `Gnqsmin;
            I(nqs_qb) <+ V(nqs_qb)* `Gnqsmin;
            I(nqs_qi) <+ ddt( `NQS_CAP * V(nqs_qi) ) ;
            I(nqs_qb) <+ ddt( `NQS_CAP * V(nqs_qb) ) ;
        end else begin
            V(nqs_qi) <+ 0.0 ;
            V(nqs_qb) <+ 0.0 ;
        end // else: !if(CONQS)
        // QHS Node Currents

        if (COHIST || (COISUB == 1 && COFBE == 2)) begin
            I(nqs_qhs) <+ Iqh_nqs ;
            I(nqs_qhs) <+ V(nqs_qhs)* `Gnqsmin;
            I(nqs_qhs) <+ ddt( `NQS_CAP * V(nqs_qhs) ) ;
        end else begin
            V(nqs_qhs) <+ 0.0 ;
        end
`ifdef  PROBE
            V(PROBE1)  <+ OP_QHS ; // 20201013 probing only
            V(PROBE2)  <+ OP_DVBS_FBE ; // 20201013 probing only
`endif // PROBE
    end else begin
        // if ( COBCNODE == 0 )
        //  Substrate ,  GIDL and GISL Currents
        I(BRdpsp)  <+  TYPE * (Igidl + Isub ) ;
        I(BRspdp)  <+  TYPE * (Igisl + Isubs) ;
        // Collapsing Internal Substrate Node
        V(BRebp ) <+  0 ;
        // QHS Node Currents
        if (COHIST) begin
            I(nqs_qhs) <+ Iqh_nqs ;
            I(nqs_qhs) <+ V(nqs_qhs)* `Gnqsmin;
            I(nqs_qhs) <+ ddt( `NQS_CAP * V(nqs_qhs) ) ;
        end else begin
            V(nqs_qhs) <+ 0.0 ;
        end
`ifdef  PROBE
            V(PROBE1)  <+ OP_QHS ; // 20201013 probing only
            V(PROBE2)  <+ OP_DVBS_FBE; // 20201013 probing only
`endif // PROBE

        if (CONQS) begin
            I(nqs_qd) <+ Iqd_nqs ;
            I(nqs_qs) <+ Iqs_nqs ;
            I(nqs_qb) <+ Iqb_nqs ;
            I(nqs_qd) <+ V(nqs_qd)* `Gnqsmin;
            I(nqs_qs) <+ V(nqs_qs)* `Gnqsmin;
            I(nqs_qb) <+ V(nqs_qb)* `Gnqsmin;
            I(nqs_qd) <+ ddt( `NQS_CAP * V(nqs_qd) ) ;
            I(nqs_qs) <+ ddt( `NQS_CAP * V(nqs_qs) ) ;
            I(nqs_qb) <+ ddt( `NQS_CAP * V(nqs_qb) ) ;
        end else begin
            V(nqs_qd) <+ 0.0 ;
            V(nqs_qs) <+ 0.0 ;
            V(nqs_qb) <+ 0.0 ;
        end
    end
    // collapsing nodes
    if ( COBCNODE == 0 ) begin
        V(nqs_qi)  <+ 0.0 ;
    end else begin
        V(nqs_qd ) <+ 0.0 ;
        V(nqs_qs ) <+ 0.0 ;
    end

    // end // HSMSOI_model
    //================ End of executable code.=================//

end
// ---- end `include "HSMSOI_TOP_module.inc" ----

endmodule
