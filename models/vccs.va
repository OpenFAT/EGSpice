// VCCS: voltage-controlled current source (G element), i(p,n) = m * gain * V(cp,cn).
//
// Verilog-A implementation: Omar El-Sawy, University of Waterloo.
// Based on: ngspice G element (vccs/vccsload.c, vccspar.c).
//   ngspice: Copyright Regents of the University of California and others,
//   modified BSD license.
//
// Ports in card order: G<name> p n cp cn <gain>. Constant stamp: no bias
// dependence, no limiting, no charge, so the host may cache the Jacobian entry.
// The control pair draws no current. `m` folds into the transfer as in
// vccspar.c (`coeff = value; if (mGiven) coeff *= m`).
//
// ponytail: no POLY ladder; the builder routes G POLY(1) to bsource.va
// (imode=1) and fills only `gain` here.

`include "constants.vams"
`include "disciplines.vams"

module vccs(p, n, cp, cn);
    inout p, n, cp, cn;
    electrical p, n, cp, cn;

    // The builder always overrides `gain` with the card VALUE (0 when absent).
    parameter real gain = 0.0;               // A/V  transconductance
    parameter real m    = 1.0 from (0:inf);  //      parallel multiplier

    real k;
    analog begin
        k = m * gain;
        I(p, n) <+ k * V(cp, cn);
    end
endmodule
