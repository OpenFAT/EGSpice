// *********************************************************************************************
// ****                                                                                     ****
// ****                                    L-UTSOI Model                                    ****
// ****                                   Version 102.9.0                                   ****
// ****                                                                                     ****
// ****                      Ultra Thin Fully Depleted SOI MOSFET Model                     ****
// ****                                                                                     ****
// ****                                   Verilog-A code                                    ****
// ****      Authors: S. Martinie, T. Bedecarrats, O. Rozeau, T. Poiroux, M.A. Jaud         ****
// ****                                                                                     ****
// *********************************************************************************************
//
//
// *********************************************************************************************
// ****                            Copyright 2013-2025 CEA-Leti                             ****
// *********************************************************************************************
//
// *********************************************************************************************
// ****                     Comments on this version: January, 2026                         ****
// ****                                                                                     ****
// ****   This model is suitable for undoped ultrathin film SOI MOSFET                      ****
// ****   The core of the model (drain current and intrinsic charges) is valid also         ****
// ****   for independent double gate MOSFET, since it accounts for back interface          ****
// ****   conduction                                                                        ****
// ****                                                                                     ****
// ****   Includes:                                                                         ****
// ****       - specific surface potential calculations for FDSOI, valid also for IDG       ****
// ****       - specific drain current expression for FDSOI, valid also for IDG             ****
// ****       - specific intrinsic charges model, valid also for IDG                        ****
// ****       - field-dependent mobility including remote coulomb scattering                ****
// ****       - quantum confinement effect                                                  ****
// ****       - velocity saturation                                                         ****
// ****       - channel length modulation                                                   ****
// ****       - series-resistance with gate voltage dependence                              ****
// ****       - short-channel effects                                                       ****
// ****       - overlap capacitances (SP-based)                                             ****
// ****       - gate leakage current                                                        ****
// ****       - gate-induced drain/source leakage (GIDL, GISL)                              ****
// ****       - Impact ionization current                                                   ****
// ****       - Poly-depletion model                                                        ****
// ****       - Cryogenic temperature simulation improvement                                ****
// ****       - Separate capacitance calculation                                            ****
// ****       - self heating effect                                                         ****
// ****       - narrow-width effects                                                        ****
// ****       - stress model                                                                ****
// ****       - noise (1/f, thermal, induced gate and shot noise)                           ****
// ****       - source/drain junctions asymmetry                                            ****
// ****       - Non-quasi-static effects (using RTA approximation)                          ****
// ****       - global and local scale levels                                               ****
// ****                                                                                     ****
// *********************************************************************************************

`include "constants.vams"
`include "disciplines.vams"

`include "discipline.h"

// Flag for .OP calculations. Commenting this line cancels OP-related variables definition and OP calculations
`define OP_CALC

// `define NQSmodel

// ---- begin `include "L_UTSOI_102_macrodef.include" ----
// *********************************************************************************************
// ****                                                                                     ****
// ****                                    L-UTSOI Model                                    ****
// ****                                   Version 102.9.0                                   ****
// ****                                                                                     ****
// ****                      Ultra Thin Fully Depleted SOI MOSFET Model                     ****
// ****                                                                                     ****
// ****                                   Verilog-A code                                    ****
// ****      Authors: S. Martinie, T. Bedecarrats, O. Rozeau, T. Poiroux, M.A. Jaud         ****
// ****                                                                                     ****
// *********************************************************************************************
//
//
// *********************************************************************************************
// ****                            Copyright 2013-2025 CEA-Leti                             ****
// *********************************************************************************************
//
// *********************************************************************************************
// ****                     Comments on this version: January, 2026                         ****
// ****                                                                                     ****
// ****   This model is suitable for undoped ultrathin film SOI MOSFET                      ****
// ****   The core of the model (drain current and intrinsic charges) is valid also         ****
// ****   for independent double gate MOSFET, since it accounts for back interface          ****
// ****   conduction                                                                        ****
// ****                                                                                     ****
// ****   Includes:                                                                         ****
// ****       - specific surface potential calculations for FDSOI, valid also for IDG       ****
// ****       - specific drain current expression for FDSOI, valid also for IDG             ****
// ****       - specific intrinsic charges model, valid also for IDG                        ****
// ****       - field-dependent mobility including remote coulomb scattering                ****
// ****       - quantum confinement effect                                                  ****
// ****       - velocity saturation                                                         ****
// ****       - channel length modulation                                                   ****
// ****       - series-resistance with gate voltage dependence                              ****
// ****       - short-channel effects                                                       ****
// ****       - overlap capacitances (SP-based)                                             ****
// ****       - gate leakage current                                                        ****
// ****       - gate-induced drain/source leakage (GIDL, GISL)                              ****
// ****       - Impact ionization current                                                   ****
// ****       - Poly-depletion model                                                        ****
// ****       - Cryogenic temperature simulation improvement                                ****
// ****       - Separate capacitance calculation                                            ****
// ****       - self heating effect                                                         ****
// ****       - narrow-width effects                                                        ****
// ****       - stress model                                                                ****
// ****       - noise (1/f, thermal, induced gate and shot noise)                           ****
// ****       - source/drain junctions asymmetry                                            ****
// ****       - Non-quasi-static effects (using RTA approximation)                          ****
// ****       - global and local scale levels                                               ****
// ****                                                                                     ****
// *********************************************************************************************

// *************************************************************************************************************************
// Macros and constants used in L-UTSOI model
// *************************************************************************************************************************

// Channel type
// `define PMOS                   -1
`define NMOS                   +1

// Some functions
`define MIN_FUNC(x,y,a)         0.5*((x)+(y)-sqrt(((x)-(y))*((x)-(y))+(a)))
`define MAX_FUNC(x,y,a)         0.5*((x)+(y)+sqrt(((x)-(y))*((x)-(y))+(a)))

// Constants
`define PI                      3.1415926535898
`define INV3                    0.3333333333333
`define INV6                    0.1666666666667
`define INV60                   0.0166666666667
`define INV42                   0.0238095238095
`define INV30                   0.0333333333333
`define INV28                   0.0357142857143
`define INV14                   0.0714285714286
`define INV180                  0.0055555555556
`define INV300                  0.0033333333333
`define SQRT2                   1.4142135623731
`define LN2                     0.6931471805599
`define LN10                    2.3025850929941
`define X1OV                    1.25

// Physical constants
`define EPSOX                   3.45313E-11
`define QMN                     1.27520989
`define QMP                     1.54120870
`define KBOL                    1.3806488E-23
`define QELE                    1.602176565E-19
`define HBAR                    1.054571726E-34
`define MELE                    9.10938291E-31
`define KBOL_QELE               8.617332384961E-05

// Channel material constants
`define EPSSI                   1.04479E-10        // eps_rel = 11.8 for Si
`define EPSGE                   1.43438E-10        // eps_rel = 16.2 for Ge
`define EG0SI                   1.17               // bandgap for Si at 0K
`define EG0GE                   0.744              // bandgap for Ge at 0K
`define ALPHASI                 4.730e-4           // 1st bandgap temperature dependence parameter for Si
`define ALPHAGE                 4.774e-4           // 1st bandgap temperature dependence parameter for Ge
`define BETASI                  636                // 2nd bandgap temperature dependence parameter for Si
`define BETAGE                  235                // 2nd bandgap temperature dependence parameter for Ge
`define CG                     -0.4                // non linearity coefficient for SiGe bandgap
`define NIFACT300               4.05E25            // sqrt of NcNv for Si at 300K

// Constants needed for exponential approximation
`define EXP_THRESHOLD           80.0
`define MIN_EXP                 1.80485e-35
`define MAX_EXP                 5.54062e34

// Constants defined for drain current calculation
`define QI_LOW                  1.0E-6
`define QI_TH                   0.5
`define XSAT_MIN                6.0
`define XSAT_MAX                600.0
`define SAT_FACT                0.94
`define SMTH_SQ                 36.0
`define FIELD_SMTH              2.0

// dev3_exp       3rd order dev of exp()
`define dev3_exp(u)    (1.0 + (u) * (1.0 + 0.5 * (u) * (1.0 + (u) * `INV3)))

// lin_exp        Linearization of exponential function
`define lin_exp(x, res) \
    if (abs(x) < `EXP_THRESHOLD) begin \
        res = exp(x); \
    end else begin \
        if (x < -`EXP_THRESHOLD) begin \
            res =  `MIN_EXP / `dev3_exp(- (x) - `EXP_THRESHOLD); \
        end else begin \
            res =  `MAX_EXP * `dev3_exp((x) - `EXP_THRESHOLD); \
        end \
    end

// linmin_exp     Linearization of exponential function below threshold
`define linmin_exp(x, res) \
    if (x > -`EXP_THRESHOLD) begin \
        res = exp(x); \
    end else begin \
        res = `MIN_EXP / `dev3_exp(-(x) - `EXP_THRESHOLD); \
    end

// linmax_exp     Linearization of exponential function above threshold
`define linmax_exp(x, res) \
    if (x < `EXP_THRESHOLD) begin \
        res = exp(x); \
    end else begin \
        res = `MAX_EXP * `dev3_exp((x) - `EXP_THRESHOLD); \
    end

// ln_one_plus_exp function
`define ln_one_plus_exp(x, res) \
    if (x < `EXP_THRESHOLD) begin \
        res = ln(1.0 + exp(x)); \
    end else begin \
        res = (x); \
    end

//  Parameter definition macros: "des" description argument is intended to
//  be a short description, the "inf" information argument is intended to be
//  a detailed description (e.g. for display as part of on-line help).
//
//  MPR      model    parameter real
//  MPI      model    parameter integer
//  IPR      instance parameter real
//  IPI      instance parameter integer
//  OPP      operating point parameter, includes units and description for printing
//  OPM      operating point parameter, scales with $mfactor
//  OPD      operating point parameter, scales with 1/$mfactor
//
//  Instance parameters have the attribute *type="instance"* and note that
//  compilers treat these as both instance and model parameters, with a
//  specified instance value taking precedence over a specified model card value.
//
//  There are some issues with passing range directives with some compilers,
//  so for each parameter declaration there are multiple versions:
//  cc       closed lower bound, closed upper bound
//  co       closed lower bound, open   upper bound
//  cz       closed lower bound of zero (no upper bound)
//  oc       open   lower bound, closed upper bound
//  oo       open   lower bound, open   upper bound
//  oz       open   lower bound of zero (no upper bound)
//  nb       no bounds
//  sw       switch (integer only, values  0=false  and >0=true)
//  ty       switch (integer only, values -1=n-type and +1=p-type)
//
// `define ALIAS(alias,paramName) aliasparam alias = paramName;
`define OPP(nam,uni,des)               (*units=uni,                             desc=des*)           real    nam;
`define OPM(nam,uni,des)               (*units=uni, multiplicity="multiply",    desc=des*)           real    nam;
`define OPD(nam,uni,des)               (*units=uni, multiplicity="divide",      desc=des*)           real    nam;
`define MPRcc(nam,def,uni,lwr,upr,des) (*units=uni                            , desc=des*) parameter real    nam=def from[lwr:upr];
`define MPRco(nam,def,uni,lwr,upr,des) (*units=uni                            , desc=des*) parameter real    nam=def from[lwr:upr);
`define MPRcz(nam,def,uni,        des) (*units=uni                            , desc=des*) parameter real    nam=def from[  0:inf);
// `define MPRoc(nam,def,uni,lwr,upr,des) (*units=uni                            , desc=des*) parameter real    nam=def from(lwr:upr];
`define MPRoo(nam,def,uni,lwr,upr,des) (*units=uni                            , desc=des*) parameter real    nam=def from(lwr:upr);
// `define MPRoz(nam,def,uni,        des) (*units=uni                            , desc=des*) parameter real    nam=def from(  0:inf);
`define MPRnb(nam,def,uni,        des) (*units=uni                            , desc=des*) parameter real    nam=def;
`define MPIcc(nam,def,uni,lwr,upr,des) (*units=uni                            , desc=des*) parameter integer nam=def from[lwr:upr];
// `define MPIco(nam,def,uni,lwr,upr,des) (*units=uni                            , desc=des*) parameter integer nam=def from[lwr:upr);
// `define MPIcz(nam,def,uni,        des) (*units=uni                            , desc=des*) parameter integer nam=def from[  0:inf);
// `define MPIoc(nam,def,uni,lwr,upr,des) (*units=uni                            , desc=des*) parameter integer nam=def from(lwr:upr];
// `define MPIoo(nam,def,uni,lwr,upr,des) (*units=uni                            , desc=des*) parameter integer nam=def from(lwr:upr);
// `define MPIoz(nam,def,uni,        des) (*units=uni                            , desc=des*) parameter integer nam=def from(  0:inf);
// `define MPInb(nam,def,uni,        des) (*units=uni                            , desc=des*) parameter integer nam=def;
// `define MPIsw(nam,def,uni,        des) (*units=uni                            , desc=des*) parameter integer nam=def from[  0:inf);
`define MPIty(nam,def,uni,        des) (*units=uni                            , desc=des*) parameter integer nam=def from[ -1:  1] exclude 0;
// `define IPRcc(nam,def,uni,lwr,upr,des) (*units=uni, type="instance",            desc=des*) parameter real    nam=def from[lwr:upr];
`define IPRco(nam,def,uni,lwr,upr,des) (*units=uni, type="instance",            desc=des*) parameter real    nam=def from[lwr:upr);
`define IPRcz(nam,def,uni,        des) (*units=uni, type="instance",            desc=des*) parameter real    nam=def from[  0:inf);
// `define IPRoc(nam,def,uni,lwr,upr,des) (*units=uni, type="instance",            desc=des*) parameter real    nam=def from(lwr:upr];
// `define IPRoo(nam,def,uni,lwr,upr,des) (*units=uni, type="instance",            desc=des*) parameter real    nam=def from(lwr:upr);
// `define IPRoz(nam,def,uni,        des) (*units=uni, type="instance",            desc=des*) parameter real    nam=def from(  0:inf);
`define IPRnb(nam,def,uni,        des) (*units=uni, type="instance",            desc=des*) parameter real    nam=def;
`define IPIcc(nam,def,uni,lwr,upr,des) (*units=uni, type="instance",            desc=des*) parameter integer nam=def from[lwr:upr];
`define IPIco(nam,def,uni,lwr,upr,des) (*units=uni, type="instance",            desc=des*) parameter integer nam=def from[lwr:upr);
`define IPIcz(nam,def,uni,        des) (*units=uni, type="instance",            desc=des*) parameter integer nam=def from[  0:inf);
// `define IPIoc(nam,def,uni,lwr,upr,des) (*units=uni, type="instance",            desc=des*) parameter integer nam=def from(lwr:upr];
// `define IPIoo(nam,def,uni,lwr,upr,des) (*units=uni, type="instance",            desc=des*) parameter integer nam=def from(lwr:upr);
// `define IPIoz(nam,def,uni,        des) (*units=uni, type="instance",            desc=des*) parameter integer nam=def from(  0:inf);
// `define IPInb(nam,def,uni,        des) (*units=uni, type="instance",            desc=des*) parameter integer nam=def;
// `define IPIsw(nam,def,uni,        des) (*units=uni, type="instance",            desc=des*) parameter integer nam=def from[  0:inf);

//  Function for parameter definition in the case of separate calculation of charge model
`define DefACparam(param_i,param_dc,param_ac) \
    param_i =  (param_dc); \
    if ($param_given(param_ac) == 1) \
        param_i =  (param_ac);

// Mathematical function for surface potential calculation
`define sigma2(a, b, c, tau, eta, y) \
    nu          =  (a) + (c); \
    mutau       =  nu * nu + (tau) * (0.5 * (c) * (c) - (a) * (b)); \
    y           =  (eta) + (a) * nu * (tau) / (mutau + nu / mutau * (tau) * (tau) * (c) * ((c) * (c) * `INV3 - (a) * (b)));

`define sigma3(a, c, tau, eta, y) \
    nu          =  (a) + (c); \
    mutau       =  nu * nu + (tau) * (0.5 * (c) * (c) - (a)); \
    y           =  (eta) + (a) * nu * (tau) / (mutau + nu / mutau * (tau) * (tau) * (c) * ((c) * (c) * `INV3 - a));

// Internal variables used in the surface potentials and inversion charge calculation routines
`define QcalcLocalVarDecl \
    real q_temp1, q_temp2, q_temp3, q_x1sat, q_x2sat, q_x1_WI, q_x2_WI, q_x1, q_x2, q_k1q1, q_Aexp, q_qsq, q_d1_qsq; \
    real q_d2_qsq, q_rac_qsq, q_qcoth, q_d1_qcoth, q_invexpq, q_d2_qcoth, q_sh_term, q_ln_term, q_d1_ln, q_d2_ln; \
    real q_expnum, q_d1_expnum, q_d2_expnum, q_lnexpnum, q_d1_lnexpnum, q_d2_lnexpnum, q_q2_int, q_d1_q2, q_d2_q2, q_qi_int; \
    real q_d1_qi, q_d2_qi, q_zero, q_d1_zero, q_d2_zero, q_eps2, q_k2q2, q_a, q_b, q_c, q_disc, q_delta, q_dx1, q_temp;

// Initial guess on surface potentials and gate charges
`define init_q(xg1_i, xg2_i, delta_n, q1, q2) \
    q_temp1     =  1.0 / (k1 + 1.0); \
    q_temp2     =  1.0 / (k2 + 1.0); \
    q_x1sat     =  ln((k1 + k2 * q_temp2) * diff_min / A0) + delta_n + 3.0; \
    q_x2sat     =  ln((k2 + k1 * q_temp1) * diff_min / A0) + delta_n + 3.0; \
    `ln_one_plus_exp((q_x1sat - x1_WI0) * `INV3, q_temp3) \
    q_x1        =  q_x1sat - 3.0 * q_temp3; \
    `ln_one_plus_exp((q_x2sat - x2_WI0) * `INV3, q_temp3) \
    q_x2        =  q_x2sat - 3.0 * q_temp3; \
    q_x1_WI     =  (k1 * xg1_i + q_x2) * q_temp1; \
    q_x2_WI     =  (k2 * xg2_i + q_x1) * q_temp2; \
    `ln_one_plus_exp((q_x1sat - q_x1_WI) * `INV3, q_temp3) \
    q_x1        =  q_x1sat - 3.0 * q_temp3; \
    `ln_one_plus_exp((q_x2sat - q_x2_WI) * `INV3, q_temp3) \
    q_x2        =  q_x2sat - 3.0 * q_temp3; \
    q1          =  xg1_i - q_x1; \
    q2          =  xg2_i - q_x2; \
    q_rac_qsq   =  0.0; \
    q_invexpq   =  0.0;

// Global correction on front gate charge by 2nd order Taylor dvpt of resolution function
`define corr_global_q(xg1_i, xg2_i, delta_n, q1, q_eps2) \
    q_k1q1      =  k1 * q1; \
    `linmax_exp(xg1_i - q1 - delta_n, q_temp1) \
    q_Aexp      =  A0 * q_temp1; \
    q_qsq       =  q_k1q1 * q_k1q1 - q_Aexp; \
    q_d1_qsq    =  2.0 * k1 * q_k1q1 + q_Aexp; \
    q_d2_qsq    =  2.0 * k1 * k1 - q_Aexp; \
    if (q_qsq < -0.005) begin \
        q_rac_qsq   =  sqrt(abs(q_qsq)); \
        q_qcoth     =  q_rac_qsq / tan(0.5 * q_rac_qsq); \
        q_temp1     =  0.25 * q_d1_qsq / q_qsq; \
        q_d1_qcoth  =  (q_qsq + q_qcoth * (2.0 - q_qcoth)) * q_temp1; \
        q_d2_qcoth  =  (q_d1_qsq - 2.0 * q_d1_qcoth * (1.0 + q_qcoth)) * q_temp1 + q_d1_qcoth * q_d2_qsq / q_d1_qsq; \
        q_temp2     =  1.0 - 0.5 * q_qcoth; \
        q_d1_ln     =  q_d1_qsq / q_qsq * q_temp2; \
        q_d2_ln     =  (q_d2_qsq * q_temp2 - q_d1_qsq * (q_d1_ln + 0.5 * q_d1_qcoth)) / q_qsq; \
    end else begin \
        if (q_qsq > 0.005) begin \
            q_rac_qsq   =  sqrt(abs(q_qsq)); \
            q_invexpq   =  exp(-q_rac_qsq); \
            q_qcoth     =  q_rac_qsq * (1.0 + q_invexpq) / (1.0 - q_invexpq); \
            q_temp1     =  0.25 * q_d1_qsq / q_qsq; \
            q_d1_qcoth  =  (q_qsq + q_qcoth * (2.0 - q_qcoth)) * q_temp1; \
            q_d2_qcoth  =  (q_d1_qsq - 2.0 * q_d1_qcoth * (1.0 + q_qcoth)) * q_temp1 + q_d1_qcoth * q_d2_qsq / q_d1_qsq; \
            q_temp2     =  1.0 - 0.5 * q_qcoth; \
            q_d1_ln     =  q_d1_qsq / q_qsq * q_temp2; \
            q_d2_ln     =  (q_d2_qsq * q_temp2 - q_d1_qsq * (q_d1_ln + 0.5 * q_d1_qcoth)) / q_qsq; \
        end else begin \
            q_temp3     = `INV6 * (1.0 - q_qsq * `INV60 * (1.0 - q_qsq * `INV42 * (1.0 - q_qsq * 0.025))); \
            q_qcoth     =  2.0 + q_qsq * q_temp3; \
            q_temp1     = `INV6 * (1.0 - q_qsq * `INV30 * (1.0 - q_qsq * `INV28 * (1.0 - q_qsq * `INV30))); \
            q_d1_qcoth  =  q_d1_qsq * q_temp1; \
            q_temp2     = `INV180 * (1.0 - q_qsq * `INV14 * (1.0 - 0.05 * q_qsq * (1.0 - 0.0420875420875421 * q_qsq))); \
            q_d2_qcoth  =  q_d2_qsq * q_temp1 - q_d1_qsq * q_d1_qsq * q_temp2; \
            q_d1_ln     = -0.5 * q_d1_qsq * q_temp3; \
            q_d2_ln     = -0.5 * q_d2_qsq * q_temp3 + 0.25 * `INV180 * q_d1_qsq * q_d1_qsq * (1.0 - q_qsq * `INV42 * (2.0 - 0.075 * q_qsq)); \
        end \
    end \
    if (q_qsq > 0.005) begin \
        q_temp2     =  4.0 * q_qsq / (1.0 - q_invexpq * (2.0 - q_invexpq)); \
        q_sh_term   =  q_temp2 * q_invexpq; \
        q_ln_term   =  ln(q_temp2) - q_rac_qsq; \
    end else begin \
        if (q_qsq < -0.005) begin \
            q_temp2     =  sin(0.5 * q_rac_qsq); \
            q_sh_term   = -q_qsq / (q_temp2 * q_temp2); \
            q_ln_term   =  ln(q_sh_term); \
        end else begin \
            q_sh_term   =  4.0 - q_qsq * `INV3 * (1.0 - 0.05 * q_qsq * (1.0 - 0.0396825396825397 * q_qsq)); \
            q_ln_term   =  ln(q_sh_term); \
        end \
    end \
    if (1.01 * q_k1q1 + q_qcoth > 0.0) begin \
        q_expnum    =  q_k1q1 + q_qcoth; \
        q_d1_expnum =  k1 + q_d1_qcoth; \
        q_d2_expnum =  q_d2_qcoth; \
    end else begin \
        q_temp2     =  1.0 / (q_k1q1 - q_qcoth); \
        q_temp3     =  q_d1_qcoth - k1; \
        q_expnum    =  (q_Aexp - q_sh_term) * q_temp2; \
        q_d1_expnum =  (q_temp3 * q_expnum - q_Aexp - q_d1_ln * q_sh_term) * q_temp2; \
        q_d2_expnum =  (q_d2_qcoth * q_expnum + 2.0 * q_temp3 * q_d1_expnum + q_Aexp - (q_d2_ln + q_d1_ln * q_d1_ln) * q_sh_term) * q_temp2; \
    end \
    if (q_expnum > 0.0) begin \
        q_lnexpnum  =  ln(q_expnum); \
        q_temp1     =  1.0 / q_expnum; \
        q_d1_lnexpnum =  q_d1_expnum * q_temp1; \
        q_d2_lnexpnum =  q_d2_expnum * q_temp1 - q_d1_lnexpnum * q_d1_lnexpnum; \
    end else begin \
        q_lnexpnum  =  q_k1q1 + `LN2 + ln(-q_k1q1); \
        q_temp1     =  1.0 / q1; \
        q_d1_lnexpnum =  k1 + q_temp1; \
        q_d2_lnexpnum = -q_temp1 * q_temp1; \
    end \
    q_q2_int    =  xg2_i - xg1_i + q1 + 2.0 * q_lnexpnum - q_ln_term; \
    q_d1_q2     =  1.0 + 2.0 * q_d1_lnexpnum - q_d1_ln; \
    q_d2_q2     =  2.0 * q_d2_lnexpnum - q_d2_ln; \
    q_qi_int    =  q_k1q1 + k2 * q_q2_int; \
    q_d1_qi     =  k1 + k2 * q_d1_q2; \
    q_d2_qi     =  k2 * q_d2_q2; \
    q_zero      =  q_qi_int * q_expnum - q_Aexp; \
    q_d1_zero   =  q_d1_qi * q_expnum + q_qi_int * q_d1_expnum + q_Aexp; \
    q_d2_zero   =  q_d2_qi * q_expnum + 2.0 * q_d1_qi * q_d1_expnum + q_qi_int * q_d2_expnum - q_Aexp; \
    q_temp      =  q_d1_zero * q_d1_zero - 0.5 * q_zero * q_d2_zero; \
    q_eps2      =  -q_zero * q_d1_zero * q_temp / (q_temp * q_temp + 1e-200); \
    q1          =  q1 + q_eps2;

// First strong inversion correction on front gate charge from
// 1st order Taylor dvpt of first Poisson integral at front interface side
`define corr_str_inv1(xg1_i, delta_n, q1, q2) \
    q_k1q1      =  k1 * q1; \
    q_k2q2      =  k2 * q2; \
    q_qi_int    =  q_k1q1 + q_k2q2; \
    q_a         =  1.0 + 0.065345483024 * q_qi_int; \
    q_b         =  39.478417604 + 8.5797362674 * q_qi_int + q_k1q1 * q_k2q2; \
    q_c         =  39.478417604 * (2.0 * q_qi_int + q_k1q1 * q_k2q2); \
    q_disc      =  sqrt(q_b * q_b - 4.0 * q_a * q_c); \
    q_qsq       =  (q_disc - q_b) / (2.0 * q_a); \
    q_delta     =  q_k1q1 * q_k1q1 - q_qsq; \
    if (q_delta > 0.0) begin \
        q_zero      =  q_delta * (ln(q_delta / A0) + delta_n - xg1_i + q1); \
        q_d1_zero   =  2.0 * k1 * q_k1q1 + q_delta; \
        q_dx1       =  xg1_i - q1 - q_x1sat; \
        if (((q_zero < 0.0) && (q_d1_zero > 0.0) && (q_dx1 + `LN10 + ln(k1) > 0.0)) || (q_dx1 > 1.0)) begin \
            q1          =  q1 - q_zero / q_d1_zero; \
        end \
    end

// Second strong inversion correction on front gate charge from
// 1st order Taylor dvpt of first Poisson integral at front interface side
`define corr_str_inv2(xg1_i, delta_n, q1, q2) \
    q_k1q1      =  k1 * q1; \
    q_k2q2      =  k2 * q2; \
    q_qi_int    =  q_k1q1 + q_k2q2; \
    q_a         =  1.0 + 0.065345483024 * q_qi_int; \
    q_b         =  39.478417604 + 8.5797362674 * q_qi_int + q_k1q1 * q_k2q2; \
    q_c         =  39.478417604 * (2.0 * q_qi_int + q_k1q1 * q_k2q2); \
    q_disc      =  sqrt(q_b * q_b - 4.0 * q_a * q_c); \
    q_qsq       =  (q_disc - q_b) / (2.0 * q_a); \
    if (q_qsq < -0.005) begin \
        q_rac_qsq   =  sqrt(abs(q_qsq)); \
        q_qcoth     =  q_rac_qsq / tan(0.5 * q_rac_qsq); \
        q_d1_qcoth  =  0.25 * (q_qsq + q_qcoth * (2.0 - q_qcoth)) / q_qsq; \
    end else begin \
        if (q_qsq > 0.005) begin \
            q_rac_qsq   =  sqrt(abs(q_qsq)); \
            q_invexpq   =  exp(-q_rac_qsq); \
            q_qcoth     =  q_rac_qsq * (1.0 + q_invexpq) / (1.0 - q_invexpq); \
            q_d1_qcoth  =  0.25 * (q_qsq + q_qcoth * (2.0 - q_qcoth)) / q_qsq; \
        end else begin \
            q_qcoth     =  2.0 + q_qsq * `INV6 * (1.0 - q_qsq * `INV60 * (1.0 - q_qsq * `INV42)); \
            q_d1_qcoth  = `INV6 * (1.0 - q_qsq * `INV30 * (1.0 - q_qsq * `INV28 * (1.0 - q_qsq * `INV30))); \
        end \
    end \
    q_qsq       =  q_qsq - (q_qi_int * q_qcoth + q_k1q1 * q_k2q2 + q_qsq) / (q_qi_int * q_d1_qcoth + 1.0); \
    q_delta     =  q_k1q1 * q_k1q1 - q_qsq; \
    if (q_delta > 0.0) begin \
        q_zero      =  q_delta * (ln(q_delta / A0) + delta_n - xg1_i + q1); \
        q_d1_zero   =  2.0 * k1 * q_k1q1 + q_delta; \
        q_dx1       =  xg1_i - q1 - q_x1sat; \
        if (((q_zero < 0.0) && (q_d1_zero > 0.0) && (q_dx1 + `LN10 + ln(k1) > 0.0)) || (q_dx1 > 1.0)) begin \
            q1          =  q1 - q_zero / q_d1_zero; \
        end \
    end

//  Front gate charge calculation for a quasi-Fermi level delta_n.phit
`define func_q(xg1_i, xg2_i, delta_n, q1, q2) \
    `init_q(xg1_i, xg2_i, delta_n, q1, q2) \
    `corr_global_q(xg1_i, xg2_i, delta_n, q1, q_eps2) \
    `corr_str_inv1(xg1_i, delta_n, q1, q2) \
    `corr_str_inv2(xg1_i, delta_n, q1, q2) \
    `corr_global_q(xg1_i, xg2_i, delta_n, q1, q_eps2) \
    `corr_global_q(xg1_i, xg2_i, delta_n, q1, q_eps2) \
    if (SWCRYO == 1) begin \
        if (abs(q_eps2) > 0.01) begin \
            `corr_global_q(xg1_i, xg2_i, delta_n, q1, q_eps2) \
        end \
    end

//  Inversion charge calculation for a quasi-Fermi level delta_n.phit
`define func_qi(xg1_i, xg2_i, delta_n, q1, q2, qi, k1q1, k2q2, qsq, Aexp1, Aexp2) \
    k1q1        =  k1 * q1; \
    `linmax_exp(xg1_i - q1 - delta_n, q_temp1) \
    Aexp1       =  A0 * q_temp1; \
    qsq         =  k1q1 * k1q1 - Aexp1; \
    if (Aexp1 <= 0.0) begin \
        qi          =  1.0e-80; \
        k2q2        =  qi - k1q1; \
        q2          =  k2q2 / k2; \
    end else begin \
        if (qsq < -0.005) begin \
            q_rac_qsq   =  sqrt(abs(qsq)); \
            q_qcoth     =  q_rac_qsq / tan(0.5 * q_rac_qsq); \
        end else begin \
            if (qsq > 0.005) begin \
                q_rac_qsq   =  sqrt(abs(qsq)); \
                q_invexpq   =  exp(-q_rac_qsq); \
                q_qcoth     =  q_rac_qsq * (1.0 + q_invexpq) / (1.0 - q_invexpq); \
            end else begin \
                q_qcoth     =  2.0 + qsq * `INV6 * (1.0 - qsq * `INV60 * (1.0 - qsq * `INV42)); \
            end \
        end \
        if (1.01 * k1q1 + q_qcoth > 0.0) begin \
            q_temp1     =  k1q1 + q_qcoth; \
            if (Aexp1 * k1q1 < 0.9 * k1q1 * k1q1 * q_temp1) begin \
                qi          =  Aexp1 / q_temp1 + 1.0e-80; \
                k2q2        =  qi - k1q1; \
                q2          =  k2q2 / k2; \
            end else begin \
                if (qsq > 0.005) begin \
                    q_temp2     =  ln(4.0 * qsq / (1.0 - q_invexpq * (2.0 - q_invexpq))) - q_rac_qsq; \
                end else begin \
                    if (qsq < -0.005) begin \
                        q_temp3     =  sin(0.5 * q_rac_qsq); \
                        q_temp2     =  ln(-qsq / (q_temp3 * q_temp3)); \
                    end else begin \
                        q_temp2     =  ln(4.0 - qsq * `INV3 * (1.0 - 0.05 * qsq * (1.0 - 0.0396825396825397 * qsq))); \
                    end \
                end \
                q2          =  xg2_i - xg1_i + q1 + 2.0 * ln(q_temp1) - q_temp2; \
                k2q2        =  k2 * q2; \
                qi          =  k1q1 + k2q2; \
            end \
        end else begin \
            if (qsq > 0.005) begin \
                `linmax_exp(q1 + delta_n - xg1_i - q_rac_qsq, q_temp3) \
                q_temp2     =  q_temp3 / A0; \
                q_temp1     =  4.0 * qsq * q_temp2 / (1.0 - q_invexpq * (2.0 - q_invexpq)); \
            end else begin \
                if (qsq < -0.005) begin \
                    q_temp2     =  sin(0.5 * q_rac_qsq); \
                    q_temp1     = -qsq / (q_temp2 * q_temp2) / Aexp1; \
                end else begin \
                    q_temp1     =  (4.0 - qsq * `INV3 * (1.0 - 0.05 * qsq * (1.0 - 0.0396825396825397 * qsq))) / Aexp1; \
                end \
            end \
            qi          =  (k1q1  - q_qcoth) / (1.0 - q_temp1) + 1.0e-80; \
            k2q2        =  qi - k1q1; \
            q2          =  k2q2 / k2; \
        end \
    end \
    `linmax_exp(xg2_i - q2 - delta_n, q_temp1) \
    Aexp2       =  A0 * q_temp1;

// Initial guess on surface potentials for substrate depletion
`define init_approx(xg1_i, xg2_i, delta_n, q_x2, smooth) \
    q_temp1     =  1.0 / (k1_1D + 1.0); \
    q_temp2     =  1.0 / (k2_1D + 1.0); \
    q_x1sat     =  ln((k1_1D + k2_1D * q_temp2) * diff_min / A0) + delta_n + smooth; \
    q_x2sat     =  ln((k2_1D + k1_1D * q_temp1) * diff_min / A0) + delta_n + smooth; \
    `ln_one_plus_exp((q_x1sat - x1_WI0) / smooth, q_temp3) \
    q_x1        =  q_x1sat - smooth * q_temp3; \
    q_x2_WI     =  (k2_1D * xg2_i + q_x1) * q_temp2; \
    `ln_one_plus_exp((q_x2sat - q_x2_WI) / smooth, q_temp3) \
    q_x2        =  q_x2sat - smooth * q_temp3;

//  Substrate surface potential calculation
`define SPSUBcalcLocalVarDecl \
    real nu, mutau; \
    real SPSUB_temp, SPSUB_temp1, SPSUB_temp2, SPSUB_xgb, SPSUB_delta, SPSUB_yg, SPSUB_ysub, SPSUB_eta, SPSUB_a, SPSUB_b; \
    real SPSUB_c, SPSUB_tau, SPSUB_y0, SPSUB_delta0, SPSUB_delta1, SPSUB_xi0, SPSUB_xi1, SPSUB_xi2, SPSUB_pC, SPSUB_qC; \
    real SPSUB_xg1, SPSUB_A_fac, SPSUB_xbar, SPSUB_w, SPSUB_x1, SPSUB_bx, SPSUB_x0;

`define spsub(spsub, xg1_i, xg2_i, xn_i) \
    SPSUB_xgb   =  xg1_i - xg2_i; \
    `lin_exp((-xn_i),SPSUB_delta) \
    if (abs(SPSUB_xgb) <= margin_sub) begin \
        SPSUB_temp1 =  inv_xisub * inv_xisub * `INV6 / `SQRT2; \
        spsub       =  SPSUB_xgb * inv_xisub * (1.0 + SPSUB_xgb * (1.0 - SPSUB_delta) * Gfsub * SPSUB_temp1); \
    end else begin \
        if (SPSUB_xgb < -margin_sub) begin \
            SPSUB_yg    = -SPSUB_xgb; \
            SPSUB_ysub  =  1.25 * (SPSUB_yg * inv_xisub); \
            SPSUB_eta   =  0.5 * (SPSUB_ysub + 10.0 - sqrt((SPSUB_ysub - 6.0) * (SPSUB_ysub - 6.0) + 64.0)); \
            SPSUB_temp  =  SPSUB_yg - SPSUB_eta; \
            SPSUB_a     =  SPSUB_temp * SPSUB_temp + Gfsub2 * (SPSUB_eta + 1.0); \
            SPSUB_c     =  2.0 * SPSUB_temp - Gfsub2; \
            SPSUB_tau   = -SPSUB_eta + ln(SPSUB_a * inv_Gfsub2); \
            `sigma3(SPSUB_a, SPSUB_c, SPSUB_tau, SPSUB_eta, SPSUB_y0) \
            `linmax_exp(SPSUB_y0, SPSUB_delta0) \
            SPSUB_delta1 =  1.0 / SPSUB_delta0; \
            SPSUB_temp  =  1.0 / (2.0 + SPSUB_y0 * SPSUB_y0); \
            SPSUB_xi0   =  SPSUB_y0 * SPSUB_y0 * SPSUB_temp; \
            SPSUB_xi1   =  4.0 * (SPSUB_y0 * SPSUB_temp * SPSUB_temp); \
            SPSUB_xi2   =  (8.0 * SPSUB_temp - 12.0 * SPSUB_xi0) * SPSUB_temp * SPSUB_temp; \
            SPSUB_temp  =  SPSUB_yg - SPSUB_y0; \
            SPSUB_temp1 =  SPSUB_delta * SPSUB_delta1; \
            SPSUB_pC    =  2.0 * SPSUB_temp + Gfsub2 * (SPSUB_delta0 - 1.0 - SPSUB_temp1 + SPSUB_delta * (1.0 - SPSUB_xi1)); \
            SPSUB_qC    =  SPSUB_temp * SPSUB_temp - Gfsub2 * (SPSUB_delta0 - SPSUB_y0 - 1.0 + SPSUB_temp1 + SPSUB_delta * (SPSUB_y0 - 1.0 - SPSUB_xi0)); \
            SPSUB_temp  =  2.0 - Gfsub2 * (SPSUB_delta0 + SPSUB_temp1 - SPSUB_delta * SPSUB_xi2); \
            SPSUB_temp  =  SPSUB_pC * SPSUB_pC - 2.0 * (SPSUB_qC * SPSUB_temp); \
            spsub       = -SPSUB_y0 - 2.0 * (SPSUB_qC / (SPSUB_pC + sqrt(SPSUB_temp))); \
        end else begin \
            SPSUB_xg1   =  1.0 / (1.25 + Gfsub * 0.732464877560822); \
            SPSUB_A_fac =  (1.25 * xisub * SPSUB_xg1 - 1.0) * SPSUB_xg1; \
            SPSUB_xbar  =  SPSUB_xgb * inv_xisub * (1.0 + SPSUB_A_fac * SPSUB_xgb); \
            `linmin_exp((-SPSUB_xbar), SPSUB_temp) \
            SPSUB_w     =  1.0 - SPSUB_temp; \
            SPSUB_x1    =  SPSUB_xgb + Gfsub2 * 0.5 - Gfsub * sqrt(SPSUB_xgb + Gfsub2 * 0.25 - SPSUB_w); \
            SPSUB_bx    =  xn_i + 3.0; \
            SPSUB_eta   = `MIN_FUNC(SPSUB_x1, SPSUB_bx, 5.0) - 0.5 * (SPSUB_bx - sqrt(SPSUB_bx * SPSUB_bx + 5.0)); \
            SPSUB_temp  =  SPSUB_xgb - SPSUB_eta; \
            SPSUB_temp1 =  exp(-SPSUB_eta); \
            SPSUB_temp2 =  1.0 / (2.0 + SPSUB_eta * SPSUB_eta); \
            SPSUB_xi0   =  SPSUB_eta * SPSUB_eta * SPSUB_temp2; \
            SPSUB_xi1   =  4.0 * (SPSUB_eta * SPSUB_temp2 * SPSUB_temp2); \
            SPSUB_xi2   =  (8.0 * SPSUB_temp2 - 12.0 * SPSUB_xi0) * SPSUB_temp2 * SPSUB_temp2; \
            SPSUB_a     =  max(1.0e-40, SPSUB_temp * SPSUB_temp - Gfsub2 * (SPSUB_temp1 + SPSUB_eta - 1.0 - SPSUB_delta * (SPSUB_eta + 1.0 + SPSUB_xi0))); \
            SPSUB_b     =  1.0 - 0.5 * (Gfsub2 * (SPSUB_temp1 - SPSUB_delta * SPSUB_xi2)); \
            SPSUB_c     =  2.0 * SPSUB_temp + Gfsub2 * (1.0 - SPSUB_temp1 - (SPSUB_delta) * (1.0 + SPSUB_xi1)); \
            SPSUB_tau   =  xn_i - SPSUB_eta + ln(SPSUB_a / Gfsub2); \
            `sigma2(SPSUB_a, SPSUB_b, SPSUB_c, SPSUB_tau, SPSUB_eta, SPSUB_x0) \
            if (SPSUB_x0 < `EXP_THRESHOLD) begin \
                SPSUB_delta0 =  exp(SPSUB_x0); \
                SPSUB_delta1 =  1.0 / SPSUB_delta0; \
                SPSUB_delta0 =  SPSUB_delta * SPSUB_delta0; \
            end else begin \
                if (SPSUB_x0 > (xn_i - `EXP_THRESHOLD)) begin \
                    SPSUB_delta0 =  exp(SPSUB_x0 - xn_i); \
                    SPSUB_delta1 =  SPSUB_delta / SPSUB_delta0; \
                end else begin \
                    SPSUB_delta0 = `MIN_EXP / `dev3_exp(xn_i - SPSUB_x0 - `EXP_THRESHOLD); \
                    SPSUB_delta1 = `MIN_EXP / `dev3_exp(SPSUB_x0 - `EXP_THRESHOLD); \
                end \
            end \
            SPSUB_temp  =  1.0 / (2.0 + SPSUB_x0 * SPSUB_x0); \
            SPSUB_xi0   =  SPSUB_x0 * SPSUB_x0 * SPSUB_temp; \
            SPSUB_xi1   =  4.0 * (SPSUB_x0 * SPSUB_temp * SPSUB_temp); \
            SPSUB_xi2   =  (8.0 * SPSUB_temp - 12.0 * SPSUB_xi0) * SPSUB_temp * SPSUB_temp; \
            SPSUB_temp  =  SPSUB_xgb - SPSUB_x0; \
            SPSUB_pC    =  2.0 * SPSUB_temp + Gfsub2 * (1.0 - SPSUB_delta1 + SPSUB_delta0 - SPSUB_delta * (1.0 + SPSUB_xi1)); \
            SPSUB_qC    =  SPSUB_temp * SPSUB_temp - Gfsub2 * (SPSUB_delta1 + SPSUB_x0 - 1.0 + SPSUB_delta0 - SPSUB_delta * (SPSUB_x0 + 1.0 + SPSUB_xi0)); \
            SPSUB_temp  =  2.0 - Gfsub2 * (SPSUB_delta1 + SPSUB_delta0 - SPSUB_delta * SPSUB_xi2); \
            SPSUB_temp  =  SPSUB_pC * SPSUB_pC - 2.0 * (SPSUB_qC * SPSUB_temp); \
            spsub       =  SPSUB_x0 + 2.0 * (SPSUB_qC / (SPSUB_pC + sqrt(SPSUB_temp))); \
        end \
    end

//  Surface potential calculation for the overlap regions for gate currents, GIDL/GISL and overlap capacitances
`define SPOVcalcLocalVarDecl \
    real SP_OV_ygf, SP_OV_z, SP_OV_eta, SP_OV_a, SP_OV_c, SP_OV_tau, SP_OV_nu, SP_OV_mutau, SP_OV_temp; \
    real SP_OV_y0, SP_OV_D0, SP_OV_p, SP_OV_q, SP_OV_xi, SP_OV_w, SP_OV_Afac, SP_OV_xbar, SP_OV_x0, SP_OV_u; \

`define sp_fdsoi_ov(sp,xgf_ov) \
    if (abs(xgf_ov) <= x_mrg_ov) begin \
        sp          = -xgf_ov * inv_xi_ov; \
    end else begin \
        if (xgf_ov < -x_mrg_ov) begin \
            SP_OV_ygf   = -xgf_ov; \
            SP_OV_z     = `X1OV * SP_OV_ygf * inv_xi_ov; \
            SP_OV_eta   =  0.5 * (SP_OV_z + 10.0 - sqrt((SP_OV_z - 6.0) * (SP_OV_z - 6.0) + 64.0)); \
            SP_OV_a     =  (SP_OV_ygf - SP_OV_eta) * (SP_OV_ygf - SP_OV_eta) + GOV2 * (SP_OV_eta + 1.0); \
            SP_OV_c     =  2.0 * (SP_OV_ygf - SP_OV_eta) - GOV2; \
            SP_OV_tau   =  ln(SP_OV_a / GOV2) - SP_OV_eta; \
            SP_OV_nu    =  SP_OV_a + SP_OV_c; \
            SP_OV_mutau =  SP_OV_nu * SP_OV_nu + SP_OV_tau * (0.5 * SP_OV_c * SP_OV_c - SP_OV_a); \
            SP_OV_temp  =  SP_OV_mutau + SP_OV_nu / SP_OV_mutau * SP_OV_tau * SP_OV_tau * SP_OV_c * (SP_OV_c * SP_OV_c * `INV3 - SP_OV_a); \
            SP_OV_y0    =  SP_OV_eta + SP_OV_a * SP_OV_nu * SP_OV_tau / SP_OV_temp; \
            `lin_exp(SP_OV_y0, SP_OV_D0) \
            SP_OV_temp  =  SP_OV_ygf - SP_OV_y0; \
            SP_OV_p     =  2.0 * SP_OV_temp + GOV2 * (SP_OV_D0 - 1.0); \
            SP_OV_q     =  SP_OV_temp * SP_OV_temp + GOV2 * (SP_OV_y0 + 1.0 - SP_OV_D0); \
            SP_OV_xi    =  1.0 - GOV2 * 0.5 * SP_OV_D0; \
            SP_OV_temp  =  SP_OV_p * SP_OV_p - 4.0 * (SP_OV_xi * SP_OV_q); \
            SP_OV_w     =  2.0 * SP_OV_q / (SP_OV_p + sqrt(SP_OV_temp)); \
            sp          = -(SP_OV_y0 + SP_OV_w); \
        end else begin \
            SP_OV_Afac  =  (xi_ov * `X1OV * inv_xg1 - 1.0) * inv_xg1; \
            SP_OV_xbar  =  xgf_ov * inv_xi_ov * (1.0 + SP_OV_Afac * xgf_ov); \
            `lin_exp((-SP_OV_xbar), SP_OV_temp) \
            SP_OV_w     =  1.0 - SP_OV_temp; \
            SP_OV_x0    =  xgf_ov + GOV2 * 0.5 - GOV * sqrt(xgf_ov + GOV2 * 0.25 - SP_OV_w); \
            `lin_exp((-SP_OV_x0), SP_OV_D0) \
            SP_OV_p     =  2.0 * (xgf_ov - SP_OV_x0) + GOV2 * (1 - SP_OV_D0); \
            SP_OV_q     =  (xgf_ov - SP_OV_x0) * (xgf_ov - SP_OV_x0) - GOV2 * (SP_OV_x0 - 1.0 + SP_OV_D0); \
            SP_OV_xi    =  1.0 - GOV2 * 0.5 * SP_OV_D0; \
            SP_OV_temp  =  SP_OV_p * SP_OV_p - 4.0 * (SP_OV_xi * SP_OV_q); \
            SP_OV_u     =  2.0 * SP_OV_q / (SP_OV_p + sqrt(SP_OV_temp)); \
            sp          =  SP_OV_x0 + SP_OV_u; \
        end \
        sp          = -sp; \
    end

// Lambert W function asymptote for surface potential computation
`define Wfunc(a, x, res) \
    if ((x) < `EXP_THRESHOLD) begin \
        w_temp       =  ln(1.0 + (a) * exp(x)); \
        res          =  w_temp * (1.0 - ln(1.0 + w_temp) / (2.0 + w_temp)); \
    end else begin \
        if ((x) < 0.0) begin \
            `linmin_exp(x, w_temp) \
            res       =  (a) * w_temp; \
        end else begin \
            w_temp    =  ln(a) + (x); \
            res          =  w_temp * (1.0 - ln(1.0 + w_temp) / (2.0 + w_temp)); \
        end \
    end

//  Threshold voltage calculation for operating point information
`define vth(VFB1_t, VFB2_t, VFB1_i, PSCE1_i, PSCE2_i, CF1_t, CF2_t, k1, k2, A0, diff_min, xg2x, xg2, xedge, sce1, dxg1_dibl) \
    r1init_op   =  k2 / k1 / (1.0 + k2); \
    r2init_op   =  k1 / k2 / (1.0 + k1); \
    x1init_op   =  ln(k1 * (1.0 + r1init_op) * diff_min / A0) + 2.0; \
    x2init_op   =  ln(k2 * (1.0 + r2init_op) * diff_min / A0) + 2.0; \
    xth1init_op =  (1.0 + r1init_op) * x1init_op - xg2x * r1init_op; \
    xth2init_op =  (1.0 + 1.0 / r2init_op) * x2init_op - xg2x / r2init_op; \
    xg1thinit_op =  (`MIN_FUNC(xth1init_op, xth2init_op, 38.0) - xg2) / CIC1_i + xg2; \
    vthinit_op  =  phit * ((xg1thinit_op - xedge) / sce1 - dxg1_dibl + xedge) + VFB1_i;  \
    temp        =  STCF_i * (TKD - TKR); \
    CF1_op      =  CF1_t + temp; \
    CF2_op      =  CF2_t + temp; \
    temp        =  TYPE * STVFB_i * (TKD - TKR) + dVfbQM; \
    VFB1_op     =  TYPE * (VFB1_t + dVfbch_op + dVfb1Nch) + temp + DELVTO - dVfbpdep_op; \
    VFB2_op     =  TYPE * (VFB2_t + dVfbch_op + dVfb2Nch) + temp; \
    /* Conditioning of terminal voltages for threshold voltage conditions */ \
    xg10_op     =  (vthinit_op - VFB1_op) * inv_phit_op - dxdsx_op; \
    xg20_op     =  (-Vsb - VFB2_op) * inv_phit_op - dxdsx_op; \
    /* Substrate depletion effect at threshold voltage */ \
    if (SWSUBDEP > 0) begin \
        temp        =  TYPE * TYPESUB_i * (xg10_op - xg20_op) / Gfsub; \
        if (temp < 0.0) begin \
            temp1       = -2.0 * ln(1.0 - temp); \
        end else begin \
            temp1       =  temp * temp / (1.0 + 2.0 * temp / Gfsub); \
        end \
        xg2eff_op   =  xg20_op + TYPE * TYPESUB_i * temp1; \
    end else begin \
        xg2eff_op   =  xg20_op; \
    end \
    /* Quantum mechanical corrections below threshold */ \
    temp        =  keq_1D * (xg10_op - xg2eff_op); \
    if (QMC > 0.0) begin \
        e1_op       = `MAX_FUNC(temp, emin, emin * emin); \
        e2_op       = `MAX_FUNC(-temp, emin, emin * emin); \
        temp1       =  qq_op * exp(-`INV3 * ln(e1_op)); \
        temp2       =  qq_op * exp(-`INV3 * ln(e2_op)); \
        temp3       =  1.0 - temp1 - temp2; \
        CsiPrime_op =  CsiPrime_0 / temp3; \
        k1_1D_QM_op =  k1_1D * temp3 / (1.0 + k1_1D * temp1); \
        k2_1D_QM_op =  k2_1D * temp3 / (1.0 + k2_1D * temp2); \
        keq_1D_QM_op = 1.0 / (1.0 + 1.0 / k1_1D_QM_op + 1.0 / k2_1D_QM_op); \
    end else begin \
        CsiPrime_op =  CsiPrime_0; \
        k1_1D_QM_op =  k1_1D; \
        k2_1D_QM_op =  k2_1D; \
        keq_1D_QM_op = keq_1D; \
    end \
    /* Short channel effects */ \
    Dx_WI_1D_op =  keq_1D_QM_op * (xg10_op - xg2eff_op); \
    if (Dx_WI_1D_op > 0.0) begin \
        `ln_one_plus_exp(-Dx_WI_1D_op, temp) \
        x_WI_1D_op  =  xg10_op - Dx_WI_1D_op / k1_1D_QM_op + temp - `LN2; \
    end else begin \
        `ln_one_plus_exp(Dx_WI_1D_op, temp) \
        x_WI_1D_op  =  xg2eff_op + Dx_WI_1D_op / k2_1D_QM_op + temp - `LN2; \
    end \
    x_1D_op     = `MIN_FUNC(x_WI_1D_op, xth_1D_op, 4.0); \
    dleff_op    =  sqrt(1.0 + 2.0 * (xth_1D_op - x_1D_op) / xSDdep_op) - 1.0; \
    xedge_op    =  x_1D_op + xSDdep_op * dleff_op; \
    temp        = `MAX_FUNC(1.0 + PSCEDLB_i * xg20_op, 0.5, 0.01); \
    sce1_op     =  1.0 / (1.0 + PSCE1_i * temp); \
    sce2_op     =  1.0 / (1.0 + PSCE2_i * temp); \
    temp        =  2.0 * xd0_op * (sqrt(1.0 + xdsx_op / xd0_op) - 1.0) * (1.0 + CFDL_i * dleff_op) * (1.0 + CFDLB_i * xg20_op); \
    dxg1_dibl_op =  CF1_op * temp; \
    dxg2_dibl_op =  CF2_op * temp; \
    xg1_op      =  (xg10_op - xedge_op + dxg1_dibl_op) * sce1_op + xedge_op + dxdsx_op; \
    xg2_op      =  (xg2eff_op - xedge_op + dxg2_dibl_op) * sce2_op + xedge_op + dxdsx_op; \
    xg2x_op     =  xg1_op + CIC2_i * (xg2_op - xg1_op); \
    /* Coupling factors at threshold voltage */ \
    k1_op       =  k1_1D_QM_op / sce1_op; \
    k2_op       =  k2_1D_QM_op / sce2_op; \
    A0_op       =  A0_Csisq_op / (CsiPrime_op * CsiPrime_op); \
    exp_dxth_op =  (1.0 + k1_op) / (1.0 + k2_op); \
    dxth_op     =  ln(exp_dxth_op); \
    if (dxth_op > 1.0e-8) begin \
        diff_min_op = 2.0 * dxth_op * (exp_dxth_op + 1.0) / (exp_dxth_op - 1.0); \
    end else begin \
        diff_min_op = 2.0 * (2.0 + dxth_op); \
    end \
    /* Final threshold voltage calculation */ \
    r1_op       =  k2_op / k1_op / (1.0 + k2_op); \
    r2_op       =  k1_op / k2_op / (1.0 + k1_op); \
    x1sat_op    =  ln(k1_op * (1.0 + r1_op) * diff_min_op / A0_op) + 2.0 + Eg_2phit0_op; \
    x2sat_op    =  ln(k2_op * (1.0 + r2_op) * diff_min_op / A0_op) + 2.0 + Eg_2phit0_op; \
    xth1_op     =  (1.0 + r1_op) * x1sat_op - xg2x_op * r1_op; \
    xth2_op     =  (1.0 + 1.0 / r2_op) * x2sat_op - xg2x_op / r2_op; \
    xg1th_op    =  (`MIN_FUNC(xth1_op, xth2_op, 38.0) - xg2_dc) / CIC1_i + xg2_dc; \
    vth_op      =  ((xg1th_op - xedge_op) / sce1_op - dxg1_dibl_op + xedge_op) / inv_phit_op + VFB1_op;

//  Model's core for currents and charges calculation
`define CoreLocalVarDecl \
    `QcalcLocalVarDecl \
    `SPSUBcalcLocalVarDecl \
    real vfb1_loc, vfb2_loc, psce1_loc, psce2_loc, cf1_loc, cf2_loc, sat_phit_loc, gamAX_loc, alp_loc; \
    real xg10, xg20shift, xg20, exp_dxth, dxth, diff_min, A0, inv_k1, inv_k2, x1_WI0, x2_WI0, xg2eff, e1, e2, tox1fact, tox2fact; \
    real k1_1D_QM, k2_1D_QM, keq_1D_QM, Dx_WI_1D, CsiPrime, x_WI_1D, x_1D, dleff, xedge, sce1, sce2, dxg1_dibl, dxg2_dibl, xg1, xg2; \
    real xg1x, xg2x, k1, k2, keq, Dx_WI, Dx_WIsq, q1s, qis, k1q1s, k2q2s, q2s, qsqs, Aexp1s, Aexp2s, b1s, b2s, a1s, a2s, sums; \
    real dqsqs_dxn_qi, xdrifts, esurf1s, esurf2s, ecpl1s, ecpl2s, eeff1s, eeff2s, qi1s, qi2s, c1s, c2s, fcors, Gcss, frscsi, Grss; \
    real Gmob1s, Gmob2s, Gmobs, s1, s2, deltaxinf, q1chapinf, q2chapinf, dinf, inv_dinf, wsat1, sat_fact1, wsat2, sat_fact2; \
    real dqis_dxn_qi, ds, deltaxi, gamma, vs, vd, wd, ps_cub, qs_cub, pd_cub, qd_cub, racs, racd, deltaxsats, deltaxsatd, deltaxsat; \
    real qidsats, qidsatd, qidsat, xndssat, xdeff, q1d, q2d, qid, k1q1d, k2q2d, qsqd, Aexp1d, Aexp2d, b1d, b2d, a1d, a2d, sumd; \
    real dqsqd_dxn_qi, xdriftd, qim, dxdrift, qim_pd, xp_pd, ratio_pd, esurf1d, esurf2d, ecpl1d, ecpl2d, eeff1d, eeff2d, esurf1; \
    real esurf2, qi1m, qi2m, ecpl1, ecpl2, eeff1, eeff2, c1, c2, csum, fcor, Gcs, Grs, Gmob1, Gmob2, Gmob, inv_qimstar1, r1; \
    real dL_L_fact, dL_L, GdL, Ggamma, sqrt_zsat, zsat, vsat_fact, hsat, qmfact1, qmfact2, dqid_dxn_qi, dd, Ls, Ld, Us, Ud, idrift2; \
    real norm_Ids, q1s_chap, q1d_chap, inv_k1h1_0, q2s_chap, q2d_chap, inv_k2h2_0, zeta1, zeta2, ksi1, ksi2, inv_k1h1, inv_k2h2; \
    real delta_k1q1, delta_k2q2, prod1, prod2;

`define QCalculation \
    \
    /* *********** Conditioning of terminal voltages *********** */ \
    xg10       =  (Vgs - vfb1_loc) * inv_phit - dxdsx - Eg_2phit0; \
    xg20shift  =  (-Vsb - vfb2_loc) * inv_phit - dxdsx; \
    xg20       =  xg20shift - Eg_2phit0; \
    \
    /* *********** Substrate depletion effect *********** */ \
    if (SWSUBDEP > 0) begin \
        temp       =  TYPE * TYPESUB_i; \
        exp_dxth   =  (1.0 + k1_1D) / (1.0 + k2_1D); \
        dxth       =  ln(exp_dxth); \
        if (dxth > 1.0e-8) begin \
            diff_min   =  2.0 * dxth * (exp_dxth + 1.0) / (exp_dxth - 1.0); \
        end else begin \
            diff_min   =  2.0 * (2.0 + dxth); \
        end \
        A0         =  A0_Csisq / (CsiPrime_0 * CsiPrime_0); \
        inv_k1     =  1.0 / k1_1D; \
        inv_k2     =  1.0 / k2_1D; \
        keq        =  1.0 / (1.0 + inv_k1 + inv_k2); \
        Dx_WI      =  keq * (xg10 - xg20); \
        x1_WI0     =  xg10 - Dx_WI * inv_k1; \
        x2_WI0     =  xg20 + Dx_WI * inv_k2; \
        `init_approx(xg10, xg20, 0.0, temp0, 1.5) \
        temp1      =  temp * temp0; \
        temp2      =  temp * xg20; \
        `spsub(temp3, temp1, temp2, xn_sub) \
        xg2eff     =  temp * (temp3 + temp2); \
    end else begin \
        xg2eff     =  xg20; \
    end \
    \
    /* *********** Quantum mechanical corrections below threshold *********** */ \
    temp       =  keq_1D * (xg10 - xg2eff); \
    if (QMC > 0.0) begin \
        e1         = `MAX_FUNC(temp, emin, emin * emin); \
        e2         = `MAX_FUNC(-temp, emin, emin * emin); \
        temp1      =  qq * exp(-`INV3 * ln(e1)); \
        temp2      =  qq * exp(-`INV3 * ln(e2)); \
        temp3      =  1.0 - temp1 - temp2; \
        CsiPrime   =  CsiPrime_0 / temp3; \
        tox1fact   =  1.0 + k1_1D * temp1; \
        tox2fact   =  1.0 + k2_1D * temp2; \
        k1_1D_QM   =  k1_1D * temp3 / tox1fact; \
        k2_1D_QM   =  k2_1D * temp3 / tox2fact; \
        keq_1D_QM  =  1.0 / (1.0 + 1.0 / k1_1D_QM + 1.0 / k2_1D_QM); \
        tox1fact   =  1.0 + k1_1D_QM * temp1; \
        tox2fact   =  1.0 + k2_1D_QM * temp2; \
    end else begin \
        CsiPrime   =  CsiPrime_0; \
        k1_1D_QM   =  k1_1D; \
        k2_1D_QM   =  k2_1D; \
        keq_1D_QM  =  keq_1D; \
        tox1fact   =  1.0; \
        tox2fact   =  1.0; \
    end \
    \
    /* *********** Short channel effects *********** */ \
    Dx_WI_1D   =  keq_1D_QM * (xg10 - xg2eff); \
    if (Dx_WI_1D > 0.0) begin \
        `ln_one_plus_exp(-Dx_WI_1D, temp) \
        x_WI_1D    =  xg10 - Dx_WI_1D / k1_1D_QM + temp - `LN2; \
    end else begin \
        `ln_one_plus_exp(Dx_WI_1D, temp) \
        x_WI_1D    =  xg2eff + Dx_WI_1D / k2_1D_QM + temp - `LN2; \
    end \
    x_1D       = `MIN_FUNC(x_WI_1D, xth_1D, 4.0); \
    /* For short channel effects */ \
    dleff      =  sqrt(1.0 + 2.0 * (xth_1D - x_1D) / xSDdep) - 1.0; \
    xedge      =  x_1D + xSDdep * dleff; \
    temp       = `MAX_FUNC(1.0 + PSCEDLB_i * xg20shift, 0.5, 0.01); \
    sce1       =  1.0 / (1.0 + psce1_loc * temp); \
    sce2       =  1.0 / (1.0 + psce2_loc * temp); \
    /* For DIBL */ \
    temp       =  2.0 * xd0 * (sqrt(1.0 + xdsx / xd0) - 1.0) * (1.0 + CFDL_i * dleff) * (1.0 + CFDLB_i * xg20shift); \
    dxg1_dibl  =  cf1_loc * temp; \
    dxg2_dibl  =  cf2_loc * temp; \
    /* For drain current and intrinsic charge models */ \
    xg1        =  (xg10 - xedge + dxg1_dibl) * sce1 + xedge + dxdsx; \
    xg2        =  (xg2eff - xedge + dxg2_dibl) * sce2 + xedge + dxdsx; \
    xg1x       = `MIN_FUNC(xg2 + CIC1_i * (xg1 - xg2), xsatmax, 0.01); \
    xg2x       = `MIN_FUNC(xg1 + CIC2_i * (xg2 - xg1), xsatmax, 0.01); \
    \
    /* *********** Coupling factors *********** */ \
    k1         =  k1_1D_QM / sce1; \
    k2         =  k2_1D_QM / sce2; \
    inv_k1     =  1.0 / k1; \
    inv_k2     =  1.0 / k2; \
    keq        =  1.0 / (1.0 + inv_k1 + inv_k2); \
    A0         =  A0_Csisq / (CsiPrime * CsiPrime); \
    exp_dxth   =  (1.0 + k1) / (1.0 + k2); \
    dxth       =  ln(exp_dxth); \
    if (dxth > 1.0e-8) begin \
        diff_min   =  2.0 * dxth * (exp_dxth + 1.0) / (exp_dxth - 1.0); \
    end else begin \
        diff_min   =  2.0 * (2.0 + dxth); \
    end \
    Dx_WI      =  keq * (xg1x - xg2x); \
    Dx_WIsq    =  Dx_WI * Dx_WI; \
    x1_WI0     =  xg1x - Dx_WI * inv_k1; \
    x2_WI0     =  xg2x + Dx_WI * inv_k2; \
    \
    /* *********** Inversion charge at source side *********** */ \
    `func_q(xg1x, xg2x, 0.0, q1s, q2s) \
    `func_qi(xg1x, xg2x, 0.0, q1s, q2s, qis, k1q1s, k2q2s, qsqs, Aexp1s, Aexp2s) \
    /* Calculation of (dqsq/dxn)/qi and xdrift at source side */ \
    a1s        =  0.0; \
    a2s        =  0.0; \
    b1s        =  0.0; \
    b2s        =  0.0; \
    sums       =  0.0; \
    dqsqs_dxn_qi =  0.0; \
    if (qis > `QI_LOW) begin \
        b1s        =  Aexp1s * inv_k1; \
        b2s        =  Aexp2s * inv_k2; \
        a1s        =  b1s + 2.0 * k1q1s; \
        a2s        =  b2s + 2.0 * k2q2s; \
        sums       =  2.0 * qis + b1s + b2s; \
        if (abs(qsqs) > 0.005) begin \
            temp1      =  a1s * a2s + 2.0 * (q1s + 2.0) * a2s + 2.0 * (q2s + 2.0) * a1s; \
            dqsqs_dxn_qi =  -4.0 * qsqs * sums / (qis * temp1); \
        end else begin \
            temp1      = `INV6 * (1.0 - qsqs * `INV30 * (1.0 - qsqs * `INV28 * (1.0 - qsqs * `INV30))); \
            temp2      =  a1s * Aexp1s + a2s * Aexp2s + a1s * a2s * qis * (1.0 + qis * temp1); \
            dqsqs_dxn_qi =  Aexp1s * Aexp2s * sums / (qis * temp2); \
        end \
    end \
    xdrifts    =  ln(qis); \
    \
    /* *********** Mobility attenuation and series resistance at source side *********** */ \
    `ln_one_plus_exp(k1q1s / `FIELD_SMTH, temp1) \
    esurf1s    = `FIELD_SMTH * temp1; \
    `ln_one_plus_exp(k2q2s / `FIELD_SMTH, temp2) \
    esurf2s    = `FIELD_SMTH * temp2; \
    ecpl1s     =  esurf2s - k2q2s; \
    ecpl2s     =  esurf1s - k1q1s; \
    eeff1s     =  eta_mu * esurf1s + one_m_eta * ecpl1s; \
    eeff2s     =  eta_mu * esurf2s + one_m_eta * ecpl2s; \
    temp       =  qis / (esurf1s + esurf2s); \
    qi1s       =  esurf1s * temp; \
    qi2s       =  esurf2s * temp; \
    c1s        =  esurf1s * BETN1_t * exp(STBET_i * lnrTn); \
    c2s        =  esurf2s * BETN2_t * exp(STBET_i * lnrTn); \
    temp1      =  XCOR_i * (ecpl1s + XCORB_i * ecpl2s); \
    temp2      = `MAX_FUNC(1.0 + temp1, 0.0, 0.01); \
    temp3      = `MAX_FUNC(1.0 + 0.2 * temp1, 0.0, 0.01); \
    fcors      =  temp2 / temp3; \
    Gcss       =  CS_i * (1.0 + CSFI_i * ecpl1s + CSBI_i * ecpl2s) * exp(-THECS_i * ln(1.0 + qi1s * inv_qi1cs + qi2s * inv_qi2cs)); \
    if (RSG_i == 0.0) begin \
        temp3      =  1.0; \
    end else begin \
        if (RSG_i < 0.0) begin \
            temp1      =  RSG_i * exp(THERSG_i * ln(qis + 1.0e-12)); \
            temp3      =  1.0 - temp1; \
        end else begin \
            temp1      =  RSG_i * exp(THERSG_i * ln(qis + 1.0e-12)); \
            temp3      =  1.0 / (1.0 + temp1); \
        end \
    end \
    frscsi     =  frs * CsiPrime * `MAX_FUNC(1.0 - RSB_i * xg20shift, 0.0, 0.01); \
    Grss       =  frscsi * (qis * temp3 + RSIG_i); \
    Gmob1s     =  (1.0 + exp(THEMU_i * ln(fmue * eeff1s + 1.0e-6)) + Gcss + BETN1_i * Grss); \
    Gmob2s     =  (1.0 + exp(THEMU_i * ln(fmue * eeff2s + 1.0e-6)) + Gcss + BETN2_i * Grss); \
    Gmobs      =  fcors * (c1s + c2s) / (c1s / Gmob1s + c2s / Gmob2s); \
    \
    /* *********** Calculation of various quantities at the onset of saturation *********** */ \
    if (abs(Dx_WI) > 0.007) begin \
        if (Dx_WI > 0.0) begin \
            temp       =  exp(-Dx_WI); \
            s1         =  Dx_WI / (1.0 - temp); \
            s2         =  temp * s1; \
            deltaxinf  =  ln(A0 / (qis * s1)) - `LN2 + x1_WI0; \
        end else begin \
            temp       =  exp(Dx_WI); \
            s2         =  Dx_WI / (temp - 1.0); \
            s1         =  temp * s2; \
            deltaxinf  =  ln(A0 / (qis * s2)) - `LN2 + x2_WI0; \
        end \
        q1chapinf  = -Dx_WI / (keq * (1.0 - s1 - Dx_WI * inv_k2)); \
        q2chapinf  =  Dx_WI / (keq * (1.0 - s2 + Dx_WI * inv_k1)); \
        dinf       =  Dx_WI / ((s2 * inv_k2 + 0.5) / q2chapinf - (s1 * inv_k1 + 0.5) / q1chapinf); \
    end else begin \
        temp       =  0.5 * `INV6 * Dx_WIsq; \
        temp1      =  0.5 * Dx_WI; \
        s1         =  1.0 + temp1 + temp; \
        s2         =  1.0 - temp1 + temp; \
        temp2      = `INV6 * temp1; \
        q1chapinf  =  1.0 / (keq * (0.5 + inv_k2 + temp2)); \
        q2chapinf  =  1.0 / (keq * (0.5 + inv_k1 - temp2)); \
        deltaxinf  =  ln(A0 / (qis * (1.0 - 0.5 * temp))) - `LN2 + 0.5 * (x1_WI0 + x2_WI0); \
        dinf       = -12.0 / (4.0 - 3.0 * keq + 12.0 * keq / (k1 * k2) + keq * (inv_k1 - inv_k2) * Dx_WI + `INV3 * (0.2 - 0.25 * keq) * Dx_WIsq); \
    end \
    inv_dinf   =  1.0 / dinf; \
    \
    /* *********** Drain saturation voltage *********** */ \
    if (qis > `QI_LOW) begin \
        /* Front gate bias dependence of velocity saturation */ \
        wsat1      =  100.0 * esurf1s / (100.0 + esurf1s); \
        if (THESAT1_i < 0.0) begin \
            sat_fact1  =  1.0 / (1.0 - THESAT1_i * wsat1); \
        end else begin \
            sat_fact1  =  1.0 + THESAT1_i * wsat1; \
        end \
        /* Back gate bias dependence of velocity saturation */ \
        wsat2      =  100.0 * esurf2s / (100.0 + esurf2s); \
        if (THESAT2_i < 0.0) begin \
            sat_fact2  =  1.0 / (1.0 - THESAT2_i * wsat2); \
        end else begin \
            sat_fact2  =  1.0 + THESAT2_i * wsat2; \
        end \
        /* deltaxsat and qidsat calculation */ \
        dqis_dxn_qi =  dqsqs_dxn_qi * sums / (a1s * a2s) - (Aexp1s / a1s + Aexp2s / a2s) / qis; \
        ds         =  dqis_dxn_qi * qis / (dqis_dxn_qi + 1.0); \
        temp1      =  dinf - ds; \
        deltaxi    =  (qis + dinf * deltaxinf) / temp1; \
        deltaxi    =  0.5 * (deltaxi + sqrt(deltaxi * deltaxi + 1.0e-6)); \
        gamma      =  sat_phit_loc / Gmobs * 0.5 * (sat_fact1 + sat_fact2); \
        vs         =  1.0 - qis / ds; \
        vd         =  1.0 + deltaxinf; \
        wd         =  ((2.0 * ds - qis) * inv_dinf - 2.0 - deltaxinf) * deltaxi; \
        if (gamma > 1.0e-14) begin \
            ps_cub     =  2.0 / (gamma * gamma); \
            qs_cub     =  ps_cub * vs; \
            pd_cub     =  ps_cub + wd; \
            qd_cub     =  ps_cub * vd; \
            racs       =  sqrt(qs_cub * qs_cub + 0.148148148148 * ps_cub * ps_cub * ps_cub + 1.0e-20); \
            racd       =  sqrt(qd_cub * qd_cub + 0.148148148148 * pd_cub * pd_cub * pd_cub + 1.0e-20); \
            deltaxsats =  exp(`INV3 * ln(0.5 * (racs + qs_cub))) - exp(`INV3 * ln(0.5 * (racs - qs_cub))); \
            deltaxsatd =  exp(`INV3 * ln(0.5 * (racd + qd_cub))) - exp(`INV3 * ln(0.5 * (racd - qd_cub))); \
        end else begin \
            deltaxsats =  vs; \
            deltaxsatd =  vd; \
        end \
        temp3      =  temp1 * temp1; \
        deltaxsat  = `SAT_FACT * `MAX_FUNC(deltaxsats, deltaxsatd, 10.0 * temp3); \
        qidsats    =  qis + ds * deltaxsat; \
        qidsatd    =  dinf * (deltaxsat - deltaxinf); \
        qidsat     = `MAX_FUNC(qidsats, qidsatd,`SMTH_SQ * temp3); \
    end else begin \
        ds         =  dinf; \
        deltaxsat  = `SAT_FACT * (1.0 + deltaxinf); \
        qidsat     =  0.5 * qis + dinf * (deltaxsat - 0.5 * deltaxinf); \
    end \
    /* xndssat calculation */ \
    `ln_one_plus_exp(qidsat - `QI_TH, temp1) \
    temp2      =  temp1 + `QI_TH; \
    temp3      =  deltaxsat + ln(qis / temp2); \
    `ln_one_plus_exp(temp3 - `XSAT_MIN, temp1) \
    temp3      =  temp1 + `XSAT_MIN; \
    `ln_one_plus_exp(xsatmax - temp3, temp1) \
    xndssat    =  xsatmax - temp1; \
    \
    /* *********** Effective drain voltage  *********** */ \
    temp1      =  xd / xndssat; \
    temp2      =  temp1 * temp1; \
    temp3      =  temp2 * temp2; \
    temp4      =  temp3 * temp3; \
    temp       =  exp(2.666666666667 * ln(1.0 + gamAX_loc * temp3)); \
    xdeff      =  xd * exp(-0.0625 * ln(temp + temp4 * temp4)); \
    \
    /* *********** Inversion charge at drain side *********** */ \
    `func_q(xg1x, xg2x, xdeff, q1d, q2d) \
    `func_qi(xg1x, xg2x, xdeff, q1d, q2d, qid, k1q1d, k2q2d, qsqd, Aexp1d, Aexp2d) \
    /* Calculation of (dqsq/dxn)/qi and xdrift at drain side */ \
    a1d         =  0.0; \
    a2d         =  0.0; \
    b1d         =  0.0; \
    b2d         =  0.0; \
    sumd        =  0.0; \
    dqsqd_dxn_qi =  0.0; \
    if (qis > `QI_LOW) begin \
        b1d         =  Aexp1d * inv_k1; \
        b2d         =  Aexp2d * inv_k2; \
        a1d         =  b1d + 2.0 * k1q1d; \
        a2d         =  b2d + 2.0 * k2q2d; \
        sumd        =  2.0 * qid + b1d + b2d; \
        if (abs(qsqd) > 0.005) begin \
            temp1       =  a1d * a2d + 2.0 * (q1d + 2.0) * a2d + 2.0 * (q2d + 2.0) * a1d; \
            dqsqd_dxn_qi =  -4.0 * qsqd * sumd / (qid * temp1); \
        end else begin \
            temp1       = `INV6 * (1.0 - qsqd * `INV30 * (1.0 - qsqd * `INV28 * (1.0 - qsqd * `INV30))); \
            temp2       =  a1d * Aexp1d + a2d * Aexp2d + a1d * a2d * qid * (1.0 + qid * temp1); \
            dqsqd_dxn_qi =  Aexp1d * Aexp2d * sumd / (qid * temp2); \
        end \
    end \
    xdriftd     =  xdeff + ln(qid); \
    \
    /* *********** Mid-point inversion charge *********** */ \
    qim         =  0.5 * (qis + qid); \
    dxdrift     =  xdriftd - xdrifts; \
    \
    /* *********** Inclusion of poly-depletion *********** */ \
    ratio_pd    =  1.0; \
    if (SWPDEP > 0) begin \
        qim_pd      =  0.5 * (k1q1s + k1q1d) / k1; \
        qim_pd      =  `MAX_FUNC(qim_pd, 1.0e-5, 1.0); \
        temp0       =  sqrt( qim_pd / inv_phit + 0.25 * KP * KP)- 0.5 * KP; \
        xp_pd       =  pow(temp0, 2.0) * inv_phit; \
        ratio_pd    =  1.0 - xp_pd / qim_pd; \
    end \
    \
    /* *********** Mobility attenuation and series resistance *********** */ \
    `ln_one_plus_exp(k1q1d / `FIELD_SMTH, temp1) \
    esurf1d     = `FIELD_SMTH * temp1; \
    `ln_one_plus_exp(k2q2d / `FIELD_SMTH, temp2) \
    esurf2d     = `FIELD_SMTH * temp2; \
    ecpl1d      =  esurf2d - k2q2d; \
    ecpl2d      =  esurf1d - k1q1d; \
    eeff1d      =  eta_mu * esurf1d + one_m_eta * ecpl1d; \
    eeff2d      =  eta_mu * esurf2d + one_m_eta * ecpl2d; \
    esurf1      =  0.5 * (esurf1s + esurf1d); \
    esurf2      =  0.5 * (esurf2s + esurf2d); \
    temp        =  1.0 / (esurf1 + esurf2); \
    qi1m        =  qim * esurf1 * temp; \
    qi2m        =  qim * esurf2 * temp; \
    ecpl1       =  0.5 * (ecpl1s + ecpl1d); \
    ecpl2       =  0.5 * (ecpl2s + ecpl2d); \
    eeff1       =  0.5 * (eeff1s + eeff1d); \
    eeff2       =  0.5 * (eeff2s + eeff2d); \
    c1          =  esurf1 * BETN1_t * exp(STBET_i * lnrTn) * ratio_pd; \
    c2          =  esurf2 * BETN2_t * exp(STBET_i * lnrTn); \
    csum        =  c1 + c2; \
    temp1       =  XCOR_i * (ecpl1 + XCORB_i * ecpl2); \
    temp2       = `MAX_FUNC(1.0 + temp1, 0.0, 0.01); \
    temp3       = `MAX_FUNC(1.0 + 0.2 * temp1, 0.0, 0.01); \
    fcor        =  temp2 / temp3; \
    Gcs         =  CS_i * (1.0 + CSFI_i * ecpl1 + CSBI_i * ecpl2) * exp(-THECS_i * ln(1.0 + qi1m * inv_qi1cs + qi2m * inv_qi2cs)); \
    if (RSG_i == 0.0) begin \
        temp3       =  1.0; \
    end else begin \
        if (RSG_i < 0.0) begin \
            temp1       =  RSG_i * exp(THERSG_i * ln(qim + 1.0e-12)); \
            temp3       =  1.0 - temp1; \
        end else begin \
            temp1       =  RSG_i * exp(THERSG_i * ln(qim + 1.0e-12)); \
            temp3       =  1.0 / (1.0 + temp1); \
        end \
    end \
    Grs         =  frscsi * (qim * temp3 + RSIG_i); \
    Gmob1       =  (1.0 + exp(THEMU_i * ln(fmue * eeff1 + 1.0e-6)) + Gcs + BETN1_i * Grs); \
    Gmob2       =  (1.0 + exp(THEMU_i * ln(fmue * eeff2 + 1.0e-6)) + Gcs + BETN2_i * Grs); \
    Gmob        =  fcor * csum / (c1 / Gmob1 + c2 / Gmob2); \
    \
    /* *********** Channel length modulation *********** */ \
    inv_qimstar1 =  1.0 / (4.0 + qim); \
    if (ALPB_i > 0) begin \
        temp        =  1.0 / (1.0 + ALPB_i * qi2m); \
    end else begin \
        temp        =  1.0 - ALPB_i * qi2m; \
    end \
    r1          =  qim * inv_qimstar1 * temp; \
    dL_L_fact   =  ln(1.0 + (xd - xdeff) / (VP_i * inv_phit + VPG_i * qim * qim)) * r1; \
    dL_L        =  alp_loc * dL_L_fact; \
    GdL         =  1.0 / (1.0 + dL_L * (1.0 + dL_L)); \
    \
    /* *********** Velocity saturation *********** */ \
    /* Front gate bias dependence of velocity saturation */ \
    wsat1       =  100.0 * esurf1 / (100.0 + esurf1); \
    if (THESAT1_i < 0.0) begin \
        sat_fact1   =  1.0 / (1.0 - THESAT1_i * wsat1); \
    end else begin \
        sat_fact1   =  1.0 + THESAT1_i * wsat1; \
    end \
    /* Back gate bias dependence of velocity saturation */ \
    wsat2       =  100.0 * esurf2 / (100.0 + esurf2); \
    if (THESAT2_i < 0.0) begin \
        sat_fact2   =  1.0 / (1.0 - THESAT2_i * wsat2); \
    end else begin \
        sat_fact2   =  1.0 + THESAT2_i * wsat2; \
    end \
    /* Gvsat calculation */ \
    Ggamma      =  sat_phit_loc * dxdrift * 0.5 * (sat_fact1 + sat_fact2); \
    sqrt_zsat   =  Ggamma / (Gmob * GdL); \
    zsat        =  sqrt_zsat * sqrt_zsat; \
    vsat_fact   =  sqrt(1.0 + zsat); \
    hsat        =  (1.0 + 1.5 * zsat) / vsat_fact; \
    \
    /* *********** Quantum mechanical corrections *********** */ \
    if (QMC > 0.0) begin \
        temp1       =  0.6 * qq * exp(-`INV6 * ln(esurf1 * esurf1 + 60.0)); \
        temp2       =  0.6 * qq * exp(-`INV6 * ln(esurf2 * esurf2 + 60.0)); \
        qmfact1     =  (1.0 + k1 * temp1) / tox1fact; \
        qmfact2     =  (1.0 + k2 * temp2) / tox2fact; \
    end else begin \
        qmfact1     =  1.0; \
        qmfact2     =  1.0; \
    end \
    \
    /* *********** Drain-source current *********** */ \
    if (qis > `QI_LOW) begin \
        if (qid > `QI_LOW) begin \
            if (abs(a2d) < 0.01) begin \
                temp        =  (2.0 + q1d + 0.5 * a1d) / ((2.0 + q2d) * a1d); \
                temp1       =  temp * a2d; \
                temp2       =  temp1 * temp1; \
                temp3       =  1.0 - temp1 + temp2; \
                temp4       =  temp3 - temp1 * temp2; \
                temp1       =  (k2q2d - 2.0 * qsqd * (temp - 1.0 / a1d) * temp4) / (2.0 + q2d); \
                dqid_dxn_qi =  ((dqsqd_dxn_qi * qid - Aexp1d) / a1d - temp1) / qid; \
                dd          =  dqid_dxn_qi * qid / (dqid_dxn_qi + 1.0); \
            end else begin \
                dqid_dxn_qi =  dqsqd_dxn_qi * sumd / (a1d * a2d) - (Aexp1d / a1d + Aexp2d / a2d) / qid; \
                dd          =  dqid_dxn_qi * qid / (dqid_dxn_qi + 1.0); \
            end \
        end else begin \
            dd          =  dinf; \
        end \
        temp1       =  dd - ds; \
        temp2       =  1.0 + `SMTH_SQ * temp1 * temp1; \
        if (abs(temp1) > 1.0e-3) begin \
            temp3       =  qid - qis; \
            Ls          =  temp3 - dd * dxdrift; \
            Ld          =  temp3 - ds * dxdrift; \
            Us          =  sqrt(Ls * Ls + temp2); \
            Ud          =  sqrt(Ld * Ld + temp2); \
            idrift2     =  0.25 / temp1 * (Ud * Ls - Us * Ld + temp2 * ln((Ld + Ud) / (Ls + Us))); \
        end else begin \
            temp3       =  dxdrift * temp1; \
            idrift2     = -0.25 * `INV6 * dxdrift * temp3 * temp3 / sqrt(temp2); \
        end \
    end else begin \
        dd          =  dinf; \
        idrift2     =  0.0; \
    end \
    norm_Ids    =  qim * dxdrift + idrift2 + qis - qid; \
    \
    /* *********** Variables for calculation of intrinsic charges and gate current *********** */ \
    if (qis > `QI_LOW) begin \
        if (norm_Ids > 1.0e-30) begin \
            q1s_chap    =  a1s / (Aexp1s / qis - dqsqs_dxn_qi); \
            q1d_chap    =  a1d / (Aexp1d / qid - dqsqd_dxn_qi); \
            inv_k1h1_0  =  (q1s_chap - q1d_chap) / norm_Ids; \
            q2s_chap    =  a2s / (Aexp2s / qis - dqsqs_dxn_qi); \
            q2d_chap    =  a2d / (Aexp2d / qid - dqsqd_dxn_qi); \
            inv_k2h2_0  =  (q2s_chap - q2d_chap) / norm_Ids; \
        end else begin \
            inv_k1h1_0  =  0.0; \
            inv_k2h2_0  =  0.0; \
        end \
    end else begin \
        zeta1       = -2.0 * s1 * (inv_k1 / q1chapinf + inv_dinf); \
        zeta2       = -2.0 * s2 * (inv_k2 / q2chapinf + inv_dinf); \
        temp        =  (zeta2 - zeta1) * inv_dinf; \
        temp1       =  zeta1 * inv_k1; \
        temp2       =  zeta2 * inv_k2; \
        temp3       =  temp1 + temp2; \
        temp4       =  3.0 + 2.0 * (s1 * inv_k1 + s2 * inv_k2); \
        ksi1        =  (temp2 + temp - temp3 / q1chapinf) / temp4; \
        ksi2        =  (temp1 - temp - temp3 / q2chapinf) / temp4; \
        inv_k1h1_0  = -q1chapinf * (ksi1 * q1chapinf + inv_dinf); \
        inv_k2h2_0  = -q2chapinf * (ksi2 * q2chapinf + inv_dinf); \
    end \
    inv_k1h1    =  inv_k1h1_0 * hsat; \
    inv_k2h2    =  inv_k2h2_0 * hsat; \
    delta_k1q1  =  0.5 * (k1q1d - k1q1s); \
    delta_k2q2  =  0.5 * (k2q2d - k2q2s); \
    prod1       =  delta_k1q1 * inv_k1h1; \
    prod2       =  delta_k2q2 * inv_k2h2;

// ---- end `include "L_UTSOI_102_macrodef.include" ----

// *************************************************************************************************************************
// Model Calculation
// *************************************************************************************************************************

module l_utsoi(d,g,s,b,Tnode);

// ---- begin `include "L_UTSOI_102_module.include" ----
// *********************************************************************************************
// ****                                                                                     ****
// ****                                    L-UTSOI Model                                    ****
// ****                                   Version 102.9.0                                   ****
// ****                                                                                     ****
// ****                      Ultra Thin Fully Depleted SOI MOSFET Model                     ****
// ****                                                                                     ****
// ****                                   Verilog-A code                                    ****
// ****      Authors: S. Martinie, T. Bedecarrats, O. Rozeau, T. Poiroux, M.A. Jaud         ****
// ****                                                                                     ****
// *********************************************************************************************
//
//
// *********************************************************************************************
// ****                            Copyright 2013-2025 CEA-Leti                             ****
// *********************************************************************************************
//
// *********************************************************************************************
// ****                     Comments on this version: January, 2026                         ****
// ****                                                                                     ****
// ****   This model is suitable for undoped ultrathin film SOI MOSFET                      ****
// ****   The core of the model (drain current and intrinsic charges) is valid also         ****
// ****   for independent double gate MOSFET, since it accounts for back interface          ****
// ****   conduction                                                                        ****
// ****                                                                                     ****
// ****   Includes:                                                                         ****
// ****       - specific surface potential calculations for FDSOI, valid also for IDG       ****
// ****       - specific drain current expression for FDSOI, valid also for IDG             ****
// ****       - specific intrinsic charges model, valid also for IDG                        ****
// ****       - field-dependent mobility including remote coulomb scattering                ****
// ****       - quantum confinement effect                                                  ****
// ****       - velocity saturation                                                         ****
// ****       - channel length modulation                                                   ****
// ****       - series-resistance with gate voltage dependence                              ****
// ****       - short-channel effects                                                       ****
// ****       - overlap capacitances (SP-based)                                             ****
// ****       - gate leakage current                                                        ****
// ****       - gate-induced drain/source leakage (GIDL, GISL)                              ****
// ****       - Impact ionization current                                                   ****
// ****       - Poly-depletion model                                                        ****
// ****       - Cryogenic temperature simulation improvement                                ****
// ****       - Separate capacitance calculation                                            ****
// ****       - self heating effect                                                         ****
// ****       - narrow-width effects                                                        ****
// ****       - stress model                                                                ****
// ****       - noise (1/f, thermal, induced gate and shot noise)                           ****
// ****       - source/drain junctions asymmetry                                            ****
// ****       - Non-quasi-static effects (using RTA approximation)                          ****
// ****       - global and local scale levels                                               ****
// ****                                                                                     ****
// *********************************************************************************************

// *************************************************************************************************************************
// Nodes definitions
// *************************************************************************************************************************

inout      d, g, s, b, Tnode;

//  Electrical node definitions
electrical d;
electrical g;
electrical s;
electrical b;

//  Temperature node for self heating
thermal    Tnode;
branch (Tnode) THPWR;
branch (Tnode) THRC;

//  Internal node for noise model
electrical NSIG;
branch (NSIG) NOII;
branch (NSIG) NOIR;
branch (NSIG) NOIC;

//  Internal nodes for drain, source and bulk resistor
electrical si;
electrical di;
electrical bp;

//  Internal nodes for gate resistor
electrical gp;

    //  Electrical node for NQS model
`ifdef NQSmodel
    electrical Gnqs, Gnqs2, Dnqs;

    // Ground definition
    electrical gndnqs;
    ground gndnqs;
`endif // NQSmodel

//  Model flags and reference temperature
// *********************************************************************************************************************

//  Model selection
`MPIcc(SWSCALE      ,0          ,""         ,0           ,1           ,"Parameter set mode (local=0, global=1)")
`MPRnb(VERSION      ,102.8      ,""                                   ,"Model version")

//  Switch parameters that turn models/effects On (=1) or Off (=0)
`MPIcc(SWSUBDEP     ,0         ,""         ,0           ,1           ,"Flag for substrate depletion model (without=0, with=1)")
`MPIcc(SWIGATE      ,0         ,""         ,0           ,1           ,"Flag for gate current (without=0, with=1)")
`MPIcc(SWGIDL       ,0         ,""         ,0           ,1           ,"Flag for GIDL current (without=0, with=1)")
`MPIcc(SWSHE        ,0         ,""         ,0           ,1           ,"Flag for self heating effect (without=0, with=1)")
`MPIcc(SWIGN        ,1         ,""         ,0           ,1           ,"Flag for induced gate noise model (without=0, with=1)")
`MPIcc(SWJUNASYM    ,0         ,""         ,0           ,1           ,"Flag for source/drain junction asymmetry (without=0, with=1)")
`MPIcc(SWIMPACT     ,0         ,""         ,0           ,1           ,"Flag for impact ionization current (without=0, with=1)")
`MPIcc(SWPDEP       ,0         ,""         ,0           ,1           ,"Flag for poly-depletion model (without=0, with=1)")
`MPIcc(SWCRYO       ,0         ,""         ,0           ,1           ,"Flag for cryogenic temperature simulation improvement (without=0, with=1)")
`MPIcc(SWQMOD       ,0         ,""         ,0           ,1           ,"Flag for separate charge calculation (without=0, with=1)")
`MPIcc(SWEDGE       ,0         ,""         ,0           ,1           ,"Flag for drain current of edge transistors (without=0, with=1)")

//  Quantum effect parameter
`MPRcz(QMC          ,1.0        ,""                                   ,"Quantum correction factor (no correction=0, full correction=1)")

//  Device type selection
`MPIty(TYPE         ,1          ,""                                   ,"Channel type parameter, +1=NMOS -1=PMOS")

//  Reference temperature and max temperature elevation
`MPRco(TR           ,21.0       ,"C"        ,-273.0      ,inf         ,"Nominal temperature")
aliasparam TREF = TR;
`MPRoo(TMAX         ,150.0      ,"C"        ,0.0         ,inf         ,"Maximum self-heating temperature elevation")

//  Temperature parameters for cryogenic subthreshold swing saturation model
`MPRco(TMIN         ,1.0       ,"K"        ,1.0          ,inf         ,"Minimum temperature (K)")
`MPRcc(ATMIN        ,0.0       ,""         ,0.0          ,1.0         ,"Minimum temperature slope")
`MPRcc(BTMIN        ,1e-3      ,"K^2"      ,0.0          ,1.0e3       ,"Minimum temperature smoothing parameter (K^2)")

//  Instance parameters definition
// *********************************************************************************************************************

//  Instance parameters
`IPRco(L            ,1.0e-06      ,"m"        ,1.0e-09     ,inf         ,"Channel length")
`IPRco(W            ,1.0e-06      ,"m"        ,1.0e-09     ,inf         ,"Channel width")
`IPRcz(ASOURCE      ,1.0e-12      ,"m^2"                                ,"Source region area")
`IPRcz(ADRAIN       ,1.0e-12      ,"m^2"                                ,"Drain region area")
`IPRcz(PSOURCE      ,1.0e-06      ,"m"                                  ,"Source region perimeter")
`IPRcz(PDRAIN       ,1.0e-06      ,"m"                                  ,"Drain region perimeter")
`IPRcz(SA           ,0.0          ,"m"                                  ,"Distance between OD-edge and poly at source side")
`IPRcz(SB           ,0.0          ,"m"                                  ,"Distance between OD-edge and poly at drain side")
`IPRcz(SD           ,0.0          ,"m"                                  ,"Distance between neighboring fingers")
`IPIco(NF           ,1            ,""         ,1           ,inf         ,"Number of fingers")
`IPIcz(MULT         ,1            ,""                                   ,"Number of devices in parallel")
`IPRco(MULT_I       ,1.0          ,""         ,0.0         ,inf         ,"Currents multiplication factor")
`IPRco(MULT_Q       ,1.0          ,""         ,0.0         ,inf         ,"Charges multiplication factor")
`IPRco(MULT_FN      ,MULT_I       ,""         ,0.0         ,inf         ,"Flicker noise multiplication factor")
`IPRnb(DELVTO       ,0.0          ,"V"                                  ,"Threshold voltage shift parameter")
`IPRcz(FACTUO       ,1.0          ,""                                   ,"Low-field mobility pre-factor")
`IPRnb(DTEMP        ,0.0          ,"K"                                  ,"Device temperature offset")
`IPIcc(NGCON        ,1.0          ,""         ,1           ,2           ,"Number of gate contacts")
`IPRnb(XGW          ,1.0e-7       ,"m"                                  ,"Distance from the gate contact to the channel edge")
`IPRnb(NRS          ,0.0          ,""                                   ,"Number of squares of source diffusion")
`IPRnb(NRD          ,0.0          ,""                                   ,"Number of squares of drain diffusion")

//  Local parameters definition SWSCALE=0
// *********************************************************************************************************************

//  Process parameters
`MPRcc(TOXE         ,2.0e-09      ,"m"        ,3.0e-10     ,1.0e-06     ,"Front gate equivalent oxide thickness")
`MPRcc(TSI          ,1.0e-08      ,"m"        ,3.0e-09     ,2.0e-08     ,"Silicon or SiGe film thickness")
`MPRcc(XGE          ,0.0          ,""         ,0.0         ,1.0         ,"Fraction of Ge content in the channel")
`MPRcc(TBOX         ,1.0e-07      ,"m"        ,3.0e-10     ,1.0e-06     ,"Buried oxide thickness")
`MPRnb(NCH          ,0.0          ,"cm^-3"                              ,"Thin film doping (n-type=negative value, p-type=positive value)")
`MPRnb(NSUB         ,3.0e18       ,"cm^-3"                              ,"Substrate doping (n-type=negative value, p-type=positive value)")
`MPRcz(CT           ,0.0          ,""                                   ,"Interface states factor")
`MPRcc(TOXP         ,2.0e-09      ,"m"        ,3.0e-10     ,1.0e-06     ,"Front gate physical oxide thickness")
`MPRcc(NOV          ,1.0e20       ,"cm^-3"    ,1.0e15      ,1.0e21      ,"Effective doping of overlap-ldd regions")
`MPRcc(NOVD         ,1.0e20       ,"cm^-3"    ,1.0e15      ,1.0e21      ,"Effective doping of overlap-ldd regions ar drain side")
`MPRnb(VFB          ,0.0          ,"V"                                  ,"Flat-band voltage of the front gate at TR")
`MPRnb(VFBB         ,0.0          ,"V"                                  ,"Flat-band voltage of the back gate at TR")
`MPRnb(STVFB        ,0.0          ,"V/K"                                ,"Temperature dependence of VFB and VFBB")
`MPRcc(NP           ,1.0e21       ,"cm^-3"    ,1.0e19      ,1.0e22      ,"Gate poly-silicon doping")

//  Gate to interface coupling parameters
`MPRcc(CICF         ,1.0          ,""         ,0.1         ,10.0        ,"Long channel front interface coupling coefficient")
`MPRcc(CIC          ,1.0          ,""         ,0.1         ,10.0        ,"Long channel back interface coupling coefficient")
`MPRcc(PSCE         ,0.0          ,""         ,0.0         ,5.0         ,"Short channel effect coefficient")
`MPRcz(PSCEB        ,1.0          ,""                                   ,"Short channel back to front interface asymmetry factor")
`MPRcc(NSDDC        ,1.0e22       ,"cm^-3"    ,1.0e18      ,1.0e22      ,"Source/Drain effective doping level for DC model")
`MPRcz(PSCEDLB      ,0.0          ,""                                   ,"Back bias dependence of short channel effect modulation")
`MPRcc(PNCE         ,0.0          ,""         ,-1.0        ,1.0         ,"Narrow channel effect on body factor")

//  DIBL parameters
`MPRcz(CF           ,0.0          ,""                                   ,"DIBL parameter")
`MPRcz(CFB          ,1.0          ,""                                   ,"DIBL back to front interface asymmetry factor")
`MPRnb(STCF         ,0.0          ,"1/K"                                ,"Temperature dependence of CF, with same scaling as CF")
`MPRco(CFD          ,0.2          ,"V"        ,0.05        ,inf         ,"Drain voltage dependence parameter of DIBL")
`MPRnb(CFDL         ,0.0          ,""                                   ,"DIBL modulation coefficient due to Leff variation")
`MPRcz(CFDLB        ,0.0          ,""                                   ,"Back bias dependence of DIBL modulation")

//  Mobility parameters
`MPRco(BETN         ,5.0e-02      ,"m^2/V/s"  ,1.0e-10     ,inf         ,"Front channel aspect ratio times zero-field mobility")
`MPRcc(BETNB        ,1.0          ,""         ,0.1         ,10.0        ,"Back channel over front channel zero-field mobility ratio")
`MPRnb(STBET        ,1.5          ,""                                   ,"Temperature dependence of BETN")
`MPRcz(CS           ,0.0          ,""                                   ,"Remote Coulomb scattering parameter at TR")
`MPRcz(CSFI         ,0.0          ,""                                   ,"Field dependence of Coulomb scattering at front interface")
`MPRcz(CSBI         ,0.0          ,""                                   ,"Field dependence of Coulomb scattering at back interface")
`MPRnb(STCS         ,0.0          ,""                                   ,"Temperature dependence of CS")
`MPRcz(THECS        ,1.5          ,""                                   ,"Remote Coulomb scattering exponent at TR")
`MPRnb(STTHECS      ,0.0          ,""                                   ,"Temperature dependence of THECS")
`MPRco(CSTHR        ,2.0          ,""         ,1.0e-03     ,inf         ,"Remote Coulomb scattering threshold level")
`MPRco(CSTHRB       ,1.0          ,""         ,0.1         ,inf         ,"Remote Coulomb scattering threshold asymmetry parameter")
`MPRcz(MUE          ,0.0          ,"cm/MV"                              ,"Front channel mobility reduction coefficient at TR")
`MPRnb(STMUE        ,0.0          ,""                                   ,"Temperature dependence of MUE")
`MPRcz(THEMU        ,1.5          ,""                                   ,"Front channel mobility reduction exponent at TR")
`MPRnb(STTHEMU      ,0.0          ,""                                   ,"Temperature dependence of THEMU")
`MPRnb(XCOR         ,0.0          ,""                                   ,"Front channel non-universality factor")
`MPRnb(XCORB        ,1.0          ,""                                   ,"Asymmetry term of non-universality factor")
`MPRnb(STXCOR       ,0.0          ,""                                   ,"Temperature dependence of XCOR")
`MPRcz(FETA         ,1.0          ,""                                   ,"Effective field parameter")

//  Series resistance parameters (for resistance modeling as part of intrinsic mobility reduction)
`MPRcz(RS           ,30.0         ,"Ohm"                                ,"Source/Drain series resistance at TR")
`MPRcz(RSIG         ,0.0          ,""                                   ,"Source/Drain extension resistance coefficient")
`MPRnb(STRS         ,0.0          ,""                                   ,"Temperature dependence of RS")
`MPRco(RSG          ,0.0          ,""         ,-0.5        ,inf         ,"Transverse electric field dependence of RS")
`MPRnb(THERSG       ,2.0          ,""                                   ,"Transverse electric field dependence exponent of RS")
`MPRnb(RSB          ,0.0          ,""                                   ,"Back bias dependence of RS")

//  Velocity saturation parameters
`MPRcz(THESAT       ,0.0          ,"V^-1"                               ,"Velocity saturation parameter at TR")
`MPRnb(STTHESAT     ,-0.1         ,""                                   ,"Temperature dependence of THESAT")
`MPRco(THESATG      ,0.0          ,""         ,-0.5        ,inf         ,"Front gate bias dependence of velocity saturation")
`MPRco(THESATB      ,0.0          ,""         ,-0.5        ,inf         ,"Back gate bias dependence of velocity saturation")

//  Saturation voltage parameters
`MPRcc(AX           ,8.0          ,""         ,1.0         ,16.0        ,"Linear/saturation transition exponent")

//  Channel length modulation (CLM) parameters
`MPRcz(ALP          ,0.0          ,""                                   ,"CLM pre-factor")
`MPRcz(ALP1         ,0.0          ,"V"                                  ,"CLM enhancement factor above threshold")
`MPRnb(ALPB         ,0.0          ,""                                   ,"Back bias dependence of channel length modulation")
`MPRco(VP           ,0.05         ,"V"        ,1.0e-10     ,inf         ,"CLM logarithm dependence factor")
`MPRcz(VPG          ,0.0          ,""                                   ,"Transverse electric field dependence of CLM logarithm factor")

//  Gate current parameters
`MPRcc(GCO          ,0.0          ,""         ,-10.0       ,10.0        ,"Gate tunneling energy adjustment in inversion")
`MPRcz(IGINV        ,0.0          ,"A"                                  ,"Gate to channel current pre-factor")
`MPRcz(IGOVINV      ,0.0          ,"A"                                  ,"Gate to overlap current pre-factor in inversion")
`MPRcz(IGOVINVD     ,0.0          ,"A"                                  ,"Gate to overlap current pre-factor in inversion at drain side")
`MPRcz(IGOVACC      ,0.0          ,"A"                                  ,"Gate to overlap current pre-factor in accumulation")
`MPRcz(IGOVACCD     ,0.0          ,"A"                                  ,"Gate to overlap current pre-factor in accumulation at drain side")
`MPRnb(STIG         ,0.0          ,""                                   ,"Temperature dependence of all gate currents")
`MPRcc(GC2CH        ,0.375        ,""         ,0.0         ,10.0        ,"Gate to channel current slope factor")
`MPRcc(GC3CH        ,0.063        ,""         ,-2.0        ,2.0         ,"Gate to channel current curvature factor")
`MPRcc(GC2OVINV     ,0.375        ,""         ,0.0         ,10.0        ,"Gate current slope factor for overlap regions in inversion mode")
`MPRcc(GC3OVINV     ,0.063        ,""         ,-2.0        ,2.0         ,"Gate current curvature factor for overlap regions in inversion mode")
`MPRcc(GC2OVACC     ,0.375        ,""         ,0.0         ,10.0        ,"Gate current slope factor for overlap regions in accumulation mode")
`MPRcc(GC3OVACC     ,0.063        ,""         ,-2.0        ,2.0         ,"Gate current curvature factor for overlap regions in accumulation mode")
`MPRnb(GCDOV        ,0.0          ,"V^-1"                               ,"High drain voltage dependence of overlap gate current")
`MPRnb(GCVDOV       ,1.0          ,"V"                                  ,"Threshold of high drain voltage effect on overlap gate current")
`MPRco(CHIB         ,3.1          ,"V"        ,1.0         ,inf         ,"Tunneling barrier height")
`MPRcz(NIGINV       ,0.0          ,""                                   ,"Gate tunneling slope adjustment in subthreshold regime")
`MPRcz(FNOVINV      ,0.0          ,"A"                                  ,"Extra gate to overlap current pre-factor in inversion")
`MPRcz(FNOVINVD     ,0.0          ,"A"                                  ,"Extra gate to overlap current pre-factor in inversion at drain side")
`MPRcc(GCOVINVFN    ,0.2          ,""         ,0.1         ,10.0        ,"Extra gate current slope factor for overlap regions in inversion mode")
`MPRnb(STIGFN       ,0.0          ,""                                   ,"Temperature dependence of extra gate to overlap current")

//  Gate Induced Drain/Source Leakage (GIDL/GISL) parameters
`MPRcz(AGIDL        ,0.0          ,"A/V^3"                              ,"GIDL pre-factor")
`MPRcz(AGIDLD       ,0.0          ,"A/V^3"                              ,"GIDL pre-factor at drain side")
`MPRcz(BGIDL        ,41.0         ,"V"                                  ,"GIDL probability factor at TR")
`MPRcz(BGIDLD       ,41.0         ,"V"                                  ,"GIDL probability factor at TR at drain side")
`MPRnb(STBGIDL      ,0.0          ,"V/K"                                ,"Temperature dependence of BGIDL")
`MPRnb(STBGIDLD     ,0.0          ,"V/K"                                ,"Temperature dependence of BGIDL at drain side")
`MPRnb(CGIDL        ,0.0          ,"V^-1"                               ,"Substrate bias dependence of GIDL")
`MPRnb(CGIDLD       ,0.0          ,"V^-1"                               ,"Substrate bias dependence of GIDL at drain side")
`MPRnb(DGIDL        ,0.0          ,"V^-1"                               ,"High longitudinal field parameter of GIDL")
`MPRnb(DGIDLD       ,0.0          ,"V^-1"                               ,"High longitudinal field parameter of GIDL at drain side")

//  Edge transistor parameters
`MPRcz(CTEDGE       ,0.0          ,""                                   ,"Interface states factor of edge transistors")
`MPRnb(VFBEDGE      ,0.0          ,"V"                                  ,"Flat-band voltage of the front gate of edge transistors at TR")
`MPRnb(VFBBEDGE     ,0.0          ,"V"                                  ,"Flat-band voltage of the back gate of edge transistors at TR")
`MPRnb(STVFBEDGE    ,0.0          ,"V/K"                                ,"Temperature dependence of VFBEDGE and VFBBEDGE")
`MPRcc(CICFEDGE     ,1.0          ,""         ,0.1         ,10.0        ,"Long channel front interface coupling coefficient of edge transistors")
`MPRcc(CICEDGE      ,1.0          ,""         ,0.1         ,10.0        ,"Long channel back interface coupling coefficient of edge transistors")
`MPRcc(PSCEEDGE     ,0.0          ,""         ,0.0         ,5.0         ,"Short channel effect coefficient of edge transistors")
`MPRcz(PSCEBEDGE    ,1.0          ,""                                   ,"Short channel back to front interface asymmetry factor of edge transistors")
`MPRcz(CFEDGE       ,0.0          ,""                                   ,"DIBL parameter of edge transistors")
`MPRcz(CFBEDGE      ,1.0          ,""                                   ,"DIBL back to front interface asymmetry factor of edge transistors")
`MPRco(CFDEDGE      ,0.2          ,"V"        ,0.05        ,inf         ,"Drain voltage dependence parameter of DIBL of edge transistors")
`MPRco(BETNEDGE     ,5.0e-02      ,"m^2/V/s"  ,1.0e-10     ,inf         ,"Front channel aspect ratio times zero-field mobility of edge transistors")
`MPRnb(STBETEDGE    ,1.5          ,""                                   ,"Temperature dependence of BETNEDGE")

//  Impact Ionization parameters
`MPRcz(A1           ,1.0          ,""                                   ,"Impact ionization pre-factor")
`MPRcz(A2           ,10.0         ,""                                   ,"Impact ionization exponent at TR")
`MPRnb(STA2         ,0.0          ,""                                   ,"Temperature dependence of A2")
`MPRcz(A3           ,1.0          ,""                                   ,"Saturation voltage dependence of impact-ionization")

//  Charge model parameters
`MPRco(AREAQ        ,1.0e-12      ,"m^2"      ,1.0e-18     ,inf         ,"Effective channel area for intrinsic CV")
`MPRcz(CGBOV        ,0.0          ,"F"                                  ,"Oxide capacitance for gate-substrate overlap")
`MPRcc(NSDAC        ,1.0e22       ,"cm^-3"    ,1.0e18      ,1.0e22      ,"Source/Drain effective doping level for AC model")
`MPRcz(FIF          ,0.0          ,""                                   ,"Inner fringe capacitance prefactor")
`MPRcz(FSCEAC       ,0.0          ,""                                   ,"Short channel effect adjustment factor for charge model")
`MPRnb(VFBAC        ,0.0          ,"V"                                  ,"Flat-band voltage of the front gate at TR when SWQMOD=1")
`MPRnb(VFBBAC       ,0.0          ,"V"                                  ,"Flat-band voltage of the back gate at TR when SWQMOD=1")
`MPRcc(PSCEAC       ,0.0          ,""         ,0.0         ,5.0         ,"Short channel effect coefficient when SWQMOD=1")
`MPRcz(CFAC         ,0.0          ,""                                   ,"DIBL-parameter when SWQMOD=1")
`MPRcz(THESATAC     ,0.0          ,"V^-1"                               ,"Velocity saturation parameter at TR when SWQMOD=1")
`MPRco(AXAC         ,8.0          ,""         ,1.0         ,16.0        ,"Linear/saturation transition exponent when SWQMOD=1")
`MPRcz(ALPAC        ,0.0          ,""                                   ,"CLM pre-factor when SWQMOD=1")
`MPRcz(COV          ,0.0          ,"F"                                  ,"Overlap capacitance per side")
`MPRcz(COVD         ,0.0          ,"F"                                  ,"Overlap capacitance at drain side")
`MPRnb(COVDL        ,0.0          ,""                                   ,"Overlap capacitance modulation coefficient due to Leff variation")
`MPRnb(COVDLB       ,0.0          ,""                                   ,"Overlap capacitance modulation with back bias")
`MPRnb(DVFBOV       ,0.0          ,"V"                                  ,"Overlap capacitance flat-band voltage adjustment")
`MPRcz(CFR          ,0.0          ,"F"                                  ,"Outer fringe capacitance per side")
`MPRcz(CFRD         ,0.0          ,"F"                                  ,"Outer fringe capacitance at drain side")
`MPRcz(CSD          ,1.04e-18     ,"F"                                  ,"Drain-source capacitance")
`MPRcz(CSDBP        ,0.0          ,"F/m"                                ,"Drain/source to substrate perimeter capacitance")

//  Self heating parameters
`MPRco(RTH          ,1.0e04       ,"K/W"      ,1.0e-06     ,inf         ,"Thermal resistance")
`MPRnb(STRTH        ,0.0          ,""                                   ,"Temperature dependence of RTH")
`MPRcz(CTH          ,1.0e-11      ,"J/K"                                ,"Thermal capacitance")

//  Noise model parameters
`MPRcz(FNT          ,1.0          ,""                                   ,"Thermal noise coefficient")
`MPRcz(FNTEXC       ,0.0          ,""                                   ,"Excess noise coefficient")
`MPRcz(NFA          ,8.0e22       ,"V^-1/m^4"                           ,"First coefficient of flicker noise")
`MPRcz(NFB          ,3.0e07       ,"V^-1/m^2"                           ,"Second coefficient of flicker noise")
`MPRcz(NFC          ,0.0          ,"V^-1"                               ,"Third coefficient of flicker noise")
`MPRcc(NFE          ,0.0          ,""         ,-1.0        ,1.0         ,"Flicker noise front transverse field effect coefficient")
`MPRcc(NFEB         ,0.0          ,""         ,-1.0        ,1.0         ,"Flicker noise back transverse field effect coefficient")
`MPRco(EF           ,1.0          ,""         ,0.1         ,inf         ,"Frequency coefficient of flicker noise")

//  NQS model parameters
`ifdef NQSmodel
    `MPRco(KDRIFT       ,1.0          ,""         ,0.0         ,inf         ,"Drift component parameter of NQS effect")
    `MPRco(KDIFF        ,1.0          ,""         ,0.0         ,inf         ,"Diffusion component parameter of NQS effect")
    `MPRcc(FRACINV      ,1.0          ,""         ,0.0         ,1.0         ,"Fraction of inversion charge for the second pole of the NQS transition")
    `MPRcc(KFRACINV     ,1.0e-15      ,""         ,1.0e-15     ,1.0         ,"Second pole frequency coefficient of the NQS transition")
`endif // NQSmodel

//  Parasitic resistance parameters
`MPRco(RG           ,0.0          ,"Ohm"       ,0.0        ,inf         ,"Gate resistance")
`MPRco(RSE          ,0.0          ,"Ohm"       ,0.0        ,inf         ,"External source resistance")
`MPRco(RDE          ,0.0          ,"Ohm"       ,0.0        ,inf         ,"External drain resistance")
`MPRco(RWELL        ,0.0          ,"Ohm"       ,0.0        ,inf         ,"Well resistance between node BP and B")

//  Global parameters definition SWSCALE=1
// *********************************************************************************************************************

//  Geometry scaling parameters
`MPRnb(LVARO        ,0.0          ,"m"                                  ,"Geometry independent difference between physical and drawn gate lengths")
`MPRnb(LVARL        ,0.0          ,""                                   ,"Length dependence of LPS")
`MPRnb(LVARW        ,0.0          ,""                                   ,"Width dependence of LPS")
`MPRnb(LAP          ,0.0          ,"m"                                  ,"Effective channel length reduction per side")
`MPRnb(WVARO        ,0.0          ,"m"                                  ,"Geometry-independent difference between physical and drawn field-oxide opening")
`MPRnb(WVARL        ,0.0          ,""                                   ,"Length dependence of WOD")
`MPRnb(WVARW        ,0.0          ,""                                   ,"Width dependence of WOD")
`MPRnb(WOT          ,0.0          ,"m"                                  ,"Effective reduction of channel width per side")
`MPRnb(DLQ          ,0.0          ,"m"                                  ,"Effective channel length additional offset for charge model")
`MPRnb(DWQ          ,0.0          ,"m"                                  ,"Effective channel width additional offset for charge model")

//  Process parameters
`MPRcc(TOXEO        ,2.0e-09      ,"m"        ,3.0e-10     ,1.0e-06     ,"Front gate equivalent oxide thickness")
`MPRcc(TSIO         ,1.0e-08      ,"m"        ,3.0e-09     ,2.0e-08     ,"Silicon or SiGe film thickness")
`MPRcc(XGEO         ,0.0          ,""         ,0.0         ,1.0         ,"Fraction of Ge content in the channel")
`MPRcc(TBOXO        ,1.0e-07      ,"m"        ,3.0e-10     ,1.0e-06     ,"Buried oxide thickness")
`MPRnb(NCHO         ,0.0          ,"cm^-3"                              ,"Thin film doping (n-type=negative value, p-type=positive value)")
`MPRnb(NSUBO        ,3.0e18       ,"cm^-3"                              ,"Substrate doping (n-type=negative value, p-type=positive value)")
`MPRcz(CTO          ,0.0          ,""                                   ,"Interface states factor")
`MPRcc(TOXPO        ,2.0e-09      ,"m"        ,3.0e-10     ,1.0e-06     ,"Front gate physical oxide thickness")
`MPRcc(NOVO         ,1.0e20       ,"cm^-3"    ,1.0e15      ,1.0e21      ,"Effective doping of overlap-ldd regions")
`MPRcc(NOVDO        ,1.0e20       ,"cm^-3"    ,1.0e15      ,1.0e21      ,"Effective doping of overlap-ldd regions at drain side")
`MPRnb(VFBO         ,0.0          ,"V"                                  ,"Geometry-independent front gate flat-band voltage at TR")
`MPRnb(VFBL         ,0.0          ,"V"                                  ,"Length dependence of VFB")
`MPRnb(VFBLEXP      ,2.0          ,""                                   ,"Exponent describing length dependence of VFB")
`MPRcz(VFBL2        ,0.0          ,""                                   ,"Second order length dependence of VFB")
`MPRnb(VFBLEXP2     ,2.0          ,""                                   ,"Exponent of second order length dependence of VFB")
`MPRnb(VFBW         ,0.0          ,"V"                                  ,"Width dependence of VFB")
`MPRnb(VFBLW        ,0.0          ,"V"                                  ,"Area dependence of VFB")
`MPRnb(VFBBO        ,0.0          ,"V"                                  ,"Geometry-independent back gate flat-band voltage at TR")
`MPRcz(VFBLBO       ,0.0          ,""                                   ,"Roll-off back to front interface asymmetry factor")
`MPRnb(STVFBO       ,0.0          ,"V/K"                                ,"Geometry-independent temperature dependence of VFB and VFBB")
`MPRnb(STVFBL       ,0.0          ,""                                   ,"Length dependence of STVFB")
`MPRnb(STVFBW       ,0.0          ,""                                   ,"Width dependence of STVFB")
`MPRnb(STVFBLW      ,0.0          ,""                                   ,"Area dependence of STVFB")
`MPRcz(NPO          ,1.0e21       ,"cm^-3"                              ,"Geometry-independent gate poly-silicon doping")
`MPRnb(NPL          ,0.0          ,""                                   ,"Length dependence of gate poly-silicon doping")

//  Gate to interface coupling parameters
`MPRcc(CICFO        ,1.0          ,""         ,0.1         ,10.0        ,"Long channel front interface coupling coefficient")
`MPRcc(CICO         ,1.0          ,""         ,0.1         ,10.0        ,"Long channel back interface coupling coefficient")
`MPRnb(PSCEL        ,0.0          ,""                                   ,"Length dependence of PSCE")
`MPRnb(PSCELEXP     ,2.0          ,""                                   ,"Exponent describing length dependence of PSCE")
`MPRnb(PSCEW        ,0.0          ,""                                   ,"Width dependence of PSCE")
`MPRcz(PSCEBO       ,1.0          ,""                                   ,"Short channel back to front interface asymmetry factor")
`MPRcc(NSDDCO       ,1.0e22       ,"cm^-3"    ,1.0e18      ,1.0e22      ,"Source/Drain effective doping level for DC model")
`MPRcz(PSCEDLBO     ,0.0          ,""                                   ,"Back bias dependence of short channel effect modulation")
`MPRnb(PNCEW        ,0.0          ,""                                   ,"Narrow channel effect on body factor for a width of WEN")

//  DIBL parameters
`MPRnb(CFL          ,0.0          ,""                                   ,"Length dependence of DIBL-parameter")
`MPRnb(CFLEXP       ,2.0          ,""                                   ,"Exponent for length dependence of CF")
`MPRnb(CFW          ,0.0          ,""                                   ,"Width dependence of CF")
`MPRcz(CFBO         ,1.0          ,""                                   ,"DIBL back to front interface asymmetry factor")
`MPRnb(STCFL        ,0.0          ,"1/K"                                ,"Length dependence of temperature dependence of CF, with same scaling as CF")
`MPRco(CFDO         ,0.2          ,"V"        ,0.05        ,inf         ,"Drain voltage dependence parameter of DIBL")
`MPRnb(CFDLL        ,0.0          ,""                                   ,"Length dependence of DIBL modulation coefficient due to Leff variation")
`MPRnb(CFDLW        ,0.0          ,""                                   ,"Width dependence of CFDL")
`MPRcz(CFDLBO       ,0.0          ,""                                   ,"Back bias dependence of DIBL modulation")

//  Mobility parameters
`MPRcz(UO           ,5.0e-02      ,"m^2/V/s"                            ,"Front channel zero-field mobility at TR")
`MPRnb(FBET1        ,0.0          ,""                                   ,"First length dependence modulation of BETN")
`MPRnb(FBET1W       ,0.0          ,""                                   ,"Width dependence of FBET1")
`MPRco(LP1          ,1.0e-08      ,"m"        ,1.0e-10     ,inf         ,"First characteristic length of BETN scaling")
`MPRnb(LP1W         ,0.0          ,""                                   ,"Width dependence of LP1")
`MPRnb(FBET2        ,0.0          ,""                                   ,"Second length dependence modulation of BETN")
`MPRco(LP2          ,1.0e-08      ,"m"        ,1.0e-10     ,inf         ,"Second characteristic length of BETN scaling")
`MPRnb(BETW1        ,0.0          ,""                                   ,"First width dependence modulation of BETN")
`MPRnb(BETW2        ,0.0          ,""                                   ,"Second width dependence modulation of BETN")
`MPRco(WBET         ,1.0e-08      ,"m"        ,1.0e-10     ,inf         ,"Characteristic width of BETN scaling")
`MPRcc(BETNBO       ,1.0          ,""         ,0.1         ,10.0        ,"Back channel over front channel zero-field mobility ratio")
`MPRnb(STBETO       ,1.5          ,""                                   ,"Geometry independent temperature dependence of BETN")
`MPRnb(STBETL       ,0.0          ,""                                   ,"Length dependence of STBET")
`MPRnb(STBETW       ,0.0          ,""                                   ,"Width dependence of STBET")
`MPRnb(STBETLW      ,0.0          ,""                                   ,"Area dependence of STBET")
`MPRnb(CSO          ,0.0          ,""                                   ,"Remote Coulomb scattering parameter at TR")
`MPRnb(CSL          ,0.0          ,""                                   ,"Length dependence of CS")
`MPRnb(CSLEXP       ,1.0          ,""                                   ,"Exponent describing length dependence of CS")
`MPRnb(CSW          ,0.0          ,""                                   ,"Width dependence of CS")
`MPRnb(CSLW         ,0.0          ,""                                   ,"Area dependence of CS")
`MPRcz(CSFIO        ,0.0          ,""                                   ,"Field dependence of Coulomb scattering at front interface")
`MPRcz(CSBIO        ,0.0          ,""                                   ,"Field dependence of Coulomb scattering at back interface")
`MPRnb(STCSO        ,0.0          ,""                                   ,"Temperature dependence of CS")
`MPRnb(STCSL        ,0.0          ,""                                   ,"Length dependence of STCS")
`MPRnb(STCSW        ,0.0          ,""                                   ,"Width dependence of STCS")
`MPRnb(STCSLW       ,0.0          ,""                                   ,"Area dependence of STCS")
`MPRcz(THECSO       ,1.5          ,""                                   ,"Remote Coulomb scattering exponent at TR")
`MPRnb(STTHECSO     ,0.0          ,""                                   ,"Temperature dependence of THECS")
`MPRco(CSTHRO       ,2.0          ,""         ,1.0e-03     ,inf         ,"Remote Coulomb scattering threshold level")
`MPRco(CSTHRBO      ,1.0          ,""         ,0.1         ,inf         ,"Remote Coulomb scattering threshold asymmetry parameter")
`MPRcz(MUEO         ,0.0          ,"cm/MV"                              ,"Front channel mobility reduction coefficient at TR")
`MPRnb(STMUEO       ,0.0          ,""                                   ,"Temperature dependence of MUE")
`MPRcz(THEMUO       ,1.5          ,""                                   ,"Front channel mobility reduction exponent at TR")
`MPRnb(STTHEMUO     ,0.0          ,""                                   ,"Temperature dependence of THEMU")
`MPRnb(XCORO        ,0.0          ,""                                   ,"Geometry-independent part of non-universality factor")
`MPRnb(XCORL        ,0.0          ,""                                   ,"Length dependence of XCOR")
`MPRnb(XCORLEXP     ,1.0          ,""                                   ,"Exponent describing length dependence of XCOR")
`MPRnb(XCORW        ,0.0          ,""                                   ,"Width dependence of XCOR")
`MPRnb(XCORLW       ,0.0          ,""                                   ,"Area dependence of XCOR")
`MPRnb(XCORBO       ,1.0          ,""                                   ,"Asymmetry term of non-universality factor")
`MPRnb(STXCORO      ,0.0          ,""                                   ,"Temperature dependence of XCOR")
`MPRcz(FETAO        ,1.0          ,""                                   ,"Effective field parameter")

//  Series resistance parameters (for resistance modeling as part of intrinsic mobility reduction)
`MPRnb(RSW1         ,30.0         ,"Ohm"                                ,"Source/Drain series resistance for channel width WEN at TR")
`MPRnb(RSW2         ,0.0          ,""                                   ,"Higher-order width scaling of source/drain series resistance")
`MPRcz(RSIGO        ,0.0          ,""                                   ,"Source/Drain extension resistance coefficient")
`MPRnb(STRSO        ,0.0          ,""                                   ,"Temperature dependence of RS")
`MPRco(RSGO         ,0.0          ,""         ,-0.5        ,inf         ,"Transverse electric field dependence of RS")
`MPRnb(THERSGO      ,2.0          ,""                                   ,"Transverse electric field dependence exponent of RS")
`MPRnb(RSBO         ,0.0          ,""                                   ,"Back bias dependence of RS")

//  Velocity saturation parameters
`MPRcz(THESATO      ,0.0          ,"s/m^2"                              ,"Geometry independent velocity saturation parameter at TR")
`MPRnb(THESATL      ,0.0          ,"s/m^2"                              ,"Length dependence of THESAT")
`MPRnb(THESATLEXP   ,1.0          ,""                                   ,"Exponent for length dependence of THESAT")
`MPRnb(THESATW      ,0.0          ,""                                   ,"Width dependence of THESAT")
`MPRnb(THESATLW     ,0.0          ,""                                   ,"Area dependence of THESAT")
`MPRnb(STTHESATO    ,-0.1         ,""                                   ,"Geometry independent temperature dependence of THESAT")
`MPRnb(STTHESATL    ,0.0          ,""                                   ,"Length dependence of STTHESAT")
`MPRnb(STTHESATW    ,0.0          ,""                                   ,"Width dependence of STTHESAT")
`MPRnb(STTHESATLW   ,0.0          ,""                                   ,"Area dependence of STTHESAT")
`MPRco(THESATGO     ,0.0          ,""         ,-0.5        ,inf         ,"Front gate bias dependence of velocity saturation")
`MPRco(THESATBO     ,0.0          ,""         ,-0.5        ,inf         ,"Back gate bias dependence of velocity saturation")

//  Saturation voltage parameters
`MPRnb(AXO          ,8.0          ,""                                   ,"Geometry independent linear/saturation transition exponent")
`MPRcz(AXL          ,0.0          ,""                                   ,"Length dependence of AX")
`MPRnb(AXLEXP       ,1.0          ,""                                   ,"Exponent for length dependence of AX")
`MPRcz(AXL2         ,0.0          ,""                                   ,"Second order length dependence of AX")
`MPRnb(AXLEXP2      ,1.5          ,""                                   ,"Exponent for second order length dependence of AX")

//  Channel length modulation (CLM) parameters
`MPRnb(ALPL1        ,0.0          ,""                                   ,"Length dependence of CLM pre-factor ALP")
`MPRnb(ALPLEXP      ,1.0          ,""                                   ,"Exponent for length dependence of ALP")
`MPRcz(ALPL2        ,0.0          ,""                                   ,"Second order length dependence of ALP")
`MPRnb(ALPLEXP2     ,2.0          ,""                                   ,"Exponent for second order length dependence of ALP")
`MPRnb(ALPW         ,0.0          ,""                                   ,"Width dependence of ALP")
`MPRnb(ALP1L1       ,0.0          ,"V"                                  ,"Length dependence of CLM enhancement factor above threshold ALP1")
`MPRnb(ALP1LEXP     ,0.5          ,""                                   ,"Exponent for length dependence of ALP1")
`MPRcz(ALP1L2       ,0.0          ,""                                   ,"Second order length dependence of ALP1")
`MPRnb(ALP1LEXP2    ,1.5          ,""                                   ,"Exponent for second order length dependence of ALP1")
`MPRnb(ALP1W        ,0.0          ,""                                   ,"Width dependence of ALP1")
`MPRnb(ALPBO        ,0.0          ,""                                   ,"Back bias dependence of channel length modulation")
`MPRco(VPO          ,0.05         ,"V"       ,1.0e-10      ,inf         ,"CLM logarithm dependence factor")
`MPRcz(VPGO         ,0.0          ,""                                   ,"Transverse electric field dependence of CLM logarithm factor")

//  Gate current parameters
`MPRcc(GCOO         ,0.0          ,""        ,-10.0        ,10.0        ,"Gate tunneling energy adjustment in inversion")
`MPRcz(IGINVLW      ,0.0          ,"A"                                  ,"Gate to channel current pre-factor for a channel area of WEN.LEN")
`MPRcz(IGOVINVW     ,0.0          ,"A"                                  ,"Gate to overlap current pre-factor for a width of WEN in inversion")
`MPRcz(IGOVINVDW    ,0.0          ,"A"                                  ,"Gate to overlap current pre-factor for a width of WEN in inversion at drain side")
`MPRcz(IGOVACCW     ,0.0          ,"A"                                  ,"Gate to overlap current pre-factor for a width of WEN in accumulation")
`MPRcz(IGOVACCDW    ,0.0          ,"A"                                  ,"Gate to overlap current pre-factor for a width of WEN in accumulation at drain side")
`MPRnb(STIGO        ,0.0          ,""                                   ,"Temperature dependence of all gate currents")
`MPRcc(GC2CHO       ,0.375        ,""        ,0.0          ,10.0        ,"Gate to channel current slope factor")
`MPRcc(GC3CHO       ,0.063        ,""        ,-2.0         ,2.0         ,"Gate to channel current curvature factor")
`MPRcc(GC2OVINVO    ,0.375        ,""        ,0.0          ,10.0        ,"Gate current slope factor for overlap regions in inversion mode")
`MPRcc(GC3OVINVO    ,0.063        ,""        ,-2.0         ,2.0         ,"Gate current curvature factor for overlap regions in inversion mode")
`MPRcc(GC2OVACCO    ,0.375        ,""        ,0.0          ,10.0        ,"Gate current slope factor for overlap regions in accumulation mode")
`MPRcc(GC3OVACCO    ,0.063        ,""        ,-2.0         ,2.0         ,"Gate current curvature factor for overlap regions in accumulation mode")
`MPRnb(GCDOVL       ,0.0          ,"V^-1"                               ,"Length dependence of high drain voltage dependence of overlap gate current")
`MPRnb(GCVDOVO      ,1.0          ,"V"                                  ,"Threshold of high drain voltage effect on overlap gate current")
`MPRco(CHIBO        ,3.1          ,"V"       ,1.0          ,inf         ,"Tunneling barrier height")
`MPRcz(NIGINVO      ,0.0          ,""                                   ,"Gate tunneling slope adjustment in subthreshold regime")
`MPRcz(FNOVINVW     ,0.0          ,"A"                                  ,"Extra gate to overlap current pre-factor for a width of WEN in inversion")
`MPRcz(FNOVINVDW    ,0.0          ,"A"                                  ,"Extra gate to overlap current pre-factor for a width of WEN in inversion at drain side")
`MPRcc(GCOVINVFNO   ,0.2          ,""        ,0.1          ,10.0        ,"Extra gate current slope factor for overlap regions in inversion mode")
`MPRnb(STIGFNO      ,0.0          ,""                                   ,"Temperature dependence of extra gate to overlap current")

//  Gate Induced Drain/Source Leakage (GIDL/GISL) parameters
`MPRnb(AGIDLO       ,0.0          ,"A/V^3"                              ,"GIDL geometry independent pre-factor")
`MPRnb(AGIDLDO      ,0.0          ,"A/V^3"                              ,"GIDL geometry independent pre-factor at drain side")
`MPRnb(AGIDLW       ,0.0          ,"A/V^3"                              ,"GIDL pre-factor for a width of WEN")
`MPRnb(AGIDLDW      ,0.0          ,"A/V^3"                              ,"GIDL pre-factor for a width of WEN at drain side")
`MPRcz(BGIDLO       ,41.0         ,"V"                                  ,"GIDL probability factor at TR")
`MPRcz(BGIDLDO      ,41.0         ,"V"                                  ,"GIDL probability factor at TR at drain side")
`MPRnb(STBGIDLO     ,0.0          ,"V/K"                                ,"Temperature dependence of BGIDL")
`MPRnb(STBGIDLDO    ,0.0          ,"V/K"                                ,"Temperature dependence of BGIDL at drain side")
`MPRnb(CGIDLO       ,0.0          ,"V^-1"                               ,"Substrate bias dependence of GIDL")
`MPRnb(CGIDLDO      ,0.0          ,"V^-1"                               ,"Substrate bias dependence of GIDL at drain side")
`MPRnb(DGIDLO       ,0.0          ,"V^-1"                               ,"High field geometry independent parameter of GIDL")
`MPRnb(DGIDLDO      ,0.0          ,"V^-1"                               ,"High field geometry independent parameter of GIDL at drain side")
`MPRnb(DGIDLL       ,0.0          ,"V^-1"                               ,"Length dependence of high longitudinal field parameter of GIDL")
`MPRnb(DGIDLDL      ,0.0          ,"V^-1"                               ,"Length dependence of high longitudinal field parameter of GIDL at drain side")

//  Edge transistor parameters
`MPRcz(WEDGE        ,1.0e-8       ,"m"                                  ,"Electrical width of edge transistor per side")
`MPRcz(WEDGEW       ,0.0          ,""                                   ,"Width dependence of WEDGE of edge transistors")
`MPRcz(CTEDGEO      ,0.0          ,""                                   ,"Interface states factor of edge transistors")
`MPRnb(VFBEDGEO     ,0.0          ,"V"                                  ,"Geometry-independent front gate flat-band voltage of edge transistors at TR")
`MPRnb(VFBEDGEL     ,0.0          ,"V"                                  ,"Length dependence of VFBEDGE")
`MPRnb(VFBEDGELEXP  ,2.0          ,""                                   ,"Exponent describing length dependence of VFBEDGE")
`MPRnb(VFBEDGEW     ,0.0          ,"V"                                  ,"Width dependence of VFBEDGE")
`MPRnb(VFBEDGELW    ,0.0          ,"V"                                  ,"Area dependence of VFBEDGE")
`MPRnb(VFBBEDGEO    ,0.0          ,"V"                                  ,"Geometry-independent back gate flat-band voltage of edge transistors at TR")
`MPRnb(STVFBEDGEO   ,0.0          ,"V/K"                                ,"Geometry-independent temperature dependence of VFBEDGE and VFBBEDGE")
`MPRnb(STVFBEDGEL   ,0.0          ,""                                   ,"Length dependence of STVFBEDGE")
`MPRnb(STVFBEDGEW   ,0.0          ,""                                   ,"Width dependence of STVFBEDGE")
`MPRnb(STVFBEDGELW  ,0.0          ,""                                   ,"Area dependence of STVFBEDGE")
`MPRcc(CICFEDGEO    ,1.0          ,""         ,0.1         ,10.0        ,"Long channel front interface coupling coefficient of edge transistors")
`MPRcc(CICEDGEO     ,1.0          ,""         ,0.1         ,10.0        ,"Long channel back interface coupling coefficient of edge transistors")
`MPRnb(PSCEEDGEL    ,0.0          ,""                                   ,"Length dependence of PSCEEDGE")
`MPRnb(PSCEEDGELEXP ,2.0          ,""                                   ,"Exponent describing length dependence of PSCEEDGE")
`MPRnb(PSCEEDGEW    ,0.0          ,""                                   ,"Width dependence of PSCEEDGE")
`MPRcz(PSCEBEDGEO   ,1.0          ,""                                   ,"Short channel back to front interface asymmetry factor of edge transistors")
`MPRnb(CFEDGEL      ,0.0          ,""                                   ,"Length dependence of DIBL-parameter of edge transistors")
`MPRnb(CFEDGELEXP   ,2.0          ,""                                   ,"Exponent for length dependence of CFEDGE")
`MPRnb(CFEDGEW      ,0.0          ,""                                   ,"Width dependence of CFEDGE")
`MPRcz(CFBEDGEO     ,1.0          ,""                                   ,"DIBL back to front interface asymmetry factor of edge transistors")
`MPRco(CFDEDGEO     ,0.2          ,"V"        ,0.05        ,inf         ,"Drain voltage dependence parameter of DIBL of edge transistors")
`MPRnb(FBETEDGE     ,0.0          ,""                                   ,"Length dependence of edge transistor mobility")
`MPRco(LPEDGE       ,1.0e-8       ,"m"        ,1.0e-10     ,inf         ,"Exponent for length dependence of edge transistor mobility")
`MPRnb(BETEDGEW     ,0.0          ,""                                   ,"Width scaling coefficient of edge transistor mobility")
`MPRnb(STBETEDGEO   ,1.0          ,""                                   ,"Geometry independent temperature dependence of BETNEDGE")
`MPRnb(STBETEDGEL   ,0.0          ,""                                   ,"Length dependence of temperature dependence of BETNEDGE")
`MPRnb(STBETEDGEW   ,0.0          ,""                                   ,"Width dependence of temperature dependence of BETNEDGE")
`MPRnb(STBETEDGELW  ,0.0          ,""                                   ,"Area dependence of temperature dependence of BETNEDGE")

//  Impact Ionization parameters
`MPRnb(A1O          ,1.0          ,""                                   ,"Geometry independent impact ionization pre-factor")
`MPRnb(A1L          ,0.0          ,""                                   ,"Length dependence of A1")
`MPRnb(A1W          ,0.0          ,""                                   ,"Width dependence of A1")
`MPRcz(A2O          ,10.0         ,""                                   ,"Impact ionization exponent at TR")
`MPRnb(STA2O        ,0.0          ,""                                   ,"Temperature dependence of A2")
`MPRnb(A3O          ,1.0          ,""                                   ,"Geometry independent saturation-voltage dependence of II")
`MPRnb(A3L          ,0.0          ,""                                   ,"Length dependence of A3")
`MPRnb(A3W          ,0.0          ,""                                   ,"Width dependence of A3")

//  Charge model parameters
`MPRnb(CGBOVO       ,0.0          ,"F"                                  ,"Geometry independent gate-substrate overlap capacitance part")
`MPRnb(CGBOVL       ,0.0          ,"F"                                  ,"Length dependent gate-substrate overlap capacitance part for a length of LEN")
`MPRcc(NSDACO       ,1.0e22       ,"cm^-3"   ,1.0e18       ,1.0e22      ,"Source/Drain effective doping level for AC model")
`MPRcz(FIFW         ,0.0          ,""                                   ,"Inner fringe capacitance prefactor for a width of WEN")
`MPRcz(FSCEACO      ,0.0          ,""                                   ,"Short channel effect adjustment factor for charge model")
`MPRnb(VFBACO       ,0.0          ,"V"                                  ,"Geometry-independent front gate flat-band voltage at TR when SWQMOD=1")
`MPRnb(VFBACL       ,0.0          ,"V"                                  ,"Length dependence of VFBAC")
`MPRnb(VFBACLEXP    ,2.0          ,""                                   ,"Exponent describing length dependence of VFBAC")
`MPRcz(VFBACL2      ,0.0          ,""                                   ,"Second order length dependence of VFBAC")
`MPRnb(VFBACLEXP2   ,2.0          ,""                                   ,"Exponent of second order length dependence of VFBAC")
`MPRnb(VFBACW       ,0.0          ,"V"                                  ,"Width dependence of VFBAC")
`MPRnb(VFBACLW      ,0.0          ,"V"                                  ,"Area dependence of VFBAC")
`MPRnb(VFBBACO      ,0.0          ,"V"                                  ,"Geometry-independent back gate flat-band voltage at TR when SWQMOD=1")
`MPRcz(VFBLBACO     ,0.0          ,""                                   ,"Roll-off back to front interface asymmetry factor when SWQMOD=1")
`MPRnb(PSCEACL      ,0.0          ,""                                   ,"Length dependence of PSCEAC")
`MPRnb(PSCEACLEXP   ,2.0          ,""                                   ,"Exponent describing length dependence of PSCEAC")
`MPRnb(PSCEACW      ,0.0          ,""                                   ,"Width dependence of PSCEAC")
`MPRnb(CFACL        ,0.0          ,""                                   ,"Length dependence of DIBL-parameter when SWQMOD=1")
`MPRnb(CFACLEXP     ,2.0          ,""                                   ,"Exponent for length dependence of CFAC")
`MPRnb(CFACW        ,0.0          ,""                                   ,"Width dependence of CFAC")
`MPRnb(THESATACO    ,0.0          ,"V^-1"                               ,"Geometry independent velocity saturation parameter at TR when SWQMOD=1")
`MPRnb(THESATACL    ,0.0          ,"V^-1"                               ,"Length dependence of THESATAC")
`MPRnb(THESATACLEXP ,1.0          ,""                                   ,"Exponent for length dependence of THESATAC")
`MPRnb(THESATACW    ,0.0          ,""                                   ,"Width dependence of THESATAC")
`MPRnb(THESATACLW   ,0.0          ,""                                   ,"Area dependence of THESATAC")
`MPRnb(AXACO        ,8.0          ,""                                   ,"Geometry independent linear/saturation transition exponent when SWQMOD=1")
`MPRcz(AXACL        ,0.0          ,""                                   ,"Length dependence of AXAC")
`MPRnb(AXACLEXP     ,1.0          ,""                                   ,"Exponent for length dependence of AXAC")
`MPRcz(AXACL2       ,0.0          ,""                                   ,"Second order length dependence of AXAC")
`MPRnb(AXACLEXP2    ,1.5          ,""                                   ,"Exponent for second order length dependence of AXAC")
`MPRnb(ALPACL1      ,0.0          ,""                                   ,"Length dependence of CLM pre-factor ALPAC when SWQMOD=1")
`MPRnb(ALPACLEXP    ,1.0          ,""                                   ,"Exponent for length dependence of ALPAC")
`MPRcz(ALPACL2      ,0.0          ,""                                   ,"Second order length dependence of ALPAC")
`MPRnb(ALPACLEXP2   ,2.0          ,""                                   ,"Exponent for second order length dependence of ALPAC")
`MPRnb(ALPACW       ,0.0          ,""                                   ,"Width dependence of ALPAC")
`MPRcz(LOVO         ,0.0          ,"m"                                  ,"Overlap length for gate/source-drain hdd overlap capacitance")
`MPRcz(LOVDO        ,0.0          ,"m"                                  ,"Overlap length for gate/drain hdd overlap capacitance")
`MPRnb(COVDLO       ,0.0          ,""                                   ,"Overlap capacitance modulation coefficient due to Leff variation")
`MPRnb(COVDLW       ,0.0          ,""                                   ,"Width dependence of COVDL")
`MPRnb(COVDLBO      ,0.0          ,""                                   ,"Overlap capacitance modulation with back bias")
`MPRnb(DVFBOVO      ,0.0          ,"V"                                  ,"Overlap capacitance flat-band voltage adjustment")
`MPRnb(CFRO         ,0.0          ,"F"                                  ,"Corner related outer fringe capacitance")
`MPRnb(CFRDO        ,0.0          ,"F"                                  ,"Corner related outer fringe capacitance at drain side")
`MPRnb(CFRW         ,0.0          ,"F"                                  ,"Outer fringe capacitance per side for a width of WEN")
`MPRnb(CFRDW        ,0.0          ,"F"                                  ,"Outer fringe capacitance per side for a width of WEN at drain side")
`MPRcz(CSDO         ,1.0          ,""                                   ,"Drain-source capacitance correction factor")
`MPRcz(CSDBPO       ,0.0          ,"F/m"                                ,"Drain/source to substrate perimeter capacitance")

//  Self heating parameters
`MPRcz(RTHO         ,1.0e05       ,"K/W"                                ,"Geometry independent thermal resistance")
`MPRnb(RTHL         ,1.5          ,""                                   ,"Length dependence of RTH")
`MPRnb(RTHW         ,3.0          ,""                                   ,"Width dependence of RTH")
`MPRnb(RTHLW        ,4.5          ,""                                   ,"Area dependence of RTH")
`MPRnb(STRTHO       ,0.0          ,""                                   ,"Temperature dependence of RTH")
`MPRcz(CTHO         ,1.0e-12      ,"J/K"                                ,"Geometry independent thermal capacitance")
`MPRco(LAMBTHO      ,1.0e-07      ,"m"       ,1.0e-09      ,inf         ,"Characteristic length of lateral thermal coupling for multifinger devices")
`MPRcz(FTHO         ,0.0          ,""                                   ,"First neighbour thermal coupling factor for multifinger devices")

//  Noise Parameters
`MPRcz(FNTO         ,1.0          ,""                                   ,"Thermal noise coefficient")
`MPRcz(FNTEXCL      ,0.0          ,""                                   ,"Length dependence coefficient of excess noise")
`MPRnb(FNTEXCLEXP   ,2.0          ,""                                   ,"Length dependence exponent of excess noise")
`MPRnb(NFALW        ,8.0e22       ,"V^-1/m^4"                           ,"Area dependence of first coefficient of flicker noise")
`MPRnb(NFAW         ,0.0          ,"V^-1/m^4"                           ,"Long channel first coefficient of flicker noise")
`MPRcz(NFBLW        ,3.0e07       ,"V^-1/m^2"                           ,"Area dependence of second coefficient of flicker noise")
`MPRcz(NFCLW        ,0.0          ,"V^-1"                               ,"Area dependence of third coefficient of flicker noise")
`MPRcc(NFEO         ,0.0          ,""        ,-1.0         ,1.0         ,"Flicker noise front transverse field effect coefficient")
`MPRcc(NFEBO        ,0.0          ,""        ,-1.0         ,1.0         ,"Flicker noise back transverse field effect coefficient")
`MPRco(EFO          ,1.0          ,""        ,0.1          ,inf         ,"Frequency coefficient of flicker noise")

//  General Stress Model Parameters
`MPIcc(SWSTRESS     ,1            ,""        ,0            ,2           ,"Stress model selection flag: 0=disable, 1=classical STI stress model, 2=strained channel stress model")
`MPRco(SAREF        ,1.0e-06      ,"m"       ,1.0e-09      ,inf         ,"Reference distance between OD-edge and poly from one side")
`MPRco(SBREF        ,1.0e-06      ,"m"       ,1.0e-09      ,inf         ,"Reference distance between OD-edge and poly from other side")

//  Stress Model Parameters for SWSTRESS=1
`MPRnb(WLOD         ,0.0          ,"m"                                  ,"Width parameter")
`MPRnb(KUO          ,0.0          ,"m"                                  ,"Mobility degradation/enhancement coefficient")
`MPRcc(KVSAT        ,0.0          ,""        ,-1.0         ,1.0         ,"Saturation velocity degradation/enhancement coefficient")
`MPRnb(TKUO         ,0.0          ,""                                   ,"Temperature dependence of KUO")
`MPRnb(LKUO         ,0.0          ,"m^LLODKUO"                          ,"Length dependence of KUO")
`MPRnb(WKUO         ,0.0          ,"m^WLODKUO"                          ,"Width dependence of KUO")
`MPRnb(PKUO         ,0.0          ,"m^(LLODKUO+WLODKUO)"                ,"Cross-term dependence of KUO")
`MPRcz(LLODKUO      ,0.0          ,""                                   ,"Length parameter for UO stress effect")
`MPRcz(WLODKUO      ,0.0          ,""                                   ,"Width parameter for UO stress effect")
`MPRnb(KVTHO        ,0.0          ,"Vm"                                 ,"Threshold shift parameter")
`MPRnb(LKVTHO       ,0.0          ,"m^LLODVTH"                          ,"Length dependence of KVTHO")
`MPRnb(WKVTHO       ,0.0          ,"m^WLODVTH"                          ,"Width dependence of KVTHO")
`MPRnb(PKVTHO       ,0.0          ,"m^(LLODVTH+WLODVTH)"                ,"Cross-term dependence of KVTHO")
`MPRcz(LLODVTH      ,0.0          ,""                                   ,"Length parameter for VTH-stress effect")
`MPRcz(WLODVTH      ,0.0          ,""                                   ,"Width parameter for VTH-stress effect")
`MPRnb(STETAO       ,0.0          ,"m"                                  ,"Eta0 shift factor related to VTHO change")
`MPRcz(LODETAO      ,1.0          ,""                                   ,"Eta0 shift modification factor for stress effect")

//  Stress Model Parameters for SWSTRESS=2
`MPRcc(STRLAMBDA    ,1.0e-07      ,"m"       ,1.0e-09      ,1.0e-05     ,"Relaxation characteristic length when SWSTRESS=2")
`MPRco(STRALPHA     ,3.0          ,""        ,0.5          ,inf         ,"Asymmetry parameter when SWSTRESS=2")
`MPRnb(STRDVFBO     ,0.0          ,"V"                                  ,"Threshold shift parameter when SWSTRESS=2")
`MPRnb(STRWDVFBO    ,0.0          ,""                                   ,"Width dependence of threshold shift parameter when SWSTRESS=2")
`MPRnb(STRDCFL      ,0.0          ,""                                   ,"DIBL variation parameter when SWSTRESS=2")
`MPRnb(STRRUO       ,0.0          ,""                                   ,"Mobility degradation/enhancement coefficient when SWSTRESS=2")
`MPRnb(STRTRUO      ,0.0          ,""                                   ,"Temperature dependence of mobility degradation/enhancement coefficient when SWSTRESS=2")
`MPRnb(STRRVSAT     ,0.0          ,""                                   ,"Saturation velocity degradation/enhancement coefficient when SWSTRESS=2")

//  NQS model parameters
`ifdef NQSmodel
    `MPRco(KDRIFTO         ,1.0          ,""        ,0.0         ,inf         ,"Geometry independent drift component parameter of NQS effect")
    `MPRnb(KDRIFTL         ,0.0          ,""                                  ,"Length dependence of KDRIFT")
    `MPRco(KDIFFO          ,1.0          ,""        ,0.0         ,inf         ,"Geometry independent diffusion component parameter of NQS effect")
    `MPRnb(KDIFFL          ,0.0          ,""                                  ,"Length dependence of KDIFF")
    `MPRcc(FRACINVO        ,1.0          ,""        ,0.0         ,1.0         ,"Geometry independent fraction of inversion charge for the second pole of the NQS transition")
    `MPRcc(KFRACINVO       ,1.0e-15      ,""        ,1.0e-15     ,1.0         ,"Geometry independent second pole frequency coefficient of the NQS transition")
`endif // NQSmodel

//  Parasitic resistance parameters
`MPRnb(RGO          ,0.0          ,"Ohm"                                ,"Gate resistance")
`MPRcz(RINT         ,0.0          ,"Ohm m^2"                            ,"Contact resistance between silicide and poly")
`MPRcz(RVPOLY       ,0.0          ,"Ohm m^2"                            ,"Vertical poly resistance")
`MPRcz(RSHG         ,0.0          ,"Ohm/sq"                             ,"Gate electrode diffusion sheet resistance")
`MPRnb(DLSIL        ,0.0          ,"m"                                  ,"Silicide extension over the physical gate length")
`MPRco(RSH          ,0.0          ,"Ohm/sq"   ,0.0         ,inf         ,"Sheet resistance of source diffusion")
`MPRco(RSHD         ,0.0          ,"Ohm/sq"   ,0.0         ,inf         ,"Sheet resistance of drain diffusion")
`MPRco(RWELLO       ,0.0          ,"Ohm"      ,0.0         ,inf         ,"Well resistance between node BI and B")

//  Variables
// *********************************************************************************************************************

//  Temporary variables
real temp, temp0, temp1, temp2, temp3, temp4;

//  Variables for model initializing
integer SWSHE_i;
real TKR, TKD;

//  Clipped instance parameters
real ASOURCE_i, ADRAIN_i, PSOURCE_i, PDRAIN_i, MULT_i_int;

//  Clipped local parameters including temperature dependence
real TSI_i, XGE_i, TYPESUB_i, CT_i, TOXP_i, NOV_i, NOVD_i, VFB1_i, VFB2_i, STVFB_i, NP_i, CIC1_i, CIC2_i, PSCE1_i;
real PSCE2_i, NSDDC_i, PSCEDLB_i, CF1_i, CF2_i, CS_i, STCF_i, CFD_i, CFDL_i, CFDLB_i, BETN1_i, BETN2_i, STBET_i, CSFI_i;
real CSBI_i, STCS_i, THECS_i, STTHECS_i, MUE_i, THEMU_i, STMUE_i, STTHEMU_i, XCOR_i, XCORB_i, STXCOR_i, RS_i, RSIG_i;
real STRS_i, RSG_i, THERSG_i, RSB_i, THESAT_i, STTHESAT_i, THESAT1_i, THESAT2_i, ALP_i, ALP1_i, ALPB_i, VP_i, VPG_i;
real IGINV_i, IGOVINV_i, IGOVINVD_i, IGOVACC_i, IGOVACCD_i, FNOVINV_i, FNOVINVD_i, GCO_i, STIG_i, STIGFN_i, GC2CH_i;
real GC3CH_i, GC2OVINV_i, GCOVINVFN_i, GC3OVINV_i, GC2OVACC_i, GC3OVACC_i, GCDOV_i, GCVDOV_i, CHIB_i, NIGINV_i, AGIDL_i;
real AGIDLD_i, BGIDL_i, BGIDLD_i, STBGIDL_i, STBGIDLD_i, CGIDL_i, CGIDLD_i, DGIDL_i, DGIDLD_i, CTEDGE_i, VFB1EDGE_i;
real VFB2EDGE_i, STVFBEDGE_i, CIC1EDGE_i, CIC2EDGE_i, PSCE1EDGE_i, PSCE2EDGE_i, CF1EDGE_i, CF2EDGE_i, CFDEDGE_i;
real BETNEDGE_i, STBETEDGE_i, A1_i, A2_i, STA2_i, A3_i, AREAQ_i, CGBOV_i, NSDAC_i, FIF_i, FSCEAC_i, VFBACO_i, VFBACL_i;
real VFBACLEXP_i, VFBACW_i, VFBACLW_i, VFBACL2_i, VFBACLEXP2_i, VFBBACO_i, VFBLBACO_i, VFBAC1_i, VFBAC2_i, PSCEACL_i;
real PSCEACLEXP_i, PSCEACW_i, PSCEAC1_i, PSCEAC2_i, CFACL_i, CFACLEXP_i, CFACW_i, CFAC1_i, CFAC2_i, THESATACO_i;
real THESATACL_i, THESATACLEXP_i, THESATACW_i, THESATACLW_i, THESATAC_i, AXACO_i, AXACL_i, AXACLEXP_i, AXACL2_i;
real AXACLEXP2_i, ALPACL1_i, ALPACLEXP_i, ALPACL2_i, ALPACLEXP2_i, ALPACW_i, ALPAC_i, COV_i, COVD_i, COVDL_i, COVDLB_i;
real DVFBOV_i, CFR_i, CFRD_i, CSD_i, CSDBP_i, RTH_i, STRTH_i, CTH_i, FNT_i, FNTEXC_i, NFA_i, NFB_i, NFC_i, NFE_i, NFEB_i;
real EF_i;
`ifdef NQSmodel
    real KDRIFT_i, KDIFF_i, FRACINV_i, KFRACINV_i;
`endif // NQSmodel

//  Clipped local parameters without temperature dependence
real VFB1_t, VFB2_t, VFBAC1_t, VFBAC2_t, CF1_t, CF2_t, CFAC1_t, CFAC2_t, BETN1_t, BETN2_t, MUE_t, THEMU_t, CS_t, THECS_t;
real XCOR_t, RS_t, THESAT_t, THESATAC_t, IGINV_t, IGOVINV_t, IGOVINVD_t, IGOVACC_t, IGOVACCD_t, FNOVINV_t, FNOVINVD_t;
real BGIDL_t, BGIDLD_t, A2_t, VFB1EDGE_t, VFB2EDGE_t, BETNEDGE_t, RTH_t;

//  Variables used in the global scaling part
real gamAX, gamAX_ac;

//  Variables used in the initializeInstance part
real TKC, TKC_sq, DTC, dT, rT, rTn, phit0, inv_phit0, xsatmax, phit, inv_phit, one_m_xge, epsch, EgSi, EgGe, dEg, Eg;
real Eg_2phit0, Eg_2phit0_woshe, Eg_2phit, dVfbch, niratio, Cox1Init, Cox2Init, Cox1Prime, Cox2Prime, dVfb1Nch, dVfb2Nch;
real CsiPrime_0, k1_1D, k2_1D, keq_1D, dVfbpdep, KP, neff_poly, neff, A0_Csisq, xth_1D, xSDdep, dVfbQM, emin, qq, tsisq;
real Gfsub, Gfsub2, inv_Gfsub2, xisub, inv_xisub, margin_sub, xn_sub, fmue, inv_qi1cs, inv_qi2cs, eta_mu, one_m_eta, frs;
real sat_phit, sat_phit_ac, alp1_phit, inv_CHIB, tempM, BCH, BOV, GCQCH, GCQOVINV, GCQOVACC, alpha_b, Dch, Dov, n_iginv;
real area_phit, phit_edge, inv_phit_edge, A0_Csisq_edge, inner_sd, xsd, fif_phit,lambda2D, lnrTn, tf_bet, tf_mue, tf_themu;
real tf_cs, tf_thecs, tf_xcor, tf_ther, tf_thesat, tf_ig, tf_rth, nt0_4KT, nt, nt0, fac_exc;
//  Internal variables used for Parasitic resistance
real RG_p, RG_i, L_f, L_slif, W_f, XGWE, ggate, rgatenoise;
real RSE_i, RSH_i, gsource, rsourcenoise;
real RDE_i, RSHD_i, gdrain, rdrainnoise;
real RWELL_i, gwell, rwellnoise;

//  Variables used in the evaluateStatic and evaluateDynamic parts
// *********************************************************************************************************************
real xd0, Vgsu, Vsbu, Vgdu, Vdbu, sigVds, Vgs, Vds, Vsb, Vgb, xd, xdsx, dxdsx, betneff, dL1_L, FdL, Gvsat;
real qmfact, fact_Ids, Ids, Vovscv, Vovdcv, Igc, Igs, Igd, Igidl, Igisl, Ids_edge, mavl, Iimpact, Ithpwr, Ithrc, Qg, Qb;
real Qd, Qs, Idse, Igse, Igde, Igidle, Igisle, Qgse, Qgde, Qovs, Qovd, Qgbe, Qdse, Qdsub, Qssub, Qth, Qgsif, Qgdif;
real Qbsif, Qbdif, xg20shift_dc, diff_min_dc, A0_dc, inv_k1_dc, inv_k2_dc, keq_dc, Dx_WI_dc, CsiPrime_dc, Dx_WI_1D_dc;
real q1s_dc, dleff_dc, xedge_dc, sce1_dc, sce2_dc, dxg1_dibl_dc, xg2_dc, xg2x_dc, xg1x_dc, k1_dc, k2_dc, qis_dc;
real k1q1s_dc, k2q2s_dc, xdrifts_dc, ds_dc, k1q1d_dc, k2q2d_dc, xndssat_dc, xdeff_dc, q1d_dc, qid_dc, xdriftd_dc, qim_dc;
real ratio_pd_dc, esurf1_dc, esurf2_dc, qi1m_dc, qi2m_dc, csum_dc, Gmob_dc, inv_qimstar1_dc, dL_L_fact_dc, GdL_dc;
real vsat_fact_dc, Ggamma_dc, zsat_dc, hsat_dc, qmfact1_dc, qmfact2_dc, dd_dc, norm_Ids_dc, inv_k1h1_dc, inv_k1h1_0_dc;
real delta_k1q1_dc, delta_k2q2_dc, prod1_dc, prod2_dc, xg20shift_ac, diff_min_ac, A0_ac, inv_k1_ac, inv_k2_ac, keq_ac;
real Dx_WI_ac, CsiPrime_ac, Dx_WI_1D_ac, dleff_ac, xedge_ac, sce1_ac, sce2_ac, dxg1_dibl_ac, xg2_ac, xg2x_ac, k1_ac, k2_ac;
real k1q1s_ac, k2q2s_ac, xdrifts_ac, k1q1d_ac, k2q2d_ac, xdriftd_ac, qim_ac, ratio_pd_ac, qi1m_ac, qi2m_ac, zsat_ac;
real qmfact1_ac, qmfact2_ac, delta_k1q1_ac, delta_k2q2_ac, prod1_ac, prod2_ac;

//  Gmin variable
real gmin;

//  Variables for operating point (.op)
`ifdef OP_CALC
    `OPP(type              ,""             ,"Flag for channel type")
    `OPP(vds               ,"V"            ,"Internal drain-source DC voltage (NMOS convention)")
    `OPP(vsb               ,"V"            ,"Internal source-bulk DC voltage (NMOS convention)")
    `OPP(vgs               ,"V"            ,"Internal gate-source DC voltage (NMOS convention)")
    `OPP(vth               ,"V"            ,"Threshold voltage")
    `OPP(vthac             ,"V"            ,"Threshold voltage of the charge model")
    `OPP(vth_drive         ,"V"            ,"Effective gate drive voltage, including back bias, drain bias effects and self-heating")
    `OPP(vdsat             ,"V"            ,"Drain saturation voltage at the given bias")
    `OPP(vdsat_marg        ,"V"            ,"Vds voltage margin")
    `OPM(id                ,"A"            ,"Total DC drain current flowing into drain terminal")
    `OPM(ig                ,"A"            ,"Total DC gate current flowing into gate terminal")
    `OPM(is                ,"A"            ,"Total DC source current flowing into source terminal")
    `OPM(ib                ,"A"            ,"Total DC bulk current flowing into bulk terminal")
    `OPM(ids               ,"A"            ,"DC channel current, excluding tunnel, GISL and GIDL currents")
    `OPM(igidl             ,"A"            ,"DC Gate Induced Drain Leakage current")
    `OPM(igisl             ,"A"            ,"DC Gate Induced Source Leakage current")
    `OPM(igs               ,"A"            ,"DC gate-source leakage current")
    `OPM(igd               ,"A"            ,"DC gate-drain leakage current")
    `OPM(idb               ,"A"            ,"DC drain-bulk current")
    `OPM(isb               ,"A"            ,"DC source-bulk current")
    `OPM(iavl              ,"A"            ,"Substrate current due to weak avelanche")
    `OPM(idsedge           ,"A"            ,"Drain current of edge transistors")
    `OPM(gm                ,"A/V"          ,"Internal DC transconductance")
    `OPM(gmb               ,"A/V"          ,"Internal DC bulk transconductance")
    `OPM(gds               ,"A/V"          ,"Internal DC output conductance")
    `OPM(cgg               ,"F"            ,"Internal AC gate capacitance, including overlap capacitances")
    `OPM(cgd               ,"F"            ,"Internal AC gate-drain transcapacitance, including overlap capacitances")
    `OPM(cgs               ,"F"            ,"Internal AC gate-source transcapacitance, including overlap capacitances")
    `OPM(cgb               ,"F"            ,"Internal AC gate-bulk transcapacitance")
    `OPM(cdd               ,"F"            ,"Internal AC drain capacitance")
    `OPM(cdg               ,"F"            ,"Internal AC drain-gate transcapacitance")
    `OPM(cds               ,"F"            ,"Internal AC drain-source transcapacitance")
    `OPM(cdb               ,"F"            ,"Internal AC drain-bulk transcapacitance")
    `OPM(cbb               ,"F"            ,"Internal AC bulk capacitance")
    `OPM(cbg               ,"F"            ,"Internal AC bulk-gate transcapacitance")
    `OPM(cbs               ,"F"            ,"Internal AC bulk-source transcapacitance")
    `OPM(cbd               ,"F"            ,"Internal AC bulk-drain transcapacitance")
    `OPM(css               ,"F"            ,"Internal AC source capacitance")
    `OPM(csg               ,"F"            ,"Internal AC source-gate transcapacitance")
    `OPM(csb               ,"F"            ,"Internal AC source-bulk transcapacitance")
    `OPM(csd               ,"F"            ,"Internal AC source-drain transcapacitance")
    `OPP(tk                ,"K"            ,"MOSFET device temperature")
    `OPP(dtsh              ,"K"            ,"MOSFET device temperature increase due to self-heating")
    `OPP(self_gain         ,""             ,"Internal L-UTSOI model self gain")
    `OPD(rout              ,"Ohm"          ,"AC output resistance")
    `OPM(beff              ,"A/V^2"        ,"Gain factor in saturation")
    `OPP(ft                ,"Hz"           ,"Unity gain frequency at the given bias")
    `OPD(rgate             ,"Ohm"          ,"MOS gate resistance (intrinsic input resistance)")
    `OPD(rdrain            ,"Ohm"          ,"External drain resistance")
    `OPD(rsource           ,"Ohm"          ,"External source resistance")
    `OPD(rbwell            ,"Ohm"          ,"Well resistance")
    `OPP(gmoverid          ,"1/V"          ,"Gm over Id")
    `OPP(vearly            ,"V"            ,"Equivalent Early voltage")
`endif

//  Analog block
// *********************************************************************************************************************
analog begin

    //  Initialize Model
    //  **************************************************************************************************************
    begin : initializeModel

    // *********** Transistor temperature ***********
        TKR     =  273.15 + TR;
        temp    =  min($temperature + DTEMP, 1000.0);
        if (SWCRYO == 1) begin
            TKD        = `MAX_FUNC(temp, TMIN + ATMIN * temp, BTMIN);
            xsatmax    = `MAX_FUNC(10.0 / (TKD * `KBOL_QELE) , `XSAT_MAX, 0.01);
        end else begin
            TKD        = `MAX_FUNC(temp, 1.0, 1.0e-3);
            xsatmax    = `XSAT_MAX;
        end

    // *********** Flag for self-heating effect ***********
        if (((SWSCALE == 0) && (RTH > 0.0)) || ((SWSCALE > 0) && (RTHO > 0.0))) begin
            SWSHE_i    =  SWSHE;
        end else begin
            SWSHE_i    =  0;
        end

    // *********** Gmin definition ***********
        gmin    =  $simparam("gmin",0.0);

    // *********** Tnode optional instance ***********
        if ($port_connected(Tnode));

    end    // initializeModel

    //  Initialize Instance
    //  **************************************************************************************************************
    begin : initializeInstance

    // *********** Declaration of local variables ***********
        real W_i, TOX1_i, TOX2_i, TYPECH_i, NCH_i, NSUB_i, PNCE_i, CSTHR_i, CSTHRB_i, FETA_i, AX_i, AXAC_i;
        real PSCE_p, PSCEAC_p, CF_p, CFAC_p, BETN_p, PNCE_p, CS_p, RS_p, THESAT_p, THESATAC_p, AX_p, AXAC_p, ALPAC_p;
        real ALP_p, ALP1_p, AGIDL_p, AGIDLD_p, A1_p, A3_p, CGBOV_p, CFR_p, CFRD_p, RTH_p, CTH_p, NFA_p;
        real LEN, WEN, iL, iW, delLPS, delWOD, LE, WE, LEcv, WEcv, iLE, iWE, iAE, lphy, wphy, lambda_LE, GPE, GWE, GE;
        real invNF, WE_edge, neff_sub, xb_sub;
        real tmpa, tmpb, iloop, Invsa, Invsb, Invsaref, Invsbref, Lx, Wx, templ, tempw;
        real Kstressu0, rhobeta, rhobetaref, Kstressvth0, temp0, str_g, str_gref, ruo;

    // *********** Initializing channel temperature ***********
        DTC          =  0.0;
        TKC          =  TKD;
        TKC_sq       =  TKC * TKC;
        dT           =  TKC - TKR;
        rT           =  TKC / TKR;
        rTn          =  TKR / TKC;
        phit0        =  TKC * `KBOL_QELE;
        inv_phit0    =  1.0 / phit0;

     // *********** Calculation of local parameters ***********
        if (SWSCALE == 0) begin    //  Local mode
            //  Instance parameters used in local mode
            ADRAIN_i     =  ADRAIN;
            ASOURCE_i    =  ASOURCE;
            PDRAIN_i     =  PDRAIN;
            PSOURCE_i    =  PSOURCE;
            MULT_i_int   =  MULT;
            //  Process parameters
            TOX1_i       =  TOXE;
            TSI_i        =  TSI;
            XGE_i        =  XGE;
            TOX2_i       =  TBOX;
            TYPECH_i     =  1.0;         // P-type thin film
            if (NCH < 0) begin         // N-type thin film
                TYPECH_i     = -1.0;
            end
            NCH_i        =  min(abs(NCH), 1.0e19) * 1.0e6;
            TYPESUB_i    =  1.0;         // P-type substrate
            if (NSUB < 0) begin        // N-type thin film
                TYPESUB_i    = -1.0;
            end
            NSUB_i       =  min(max(abs(NSUB), 1.0e16), 1.0e21) * 1.0e6;
            CT_i         =  CT;
            TOXP_i       =  TOXP;
            NOV_i        =  NOV * 1.0e6;
            NOVD_i       =  NOVD * 1.0e6;
            VFB1_t       =  VFB;
            VFB2_t       =  VFBB;
            STVFB_i      =  STVFB;
            NP_i         =  NP * 1.0e6;
            //  Gate to interface coupling parameters
            CIC1_i       =  CICF;
            CIC2_i       =  CIC;
            PSCE1_i      =  PSCE;
            PSCE2_i      =  PSCEB * PSCE1_i * TOX2_i / TOX1_i;
            NSDDC_i      =  NSDDC * 1.0e6;
            PSCEDLB_i    =  PSCEDLB;
            PNCE_i       =  PNCE;
            //  DIBL parameters
            CF1_t        =  CF;
            CF2_t        =  CFB * CF1_t * TOX2_i / TOX1_i;
            STCF_i       =  STCF;
            CFD_i        =  CFD;
            CFDL_i       =  CFDL;
            CFDLB_i      =  CFDLB;
            //  Mobility parameters
            BETN1_t      =  BETN;
            BETN2_t      =  BETNB * BETN1_t;
            STBET_i      =  STBET;
            CS_t         =  CS;
            CSFI_i       =  CSFI;
            CSBI_i       =  CSBI;
            STCS_i       =  STCS;
            THECS_t      =  THECS;
            STTHECS_i    =  STTHECS;
            CSTHR_i      =  CSTHR;
            CSTHRB_i     =  CSTHRB;
            MUE_t        =  MUE;
            STMUE_i      =  STMUE;
            THEMU_t      =  THEMU;
            STTHEMU_i    =  STTHEMU;
            XCOR_t       =  XCOR;
            XCORB_i      =  XCORB;
            STXCOR_i     =  STXCOR;
            FETA_i       =  FETA;
            //  Series resistance parameters
            RS_t         =  RS;
            RSIG_i       =  RSIG;
            STRS_i       =  STRS;
            RSG_i        =  RSG;
            THERSG_i     =  THERSG;
            RSB_i        =  RSB;
            //  Velocity saturation parameters
            THESAT_t     =  THESAT;
            STTHESAT_i   =  STTHESAT;
            THESAT1_i    =  THESATG;
            THESAT2_i    =  THESATB;
            //  Saturation voltage parameters
            AX_i         =  AX;
            //  Channel length modulation (CLM) parameters
            ALP_i        =  ALP;
            ALP1_i       =  ALP1;
            ALPB_i       =  ALPB;
            VP_i         =  VP;
            VPG_i        =  VPG;
            //  Gate current parameters
            GCO_i        =  GCO;
            IGINV_t      =  IGINV;
            IGOVINV_t    =  IGOVINV;
            IGOVINVD_t   =  IGOVINVD;
            FNOVINV_t    =  FNOVINV;
            FNOVINVD_t   =  FNOVINVD;
            IGOVACC_t    =  IGOVACC;
            IGOVACCD_t   =  IGOVACCD;
            STIG_i       =  STIG;
            STIGFN_i     =  STIGFN;
            GC2CH_i      =  GC2CH;
            GC3CH_i      =  GC3CH;
            GC2OVINV_i   =  GC2OVINV;
            GCOVINVFN_i  =  GCOVINVFN;
            GC3OVINV_i   =  GC3OVINV;
            GC2OVACC_i   =  GC2OVACC;
            GC3OVACC_i   =  GC3OVACC;
            GCDOV_i      =  GCDOV;
            GCVDOV_i     =  GCVDOV;
            CHIB_i       =  CHIB;
            NIGINV_i     =  NIGINV;
            //  Gate Induced Drain/Source Leakage (GIDL/GISL) parameters
            AGIDL_i      =  AGIDL;
            AGIDLD_i     =  AGIDLD;
            BGIDL_t      =  BGIDL;
            BGIDLD_t     =  BGIDLD;
            STBGIDL_i    =  STBGIDL;
            STBGIDLD_i   =  STBGIDLD;
            CGIDL_i      =  CGIDL;
            CGIDLD_i     =  CGIDLD;
            DGIDL_i      =  DGIDL;
            DGIDLD_i     =  DGIDLD;
            //  Impact ionization parameters
            A1_i         =  A1;
            A2_t         =  A2;
            STA2_i       =  STA2;
            A3_i         =  A3;
            //  Edge transistor parameters
            CTEDGE_i     =  CTEDGE;
            VFB1EDGE_t   =  VFBEDGE;
            VFB2EDGE_t   =  VFBBEDGE;
            STVFBEDGE_i  =  STVFBEDGE;
            CIC1EDGE_i   =  CICFEDGE;
            CIC2EDGE_i   =  CICEDGE;
            PSCE1EDGE_i  =  PSCEEDGE;
            PSCE2EDGE_i  =  PSCEBEDGE * PSCE1EDGE_i * TOX2_i / TOX1_i;
            CF1EDGE_i    =  CFEDGE;
            CF2EDGE_i    =  CFBEDGE * CF1EDGE_i * TOX2_i / TOX1_i;
            CFDEDGE_i    =  CFDEDGE;
            BETNEDGE_t   =  BETNEDGE;
            STBETEDGE_i  =  STBETEDGE;
            //  Charge model parameters
            AREAQ_i      =  AREAQ;
            CGBOV_i      =  CGBOV;
            NSDAC_i      =  NSDAC * 1.0e6;
            FIF_i        =  FIF;
            FSCEAC_i     =  FSCEAC;
            VFBAC1_t     =  VFB1_t;
            VFBAC2_t     =  VFB2_t;
            PSCEAC1_i    =  PSCE1_i;
            PSCEAC2_i    =  PSCE2_i;
            CFAC1_t      =  CF1_t;
            CFAC2_t      =  CF2_t;
            THESATAC_t   =  THESAT_t;
            AXAC_i       =  AX_i;
            ALPAC_i      =  ALP_i;
            if (SWQMOD > 0) begin
                `DefACparam(VFBAC1_t, VFB, VFBAC)
                `DefACparam(VFBAC2_t, VFBB, VFBBAC)
                `DefACparam(PSCEAC1_i, PSCE, PSCEAC)
                PSCEAC2_i    =  PSCEB * PSCEAC1_i * TOX2_i / TOX1_i;
                `DefACparam(CFAC1_t, CF, CFAC)
                CFAC2_t      =  CFB * CFAC1_t * TOX2_i / TOX1_i;
                `DefACparam(THESATAC_t, THESAT, THESATAC)
                `DefACparam(AXAC_i, AX, AXAC)
                `DefACparam(ALPAC_i, ALP, ALPAC)
            end
            COV_i        =  COV;
            COVD_i       =  COVD;
            COVDL_i      =  COVDL;
            COVDLB_i     =  COVDLB;
            DVFBOV_i     =  DVFBOV;
            CFR_i        =  CFR;
            CFRD_i       =  CFRD;
            CSD_i        =  CSD;
            CSDBP_i      =  CSDBP;
            //  Self heating parameters
            RTH_t        =  RTH;
            STRTH_i      =  STRTH;
            CTH_i        =  CTH;
            //  Noise model parameters
            FNT_i        =  FNT;
            FNTEXC_i     =  FNTEXC;
            NFA_i        =  NFA;
            NFB_i        =  NFB;
            NFC_i        =  NFC;
            NFE_i        =  NFE;
            NFEB_i       =  NFEB;
            EF_i         =  EF;
            //  NQS model parameters
`ifdef NQSmodel
                KDRIFT_i     =  KDRIFT;
                KDIFF_i      =  KDIFF;
                FRACINV_i    =  FRACINV;
                KFRACINV_i   =  KFRACINV;
`endif // NQSmodel
            //  Parasitic resistance parameters
            RG_i       =  RG;
            RSE_i      =  RSE;
            RDE_i      =  RDE;
            RWELL_i    =  RWELL;
        end else begin    //  Global mode
            //  Clipping of instance parameters used only in global mode
            invNF        =  1.0 / NF;
            W_i          =  max(W * invNF, 1.0e-9);
            //  Instance parameters used in local mode
            ADRAIN_i     =  ADRAIN * invNF;
            ASOURCE_i    =  ASOURCE * invNF;
            PDRAIN_i     =  PDRAIN * invNF;
            PSOURCE_i    =  PSOURCE * invNF;
            MULT_i_int   =  MULT * NF;
            //  Scaling parameters
            LEN          =  1.0e-6;
            WEN          =  1.0e-6;
            iL           =  LEN / L;
            iW           =  WEN / W_i;
            delLPS       =  LVARO * (1.0 + LVARL * iL) * (1.0 + LVARW * iW);
            delWOD       =  WVARO * (1.0 + WVARW * iW) * (1.0 + WVARL * iL);
            LE           =  max((L + delLPS - 2.0 * LAP), 1.0e-9);
            WE           =  max((W_i + delWOD - 2.0 * WOT), 1.0e-9);
            LEcv         =  max((L + delLPS - 2.0 * LAP + DLQ), 1.0e-9);
            WEcv         =  max((W_i + delWOD - 2.0 * WOT + DWQ), 1.0e-9);
            iLE          =  LEN / LE;
            iWE          =  WEN / WE;
            iAE          =  iLE * iWE;
            temp         =  max((L + delLPS), 1.0e-9);
            lphy         =  temp / LEN;
            temp         =  max((W_i + delWOD), 1.0e-9);
            wphy         =  temp / WEN;
            //  Scaling parameters for Parasitic resistance
            L_f        =  max(L + delLPS, 1.0e-09);
            L_slif     =  max(L_f + DLSIL, 1.0e-09);
            W_f        =  max(W_i + delWOD, 1.0e-09);
            XGWE       =  max(XGW - 0.5 * delWOD, 1.0e-09);
            //  Process parameters
            TOX1_i       =  TOXEO;
            TSI_i        =  TSIO;
            XGE_i        =  XGEO;
            TOX2_i       =  TBOXO;
            TYPECH_i     =  1.0;          // P-type thin film
            if (NCHO < 0) begin         // N-type thin film
                TYPECH_i     = -1.0;
            end
            NCH_i        =  min(abs(NCHO), 1.0e19) * 1.0e6;
            TYPESUB_i    =  1.0;          // P-type substrate
            if (NSUBO < 0) begin        // N-type thin film
                TYPESUB_i    = -1.0;
            end
            NSUB_i       =  min(max(abs(NSUBO), 1.0e16), 1.0e21) * 1.0e6;
            CT_i         =  CTO;
            TOXP_i       =  TOXPO;
            NOV_i        =  NOVO * 1.0e6;
            NOVD_i       =  NOVDO * 1.0e6;
            temp         =  VFBL * pow(iLE, VFBLEXP) / (1.0 + VFBL2 * pow(iLE, VFBLEXP2));
            VFB1_t       =  VFBO + temp + VFBW * iWE + VFBLW * iAE;
            VFB2_t       =  VFBBO + VFBLBO * TOX2_i / TOX1_i * temp;
            STVFB_i      =  STVFBO * (1.0 + STVFBL * iLE) * (1.0 + STVFBW * iWE) * (1.0 + STVFBLW * iAE);
            temp0        =  NPO * (1.0 + NPL * iLE) * 1.0e6;
            NP_i         =  min(max(temp0, 1.0e25), 1.0e28);
            //  Gate to interface coupling parameters
            CIC1_i       =  CICFO;
            CIC2_i       =  CICO;
            one_m_xge    =  1.0 - XGE_i;
            epsch        = `EPSSI * one_m_xge + `EPSGE * XGE_i;
            lambda_LE    =  sqrt(epsch / `EPSOX * TSI_i * (TOX1_i + 4.0e-10)) / LE;
            PSCE_p       =  PSCEL * 2.0 * pow(lambda_LE, PSCELEXP) * (1.0 + PSCEW * iWE);
            PSCE1_i      =  min(max(PSCE_p, 0.0), 5.0);
            PSCE2_i      =  PSCEBO * PSCE1_i * TOX2_i / TOX1_i;
            NSDDC_i      =  NSDDCO * 1.0e6;
            PSCEDLB_i    =  PSCEDLBO;
            PNCE_p       =  PNCEW * iWE;
            PNCE_i       =  min(max(PNCE_p, -1.0), 1.0);
            //  DIBL parameters
            temp         =  pow(lambda_LE, CFLEXP) * (1.0 + CFW * iWE);
            CF_p         =  CFL * temp;
            CF1_t        =  max(CF_p, 0.0);
            CF2_t        =  CFBO * CF1_t * TOX2_i / TOX1_i;
            STCF_i       =  STCFL * temp;
            CFD_i        =  CFDO;
            CFDL_i       =  CFDLL * iLE / max(1.0 + CFDLW * iWE, 1.0e-3);
            CFDLB_i      =  CFDLBO;
            //  Mobility parameters
            temp1        = -LE / (LP1 * max(1.0 + LP1W * iWE, 1.0e-3));
            `linmin_exp(temp1,temp2)
            temp3        = -LE / LP2;
            `linmin_exp(temp3,temp4)
            GPE          =  max(1.0 + FBET1 * (1.0 + FBET1W * iWE) * (temp2 - 1.0) / temp1 + FBET2 * (temp4 - 1.0) / temp3, 1.0e-6);
            GWE          =  max(1.0 + BETW1 * iWE + BETW2 * iWE * ln(1.0 + WE / WBET), 1.0e-6);
            GE           =  UO / GPE * GWE;
            BETN_p       =  GE * WE / LE;
            BETN1_t      =  max(BETN_p, 1.0e-10);
            BETN2_t      =  BETNBO * BETN1_t;
            STBET_i      =  STBETO * (1.0 + STBETL * iLE) * (1.0 + STBETW * iWE) * (1.0 + STBETLW * iAE);
            CS_p         =  (CSO + CSL * pow(iLE, CSLEXP)) * (1.0 + CSW * iWE) * (1.0 + CSLW * iAE);
            CS_t         =  max(CS_p, 0.0);
            CSFI_i       =  CSFIO;
            CSBI_i       =  CSBIO;
            STCS_i       =  STCSO * (1.0 + STCSL * iLE) * (1.0 + STCSW * iWE) * (1.0 + STCSLW * iAE);
            THECS_t      =  THECSO;
            STTHECS_i    =  STTHECSO;
            CSTHR_i      =  CSTHRO;
            CSTHRB_i     =  CSTHRBO;
            MUE_t        =  MUEO;
            STMUE_i      =  STMUEO;
            THEMU_t      =  THEMUO;
            STTHEMU_i    =  STTHEMUO;
            XCOR_t       =  (XCORO + XCORL * pow(iLE, XCORLEXP)) * (1.0 + XCORW * iWE) * (1.0 + XCORLW * iAE);
            XCORB_i      =  XCORBO;
            STXCOR_i     =  STXCORO;
            FETA_i       =  FETAO;
            //  Series resistance parameters
            RS_p         =  RSW1 * iWE * (1.0 + RSW2 * iWE);
            RS_t         =  max(RS_p, 0.0);
            RSIG_i       =  RSIGO;
            STRS_i       =  STRSO;
            RSG_i        =  RSGO;
            THERSG_i     =  THERSGO;
            RSB_i        =  RSBO;
            //  Velocity saturation parameters
            THESAT_p     =  GE * (THESATO + THESATL * pow(iLE, THESATLEXP)) * (1.0 + THESATW * iWE) * (1.0 + THESATLW * iAE);
            THESAT_t     =  max(THESAT_p, 0.0);
            STTHESAT_i   =  STTHESATO * (1.0 + STTHESATL * iLE) * (1.0 + STTHESATW * iWE) * (1.0 + STTHESATLW * iAE);
            THESAT1_i    =  THESATGO;
            THESAT2_i    =  THESATBO;
            //  Saturation voltage parameters
            AX_p         =  AXO / (1.0 + AXL * pow(iLE, AXLEXP) / (1.0 + AXL2 * pow(iLE, AXLEXP2)));
            AX_i         =  min(max(AX_p, 1.0), 16.0);
            //  Channel length modulation (CLM) parameters
            ALP_p        =  ALPL1 * pow(iLE, ALPLEXP) * (1.0 + ALPW * iWE) / (1.0 + ALPL2 * pow(iLE, ALPLEXP2));
            ALP_i        =  max(ALP_p, 0.0);
            ALP1_p       =  ALP1L1 * pow(iLE, ALP1LEXP) * (1.0 + ALP1W * iWE) / (1.0 + ALP1L2 * pow(iLE, ALP1LEXP2));
            ALP1_i       =  max(ALP1_p, 0.0);
            ALPB_i       =  ALPBO;
            VP_i         =  VPO;
            VPG_i        =  VPGO;
            //  Gate current parameters
            GCO_i        =  GCOO;
            IGINV_t      =  IGINVLW / iAE;
            IGOVINV_t    =  IGOVINVW / iWE;
            IGOVINVD_t   =  IGOVINVDW / iWE;
            FNOVINV_t    =  FNOVINVW / iWE;
            FNOVINVD_t   =  FNOVINVDW / iWE;
            IGOVACC_t    =  IGOVACCW / iWE;
            IGOVACCD_t   =  IGOVACCDW / iWE;
            STIG_i       =  STIGO;
            STIGFN_i     =  STIGFNO;
            GC2CH_i      =  GC2CHO;
            GC3CH_i      =  GC3CHO;
            GC2OVINV_i   =  GC2OVINVO;
            GCOVINVFN_i  =  GCOVINVFNO;
            GC3OVINV_i   =  GC3OVINVO;
            GC2OVACC_i   =  GC2OVACCO;
            GC3OVACC_i   =  GC3OVACCO;
            GCDOV_i      =  GCDOVL * iLE;
            GCVDOV_i     =  GCVDOVO;
            CHIB_i       =  CHIBO;
            NIGINV_i     =  NIGINVO;
            //  Gate Induced Drain/Source Leakage (GIDL/GISL) parameters
            AGIDL_p      =  AGIDLO + AGIDLW / iWE;
            AGIDL_i      =  max(AGIDL_p, 0.0);
            AGIDLD_p     =  AGIDLDO + AGIDLDW / iWE;
            AGIDLD_i     =  max(AGIDLD_p, 0.0);
            BGIDL_t      =  BGIDLO;
            BGIDLD_t     =  BGIDLDO;
            STBGIDL_i    =  STBGIDLO;
            STBGIDLD_i   =  STBGIDLDO;
            CGIDL_i      =  CGIDLO;
            CGIDLD_i     =  CGIDLDO;
            DGIDL_i      =  DGIDLO + DGIDLL * iLE;
            DGIDLD_i     =  DGIDLDO + DGIDLDL * iLE;
            //  Impact ionization parameters
            A1_p         =  A1O * (1.0 + A1L * iLE) * (1.0 + A1W * iWE);
            A1_i         =  max(A1_p, 0.0);
            A2_t         =  A2O;
            STA2_i       =  STA2O;
            A3_p         =  A3O * (1.0 + A3L * iLE) * (1.0 + A3W * iWE);
            A3_i         =  max(A3_p, 0.0);
            //  Edge transistor parameters
            WE_edge      =  2.0 * WEDGE + WEDGEW * WE;
            CTEDGE_i     =  CTEDGEO;
            temp         =  VFBEDGEL * pow(iLE, VFBEDGELEXP);
            VFB1EDGE_t   =  VFBEDGEO + temp + VFBEDGEW * iWE + VFBEDGELW * iAE;
            VFB2EDGE_t   =  VFBBEDGEO;
            STVFBEDGE_i  =  STVFBEDGEO * (1.0 + STVFBEDGEL * iLE) * (1.0 + STVFBEDGEW * iWE) * (1.0 + STVFBEDGELW * iAE);
            CIC1EDGE_i   =  CICFEDGEO;
            CIC2EDGE_i   =  CICEDGEO;
            temp         =  PSCEEDGEL * 2.0 * pow(lambda_LE, PSCEEDGELEXP) * (1.0 + PSCEEDGEW * iWE);
            PSCE1EDGE_i  =  min(max(temp, 0.0), 5.0);
            PSCE2EDGE_i  =  PSCEBEDGEO * PSCE1EDGE_i * TOX2_i / TOX1_i;
            temp         =  pow(lambda_LE, CFEDGELEXP) * (1.0 + CFEDGEW * iWE);
            temp         =  CFEDGEL * temp;
            CF1EDGE_i    =  max(temp, 0.0);
            CF2EDGE_i    =  CFBEDGEO * CF1EDGE_i * TOX2_i / TOX1_i;
            CFDEDGE_i    =  CFDEDGEO;
            temp         =  1.0 + FBETEDGE * LPEDGE / LE * (1.0 - exp(-LE / LPEDGE));
            temp         =  max(temp, 1.0e-15);
            BETNEDGE_t   =  UO * WE_edge / (temp * LE) * (1.0 + BETEDGEW * iWE);
            STBETEDGE_i  =  STBETEDGEO + STBETEDGEL * iLE + STBETEDGEW * iWE + STBETEDGELW * iLE * iWE;

            //  Charge model parameters
            AREAQ_i      =  WEcv * LEcv;
            CGBOV_p      =  CGBOVO + CGBOVL * lphy;
            CGBOV_i      =  max(CGBOV_p, 0.0);
            NSDAC_i      =  NSDACO * 1.0e6;
            FIF_i        =  FIFW * WEcv / WEN;
            FSCEAC_i     =  FSCEACO;
            VFBAC1_t     =  VFB1_t;
            VFBAC2_t     =  VFB2_t;
            PSCEAC1_i    =  PSCE1_i;
            PSCEAC2_i    =  PSCE2_i;
            CFAC_p       =  CF_p;
            CFAC1_t      =  CF1_t;
            CFAC2_t      =  CF2_t;
            THESATAC_p   =  THESAT_p;
            THESATAC_t   =  THESAT_t;
            AXAC_i       =  AX_i;
            ALPAC_i      =  ALP_i;
            if (SWQMOD > 0) begin
                `DefACparam(VFBACO_i, VFBO, VFBACO)
                `DefACparam(VFBACL_i, VFBL, VFBACL)
                `DefACparam(VFBACLEXP_i, VFBLEXP, VFBACLEXP)
                `DefACparam(VFBACW_i, VFBW, VFBACW)
                `DefACparam(VFBACLW_i, VFBLW, VFBACLW)
                `DefACparam(VFBACL2_i, VFBL2, VFBACL2)
                `DefACparam(VFBACLEXP2_i, VFBLEXP2, VFBACLEXP2)
                temp         =  VFBACL_i * pow(iLE, VFBACLEXP_i) / (1.0 + VFBACL2_i * pow(iLE, VFBACLEXP2_i));
                VFBAC1_t     =  VFBACO_i + temp + VFBACW_i * iWE + VFBACLW_i * iAE;
                `DefACparam(VFBBACO_i, VFBBO, VFBBACO)
                `DefACparam(VFBLBACO_i, VFBLBO, VFBLBACO)
                VFBAC2_t     =  VFBBACO_i + VFBLBACO_i * TOX2_i / TOX1_i * temp;
                `DefACparam(PSCEACL_i, PSCEL, PSCEACL)
                `DefACparam(PSCEACLEXP_i, PSCELEXP, PSCEACLEXP)
                `DefACparam(PSCEACW_i, PSCEW, PSCEACW)
                PSCEAC_p     =  PSCEACL_i * 2.0 * pow(lambda_LE, PSCEACLEXP_i) * (1.0 + PSCEACW_i * iWE);
                PSCEAC1_i    =  min(max(PSCEAC_p, 0.0), 5.0);
                PSCEAC2_i    =  PSCEBO * PSCEAC1_i * TOX2_i / TOX1_i;
                `DefACparam(CFACL_i, CFL, CFACL)
                `DefACparam(CFACLEXP_i, CFLEXP, CFACLEXP)
                `DefACparam(CFACW_i, CFW, CFACW)
                temp         =  pow(lambda_LE, CFACLEXP_i) * (1.0 + CFACW_i * iWE);
                CFAC_p       =  CFACL_i * temp;
                CFAC1_t      =  max(CFAC_p, 0.0);
                CFAC2_t      =  CFBO * CFAC1_t * TOX2_i / TOX1_i;
                `DefACparam(THESATACO_i, THESATO, THESATACO)
                `DefACparam(THESATACL_i, THESATL, THESATACL)
                `DefACparam(THESATACLEXP_i, THESATLEXP, THESATACLEXP)
                `DefACparam(THESATACW_i, THESATW, THESATACW)
                `DefACparam(THESATACLW_i, THESATLW, THESATACLW)
                THESATAC_p   =  GE * (THESATACO_i + THESATACL_i * pow(iLE, THESATACLEXP_i)) * (1.0 + THESATACW_i * iWE) * (1.0 + THESATACLW_i * iAE);
                THESATAC_t   =  max(THESATAC_p, 0.0);
                `DefACparam(AXACO_i, AXO, AXACO)
                `DefACparam(AXACL_i, AXL, AXACL)
                `DefACparam(AXACLEXP_i, AXLEXP, AXACLEXP)
                `DefACparam(AXACL2_i, AXL2, AXACL2)
                `DefACparam(AXACLEXP2_i, AXLEXP2, AXACLEXP2)
                AXAC_p       =  AXACO_i / (1.0 + AXACL_i * pow(iLE, AXACLEXP_i) / (1.0 + AXACL2_i * pow(iLE, AXACLEXP2_i)));
                AXAC_i       =  min(max(AXAC_p, 1.0), 16.0);
                `DefACparam(ALPACL1_i, ALPL1, ALPACL1)
                `DefACparam(ALPACLEXP_i, ALPLEXP, ALPACLEXP)
                `DefACparam(ALPACL2_i, ALPL2, ALPACL2)
                `DefACparam(ALPACLEXP2_i, ALPLEXP2, ALPACLEXP2)
                `DefACparam(ALPACW_i, ALPW, ALPACW)
                ALPAC_p      =  ALPACL1_i * pow(iLE, ALPACLEXP_i) * (1.0 + ALPACW_i * iWE) / (1.0 + ALPACL2_i * pow(iLE, ALPACLEXP2_i));
                ALPAC_i      =  max(ALPAC_p, 0.0);
            end
            temp         = `EPSOX / TOX1_i * WEcv;
            COV_i        =  temp * LOVO;
            COVD_i       =  temp * LOVDO;
            COVDL_i      =  COVDLO / max(1.0 + COVDLW * WEN / WEcv, 1.0e-3);
            COVDLB_i     =  COVDLBO;
            DVFBOV_i     =  DVFBOVO;
            CFR_p        =  CFRO + CFRW * wphy;
            CFR_i        =  max(CFR_p, 0.0);
            CFRD_p       =  CFRDO + CFRDW * wphy;
            CFRD_i       =  max(CFRD_p, 0.0);
            CSD_i        =  CSDO * epsch * TSI_i * WE / LE;
            CSDBP_i      =  CSDBPO;
            //  Self heating parameters
            temp         =  max(1.0 + RTHL * lphy + RTHW * wphy + RTHLW * lphy * wphy, 1.0e-10);
            temp1        =  0.0;
            if ((NF > 1.0) && (SD > 0.0)) begin
                temp2        = -(SD + L) / LAMBTHO;
                `lin_exp(temp2, temp3)
                temp4        =  1.0 - temp3;
                temp1        =  2.0 * FTHO * temp3 * (temp4 - (1.0 - pow(temp3, NF)) / NF) / (temp4 * temp4);
            end
            temp         =  temp / (1.0 + temp1);
            RTH_p        =  RTHO / temp;
            RTH_t        =  max(RTH_p, 1.0e-6);
            STRTH_i      =  STRTHO;
            CTH_p        =  CTHO * temp;
            CTH_i        =  max(CTH_p, 0.0);
            //  Noise model parameters
            FNT_i        =  FNTO;
            FNTEXC_i     =  FNTEXCL * BETN_p * BETN_p * iWE * iWE * pow(iLE, FNTEXCLEXP - 2.0);
            NFA_p        =  NFALW * iAE + NFAW * iWE;
            NFA_i        =  max(NFA_p, 0.0);
            NFB_i        =  NFBLW * iAE;
            NFC_i        =  NFCLW * iAE;
            NFE_i        =  NFEO;
            NFEB_i       =  NFEBO;
            EF_i         =  EFO;
            //  NQS model parameters
`ifdef NQSmodel
                temp       =  KDRIFTO + KDRIFTL * iLE;
                KDRIFT_i   =  max(temp, 0.0);
                temp       =  KDIFFO + KDIFFL * iLE;
                KDIFF_i    =  max(temp, 0.0);
                FRACINV_i  =  FRACINVO;
                KFRACINV_i =  KFRACINVO;
`endif // NQSmodel
            //  Parasitic resistance parameters
            RG_p       =  RSHG * (`INV3 * W_f / NGCON + XGWE) / (NGCON * L_slif) + (RINT + RVPOLY) / (W_f * L_f) + NF * RGO;
            RG_i       =  max(RG_p, 0.0);
            RSH_i      =  max(RSH, 0.0);
            RSHD_i     =  max(RSHD, 0.0);
            if (SWJUNASYM == 0) begin
                RSHD_i       =  RSH_i;
            end
            RSE_i      =  NF * NRS * RSH_i;
            RDE_i      =  NF * NRD * RSHD_i;
            RWELL_i    =  NF * RWELLO;
            //  Stress model
            if ((SWSTRESS > 0) && (SA > 0.0) && (SB > 0.0) && ((NF == 1.0) || ((NF > 1.0) && (SD > 0.0)))) begin
                if (SWSTRESS == 1) begin
                    tmpa         =  0.0;
                    tmpb         =  0.0;
                    iloop        =  0.0;
                    while (iloop < (NF - 0.5)) begin
                        tmpa         =  tmpa + 1.0 / (SA + 0.5 * L + iloop * (SD + L));
                        tmpb         =  tmpb + 1.0 / (SB + 0.5 * L + iloop * (SD + L));
                        iloop        =  iloop + 1.0;
                    end
                    Invsa        =  tmpa / NF;
                    Invsb        =  tmpb / NF;
                    Invsaref     =  1.0 / (SAREF + 0.5 * L);
                    Invsbref     =  1.0 / (SBREF + 0.5 * L);
                    Lx           =  max(L + delLPS, 1.0e-9);
                    Wx           =  max(W_i + delWOD + WLOD, 1.0e-9);
                    templ        =  1.0 / pow(Lx, LLODKUO);
                    tempw        =  1.0 / pow(Wx, WLODKUO);
                    Kstressu0    =  (1.0 + LKUO * templ + WKUO * tempw + PKUO * templ * tempw) * (1.0 + TKUO * (rT - 1.0));
                    rhobeta      =  KUO * (Invsa + Invsb) / Kstressu0;
                    rhobetaref   =  KUO * (Invsaref + Invsbref) / Kstressu0;
                    templ        =  1.0 / pow(Lx, LLODVTH);
                    tempw        =  1.0 / pow(Wx, WLODVTH);
                    Kstressvth0  =  max(1.0 + LKVTHO * templ + WKVTHO * tempw + PKVTHO * templ * tempw, 1e-20);
                    temp0        =  Invsa + Invsb - Invsaref - Invsbref;
                    // Stress effect on mobility
                    BETN_p       =  BETN_p * (1.0 + rhobeta) / (1.0 + rhobetaref);
                    BETN1_t      =  max(BETN_p, 1.0e-10);
                    BETN2_t      =  BETNBO * BETN1_t;
                    // Stress effect on saturation velocity
                    temp         =  (1.0 + rhobeta) * (1.0 + KVSAT * rhobetaref) / ((1.0 + rhobetaref) * (1.0  + KVSAT * rhobeta));
                    THESAT_p     =  THESAT_p * temp;
                    THESAT_t     =  max(THESAT_p, 0.0);
                    THESATAC_p   =  THESATAC_p * temp;
                    THESATAC_t   =  max(THESATAC_p, 0.0);
                    // Stress effect on threshold voltage
                    temp         =  KVTHO * temp0 / Kstressvth0;
                    VFB1_t       =  VFB1_t + temp;
                    VFB2_t       =  VFB2_t + temp;
                    VFBAC1_t     =  VFBAC1_t + temp;
                    VFBAC2_t     =  VFBAC2_t + temp;
                    // Stress effect on DIBL
                    temp         =  STETAO * temp0 / pow(Kstressvth0, LODETAO);
                    CF_p         =  CF_p + temp;
                    CF1_t        =  max(CF_p, 0.0);
                    CFAC_p       =  CFAC_p + temp;
                    CFAC1_t      =  max(CFAC_p, 0.0);
                    temp         =  CFBO * TOX2_i / TOX1_i;
                    CF2_t        =  CF1_t * temp;
                    CFAC2_t      =  CFAC1_t * temp;
                end else begin
                    tmpa         =  0.0;
                    iloop        =  0.0;
                    temp         = -1.0 / STRALPHA;
                    while (iloop < (NF - 0.5)) begin
                        `linmin_exp((-(SA + 0.5 * L + iloop * (SD + L)) / STRLAMBDA), temp1)
                        `linmin_exp((-(SB + 0.5 * L + (NF - 1.0 - iloop) * (SD + L)) / STRLAMBDA), temp2)
                        temp3        =  pow(1.0 - temp1, -STRALPHA);
                        temp4        =  pow(1.0 - temp2, -STRALPHA);
                        tmpa         =  tmpa + pow(0.5 * (temp3 + temp4), temp);
                        iloop        =  iloop + 1.0;
                    end
                    str_g        =  1.0 - tmpa / NF;
                    `linmin_exp((-(SAREF + 0.5 * L) / STRLAMBDA), temp1)
                    `linmin_exp((-(SBREF + 0.5 * L) / STRLAMBDA), temp2)
                    temp3        =  pow(1.0 - temp1, -STRALPHA);
                    temp4        =  pow(1.0 - temp2, -STRALPHA);
                    str_gref     =  1.0 - pow(0.5 * (temp3 + temp4), temp);
                    Wx           =  max(W_i + delWOD + WLOD, 1.0e-9);
                    ruo          =  STRRUO / (1.0 + STRTRUO * (rT - 1.0));
                    rhobeta      =  ruo * str_g;
                    rhobetaref   =  ruo * str_gref;
                    temp0        =  str_g - str_gref;
                    Kstressvth0  =  max(1.0 + STRWDVFBO * Wx / WEN, 1.0e-20);
                    // Stress effect on mobility
                    BETN_p       =  BETN_p * (1.0 + rhobeta) / (1.0 + rhobetaref);
                    BETN1_t      =  max(BETN_p, 1.0e-10);
                    BETN2_t      =  BETNBO * BETN1_t;
                    // Stress effect on saturation velocity
                    temp         =  (1.0 + rhobeta) * (1.0 + STRRVSAT * rhobetaref) / ((1.0 + rhobetaref) * (1.0 + STRRVSAT * rhobeta));
                    THESAT_p     =  THESAT_p * temp;
                    THESAT_t     =  max(THESAT_p, 0.0);
                    THESATAC_p   =  THESATAC_p * temp;
                    THESATAC_t   =  max(THESATAC_p, 0.0);
                    // Stress effect on threshold voltage
                    temp         =  STRDVFBO * temp0 / Kstressvth0;
                    VFB1_t       =  VFB1_t + temp;
                    VFB2_t       =  VFB2_t + temp;
                    VFBAC1_t     =  VFBAC1_t + temp;
                    VFBAC2_t     =  VFBAC2_t + temp;
                    // Stress effect on DIBL
                    temp         =  STRDCFL * temp0 * pow(lambda_LE, CFLEXP) * (1.0 + CFW * iWE);
                    CF_p         =  CF_p + temp;
                    CF1_t        =  max(CF_p, 0.0);
                    CFAC_p       =  CFAC_p + temp;
                    CFAC1_t      =  max(CFAC_p, 0.0);
                    temp         =  CFBO * TOX2_i / TOX1_i;
                    CF2_t        =  CF1_t * temp;
                    CFAC2_t      =  CFAC1_t * temp;
                end
            end
        end

    // *********** Source/drain symmetrization ***********
        if (SWJUNASYM == 0) begin
            NOVD_i       =  NOV_i;
            IGOVINVD_t   =  IGOVINV_t;
            FNOVINVD_t   =  FNOVINV_t;
            IGOVACCD_t   =  IGOVACC_t;
            AGIDLD_i     =  AGIDL_i;
            BGIDLD_t     =  BGIDL_t;
            STBGIDLD_i   =  STBGIDL_i;
            CGIDLD_i     =  CGIDL_i;
            DGIDLD_i     =  DGIDL_i;
            COVD_i       =  COV_i;
            CFRD_i       =  CFR_i;
        end

    // *********** Local process parameters ***********
        one_m_xge    =  1.0 - XGE_i;
        epsch        = `EPSSI * one_m_xge + `EPSGE * XGE_i;
        EgSi         = `EG0SI - `ALPHASI * TKC_sq / (`BETASI + TKC);
        EgGe         = `EG0GE - `ALPHAGE * TKC_sq / (`BETAGE + TKC);
        dEg          =  (EgGe - EgSi + `CG * one_m_xge) * XGE_i;
        Eg           =  EgSi + dEg;
        Eg_2phit0    =  0.5 * Eg * inv_phit0;
        Eg_2phit0_woshe  =  Eg_2phit0;
        niratio      =  1.0 / (1.0 + sqrt(10.0 * XGE_i));
        dVfbch       =  0.05 * XGE_i - 0.5 * dEg;
        temp         = `QELE * NCH_i * 0.5 * TSI_i / `EPSOX;
        if (TYPECH_i > 0) begin        // P-type thin film
            dVfb1Nch     =  temp * (TOX1_i + QMC * 4.0e-10);
            dVfb2Nch     =  temp * (TOX2_i + QMC * 4.0e-10);
        end else begin                // N-type thin film
            dVfb1Nch     = -temp * (TOX1_i + QMC * 4.0e-10);
            dVfb2Nch     = -temp * (TOX2_i + QMC * 4.0e-10);
        end
        temp         =  sqrt(TKC * `INV300);
        temp1        = `NIFACT300 * temp * temp * temp;
        neff         =  temp1 * niratio;
        neff_poly    =  temp1 * exp(0.5 * dEg * inv_phit0);
        neff_sub     =  temp1 * exp(0.5 * dEg * inv_phit0);
        Cox1Init     = `EPSOX / TOX1_i;
        Cox2Init     = `EPSOX / TOX2_i;
        if (PNCE_i > 0) begin
            Cox1Prime    =  Cox1Init * (1.0 + PNCE_i);
            Cox2Prime    =  Cox2Init;
        end else begin
            Cox1Prime    =  Cox1Init;
            Cox2Prime    =  Cox2Init * (1.0 - PNCE_i);
        end
        CsiPrime_0   =  epsch / TSI_i;
        phit         =  phit0 * (1.0 + CT_i * rTn);
        inv_phit     =  1.0 / phit;
        Eg_2phit     =  0.5 * Eg * inv_phit;

    // *********** Interface coupling effects ***********
        k1_1D        =  Cox1Prime / CsiPrime_0;
        k2_1D        =  Cox2Prime / CsiPrime_0;
        keq_1D       =  1.0 / (1.0 + 1.0 / k1_1D + 1.0 / k2_1D);
        A0_Csisq     =  2.0 * `QELE * neff * epsch * inv_phit;
        xth_1D       =  ln((CsiPrime_0 * CsiPrime_0) / A0_Csisq) - `LN2;
        xSDdep       =  0.5 * `QELE * NSDDC_i * TSI_i / (Cox1Prime + Cox2Prime) * inv_phit;

    // *********** DIBL effect ***********
        temp         =  STCF_i * dT;
        CF1_i        =  CF1_t + temp;
        CF2_i        =  CF2_t + temp;
        CFAC1_i      =  CFAC1_t + temp;
        CFAC2_i      =  CFAC2_t + temp;
        xd0          =  CFD_i * inv_phit;

    // *********** Substrate parameters ***********
        Gfsub        =  sqrt(2.0 * `QELE * NSUB_i * `EPSSI * inv_phit0) / Cox2Prime;
        Gfsub2       =  Gfsub * Gfsub;
        inv_Gfsub2   =  1.0 / Gfsub2;
        xisub        =  1.0 + Gfsub / `SQRT2;
        inv_xisub    =  1.0 / xisub;
        margin_sub   =  1.0e-5 * xisub;
        xb_sub       =  ln(NSUB_i / neff_sub) + Eg_2phit0;
        xn_sub       =  2.0 * xb_sub;
        if (SWSUBDEP > 0) begin
            VFB2_t       =  VFB2_t + TYPESUB_i * phit0 * xb_sub;
            VFBAC2_t     =  VFBAC2_t + TYPESUB_i * phit0 * xb_sub;
        end

    // *********** Gate poly-silicon depletion effect ***********
        dVfbpdep     =  0.0;
        if (SWPDEP > 0) begin
            dVfbpdep     =  phit0 * (ln(NP_i / neff_poly) + Eg_2phit0);
        end
        KP           =  sqrt(2.0 * `QELE * epsch * NP_i) / Cox1Init;

        // *********** QM corrections ***********
        emin         = 15.0;
        if (SWCRYO == 1) begin
            emin         = `MAX_FUNC(15.0, 2.97e3 / TKD, 1.0e-6);
        end
        dVfbQM       =  0.0;
        qq           =  0.0;
        tsisq        =  1.0e18 * TSI_i * TSI_i;
        if (QMC > 0.0) begin
            if (TYPE == `NMOS) begin
                dVfbQM       =  0.409618895 / tsisq;
                qq           =  0.4 * QMC * `QMN * exp(-`INV3 * ln(phit * tsisq));
            end else begin
                dVfbQM       =  0.723134895 / tsisq;
                qq           =  0.4 * QMC * `QMP * exp(-`INV3 * ln(phit * tsisq));
            end
        end
        temp         =  TYPE * STVFB_i * dT + dVfbQM;
        temp1        =  temp + DELVTO - dVfbpdep;
        VFB1_i       =  TYPE * (VFB1_t + dVfbch + dVfb1Nch) + temp1;
        VFB2_i       =  TYPE * (VFB2_t + dVfbch + dVfb2Nch) + temp;
        VFBAC1_i     =  TYPE * (VFBAC1_t + dVfbch + dVfb1Nch) + temp1;
        VFBAC2_i     =  TYPE * (VFBAC2_t + dVfbch + dVfb2Nch) + temp;

    // *********** Mobility parameters ***********
        lnrTn        =  ln(rTn);
        tf_bet       =  exp(STBET_i * lnrTn) * FACTUO;
        BETN1_i      =  BETN1_t * tf_bet;
        BETN2_i      =  BETN2_t * tf_bet;
        tf_mue       =  exp(STMUE_i * lnrTn);
        MUE_i        =  MUE_t * tf_mue;
        tf_themu     =  exp(STTHEMU_i * lnrTn);
        THEMU_i      =  THEMU_t * tf_themu;
        tf_cs        =  exp(STCS_i * lnrTn);
        CS_i         =  CS_t * tf_cs;
        tf_thecs     =  exp(STTHECS_i * lnrTn);
        THECS_i      =  THECS_t * tf_thecs;
        tf_xcor      =  exp(STXCOR_i * lnrTn);
        XCOR_i       =  XCOR_t * tf_xcor;
        temp         =  1.0e-8 * phit / TSI_i;
        fmue         =  temp * MUE_i;
        inv_qi1cs    =  1.0 / (`QI_TH * CSTHR_i);
        inv_qi2cs    =  inv_qi1cs / CSTHRB_i;
        if (TYPE == `NMOS) begin
            eta_mu       =  0.5 * FETA_i;
        end else begin
            eta_mu       =  `INV3 * FETA_i;
        end
        one_m_eta    =  1.0 - eta_mu;

    // *********** Series resistance ***********
        tf_ther      =  exp(STRS_i * lnrTn);
        RS_i         =  RS_t * tf_ther;
        frs          =  2.0 * RS_i * phit;

    // *********** Velocity saturation ***********
        gamAX        =  exp(0.375 * ln(exp(16.0 / AX_i * `LN2) - 1.0)) - 1.0;
        gamAX_ac     =  exp(0.375 * ln(exp(16.0 / AXAC_i * `LN2) - 1.0)) - 1.0;
        tf_thesat    =  exp(STTHESAT_i * lnrTn);
        THESAT_i     =  THESAT_t * tf_thesat * tf_bet;
        sat_phit     =  THESAT_i * phit;
        THESATAC_i   =  THESATAC_t * tf_thesat * tf_bet;
        sat_phit_ac  =  THESATAC_i * phit;

    // *********** Channel length modulation ***********
        alp1_phit    =  ALP1_i * inv_phit;

    // *********** Gate current ***********
        tf_ig        =  exp(-STIG_i * lnrTn);
        IGINV_i      =  IGINV_t * tf_ig;
        IGOVINV_i    =  IGOVINV_t * tf_ig;
        IGOVINVD_i   =  IGOVINVD_t * tf_ig;
        IGOVACC_i    =  IGOVACC_t * tf_ig;
        IGOVACCD_i   =  IGOVACCD_t * tf_ig;
        tf_ig        =  exp(-STIGFN_i * lnrTn);
        FNOVINV_i    =  FNOVINV_t * tf_ig;
        FNOVINVD_i   =  FNOVINVD_t * tf_ig;
        inv_CHIB     =  1.0 / CHIB_i;
        tempM        =  4.0 * `INV3 * sqrt(2.0 * `QELE * `MELE * CHIB_i) / `HBAR;
        BCH          =  tempM * TOXP_i;
        BOV          =  tempM * TOXP_i;
        GCQCH        =  0.0;
        if (GC3CH_i < 0.0) begin
            GCQCH        = -0.495 * GC2CH_i / GC3CH_i;
        end
        GCQOVINV     =  0.0;
        if (GC3OVINV_i < 0.0) begin
            GCQOVINV     = -0.495 * GC2OVINV_i / GC3OVINV_i;
        end
        GCQOVACC     =  0.0;
        if (GC3OVACC_i < 0.0) begin
            GCQOVACC     = -0.495 * GC2OVACC_i / GC3OVACC_i;
        end
        alpha_b      =  0.5 * Eg;
        Dch          =  GCO_i * phit;
        Dov          =  GCO_i * phit0;
        n_iginv      =  1.0 / (1.0 + NIGINV_i * Eg_2phit);

    // *********** GIDL/GISL current ***********
        temp         =  4.0e-18 / (TOXP_i * TOXP_i);
        AGIDL_i      =  AGIDL_i * temp;
        AGIDLD_i     =  AGIDLD_i * temp;
        temp         =  TOXP_i * 5.0e8;
        tempM        = `MAX_FUNC(1.0 + STBGIDL_i * dT, 0.0, 0.01);
        BGIDL_i      =  BGIDL_t * tempM * temp;
        tempM        = `MAX_FUNC(1.0 + STBGIDLD_i * dT, 0.0, 0.01);
        BGIDLD_i     =  BGIDLD_t * tempM * temp;

    // *********** Impact Ionization ***********
        A2_i         =  A2_t * exp(-STA2_i * lnrTn);

    // *********** Edge transistors ***********
        phit_edge    =  phit0 * (1.0 + CTEDGE_i * rTn);
        inv_phit_edge =  1.0 / phit_edge;
        A0_Csisq_edge =  2.0 * `QELE * neff * epsch * inv_phit_edge;
        temp         =  TYPE * STVFBEDGE_i * dT + dVfbQM;
        VFB1EDGE_i   =  TYPE * (VFB1EDGE_t + dVfbch + dVfb1Nch) + temp + DELVTO - dVfbpdep;
        VFB2EDGE_i   =  TYPE * (VFB2EDGE_t + dVfbch + dVfb2Nch) + temp;
        temp         =  exp(STBETEDGE_i * lnrTn) * FACTUO;
        BETNEDGE_i   =  BETNEDGE_t * temp;

    // *********** Charge model parameters ***********
        area_phit    =  AREAQ_i * phit;
        inner_sd     =  0.25 * `QELE * NSDAC_i / (epsch * phit);
        xsd          =  ln(NSDAC_i / neff);
        fif_phit     =  FIF_i * 1.25e-6 * phit;
        lambda2D     =  sqrt(epsch / `EPSOX * TSI_i * (TOX1_i + 4.0e-10));

    // *********** Thermal resistance ***********
        tf_rth       =  exp(STRTH_i * lnrTn);
        RTH_i        =  RTH_t * tf_rth;

    // *********** Noise ***********
        nt0_4KT      =  4.0 * `KBOL * TKC;
        nt           =  FNT_i * nt0_4KT;
        nt0          =  nt;
        fac_exc      = `MELE * 1.0e12 * FNTEXC_i;

    // *********** Conductance of parasitic resistances ***********
        if (RG_i > 0.0) begin
            ggate        =  1.0 / RG_i;
        end else begin
            ggate        =  0.0;
        end
        if (RSE_i > 0.0) begin
            gsource      =  1.0 / RSE_i;
        end else begin
            gsource      =  0.0;
        end
        if (RDE_i > 0.0) begin
            gdrain       =  1.0 / RDE_i;
        end else begin
            gdrain       =  0.0;
        end
        if (RWELL_i > 0.0) begin
            gwell        =  1.0 / RWELL_i;
        end else begin
            gwell        =  0.0;
        end

    end    // initializeInstance

    //  Calculation of All Currents
    //  **************************************************************************************************************
    begin : evaluateStatic

    // *********** Declaration of local variables ***********
        `SPOVcalcLocalVarDecl
        real Vdsu, Vsdu, xgs_ov, xgd_ov, xgs_ovcv, xgd_ovcv, GOV, GOV2, xi_ov, x_mrg_ov, inv_xi_ov, inv_xg1, xs_ov;
        real xd_ov, xs_ovcv, xd_ovcv, Vovs, Vovd, arg2mina, psi_t, zg, gc2oveff, gc3oveff, gcqoveff, igoveff;
        real igovefffowler, arg1, Dsi, Dgate, TP, TP2, Igsov, Igdov, half_x_ds, Vm, q1m, Voxm, x_m, xg1xshift, Igc0;
        real igc, igcd_h, u0, x, u0_div_H, Ag, Bg, xsq, inv_x, ex, inv_ex, Igcs, Igcd, Vtovs, Vtovd, delVsat;
        real xd_edge, xdsx_edge, dxdsx_edge, xg10_edge, xg20_edge, sce1_edge, sce2_edge, xd0_edge, dxg1_dibl_edge;
        real dxg2_dibl_edge, xg1_edge, xg2_edge, xg1x_edge, xg2x_edge, k1_edge, k2_edge, inv_k1_edge, inv_k2_edge;
        real keq_edge, A0_edge, Dx_WI_edge, prefac_qilow_edge, qis_edge, qid_edge, norm_Ids_edge, fact_Ids_edge;
        real w_temp;

    // *********** Recalculation of temperature dependent variables in case of self heating ***********
        if (SWSHE_i > 0) begin
            DTC          =  Temp(THPWR);
            // Channel temperature
            TKC          =  TKD + DTC;
            TKC_sq       =  TKC * TKC;
            dT           =  TKC - TKR;
            rT           =  TKC / TKR;
            rTn          =  TKR / TKC;
            phit0        =  TKC * `KBOL_QELE;
            inv_phit0    =  1.0 / phit0;
            if (SWCRYO == 1) begin
                xsatmax      = `MAX_FUNC(10.0 / (TKD * `KBOL_QELE) , `XSAT_MAX, 0.01);
            end else begin
                xsatmax      = `XSAT_MAX;
            end
            // Local process parameters
            EgSi         = `EG0SI - `ALPHASI * TKC_sq / (`BETASI + TKC);
            EgGe         = `EG0GE - `ALPHAGE * TKC_sq / (`BETAGE + TKC);
            dEg          = (EgGe - EgSi + `CG * one_m_xge) * XGE_i;
            Eg           =  EgSi + dEg;
            Eg_2phit0    =  0.5 * Eg * inv_phit0;
            dVfbch       =  0.05 * XGE_i - 0.5 * dEg;
            temp         =  sqrt(TKC * `INV300);
            temp1        = `NIFACT300 * temp * temp * temp;
            neff         =  temp1 * niratio;
            phit         =  phit0 * (1.0 + CT_i * rTn);
            inv_phit     =  1.0 / phit;
            Eg_2phit     =  0.5 * Eg * inv_phit;
            // Interface coupling effects
            A0_Csisq     =  2.0 * `QELE * neff * epsch * inv_phit;
            xth_1D       =  ln((CsiPrime_0 * CsiPrime_0) / A0_Csisq) - `LN2;
            xSDdep       =  0.5 * `QELE * NSDDC_i * TSI_i / (Cox1Prime + Cox2Prime) * inv_phit;
            // DIBL effect
            temp         =  STCF_i * dT;
            CF1_i        =  CF1_t + temp;
            CF2_i        =  CF2_t + temp;
            xd0          =  CFD_i * inv_phit;
            CFAC1_i      =  CFAC1_t + temp;
            CFAC2_i      =  CFAC2_t + temp;
            // Gate poly-silicon depletion effect
            if (SWPDEP > 0) begin
                dVfbpdep     =  phit0 * (ln(NP_i / neff_poly) + Eg_2phit0_woshe);
            end
            // QM corrections
            if (SWCRYO == 1) begin
                emin         = `MAX_FUNC(15.0, 2.97e3 / TKD, 1.0e-6);
            end
            qq           =  0.0;
            if (QMC > 0.0) begin
                if (TYPE == `NMOS) begin
                    qq           =  0.4 * QMC * `QMN * exp(-`INV3 * ln(phit * tsisq));
                end else begin
                    qq           =  0.4 * QMC * `QMP * exp(-`INV3 * ln(phit * tsisq));
                end
            end
            temp         =  TYPE * STVFB_i * dT + dVfbQM;
            temp1        =  temp + DELVTO - dVfbpdep;
            VFB1_i       =  TYPE * (VFB1_t + dVfbch + dVfb1Nch) + temp1;
            VFB2_i       =  TYPE * (VFB2_t + dVfbch + dVfb2Nch) + temp;
            VFBAC1_i     =  TYPE * (VFBAC1_t + dVfbch + dVfb1Nch) + temp1;
            VFBAC2_i     =  TYPE * (VFBAC2_t + dVfbch + dVfb2Nch) + temp;
            // Mobility parameters
            lnrTn        =  ln(rTn);
            tf_bet       =  exp(STBET_i * lnrTn) * FACTUO;
            BETN1_i      =  BETN1_t * tf_bet;
            BETN2_i      =  BETN2_t * tf_bet;
            tf_mue       =  exp(STMUE_i * lnrTn);
            MUE_i        =  MUE_t * tf_mue;
            tf_themu     =  exp(STTHEMU_i * lnrTn);
            THEMU_i      =  THEMU_t * tf_themu;
            tf_cs        =  exp(STCS_i * lnrTn);
            CS_i         =  CS_t * tf_cs;
            tf_thecs     =  exp(STTHECS_i * lnrTn);
            THECS_i      =  THECS_t * tf_thecs;
            tf_xcor      =  exp(STXCOR_i * lnrTn);
            XCOR_i       =  XCOR_t * tf_xcor;
            temp         =  1.0e-8 * phit / TSI_i;
            fmue         =  temp * MUE_i;
            // Series resistance
            tf_ther      =  exp(STRS_i * lnrTn);
            RS_i         =  RS_t * tf_ther;
            frs          =  2.0 * RS_i * phit;
            // Velocity saturation
            tf_thesat    =  exp(STTHESAT_i * lnrTn);
            THESAT_i     =  THESAT_t * tf_thesat * tf_bet;
            sat_phit     =  THESAT_i * phit;
            THESATAC_i   =  THESATAC_t * tf_thesat * tf_bet;
            sat_phit_ac  =  THESATAC_i * phit;
            // Channel length modulation
            alp1_phit    =  ALP1_i * inv_phit;
            // Gate current
            tf_ig        =  exp(-STIG_i * lnrTn);
            IGINV_i      =  IGINV_t * tf_ig;
            IGOVINV_i    =  IGOVINV_t * tf_ig;
            IGOVINVD_i   =  IGOVINVD_t * tf_ig;
            IGOVACC_i    =  IGOVACC_t * tf_ig;
            IGOVACCD_i   =  IGOVACCD_t * tf_ig;
            tf_ig        =  exp(-STIGFN_i * lnrTn);
            FNOVINV_i    =  FNOVINV_t * tf_ig;
            FNOVINVD_i   =  FNOVINVD_t * tf_ig;
            alpha_b      =  0.5 * Eg;
            Dch          =  GCO_i * phit;
            Dov          =  GCO_i * phit0;
            n_iginv      =  1.0 / (1.0 + NIGINV_i * Eg_2phit);
            // GIDL/GISL current
            temp         =  TOXP_i * 5.0e8;
            tempM        = `MAX_FUNC(1.0 + STBGIDL_i * dT, 0.0, 0.01);
            BGIDL_i      =  BGIDL_t * tempM * temp;
            tempM        = `MAX_FUNC(1.0 + STBGIDLD_i * dT, 0.0, 0.01);
            BGIDLD_i     =  BGIDLD_t * tempM * temp;
            // Impact Ionization
            A2_i         =  A2_t * exp(-STA2_i * lnrTn);
            // Charge model parameters
            area_phit    =  AREAQ_i * phit;
            inner_sd     =  0.25 * `QELE * NSDAC_i / (epsch * phit);
            xsd          =  ln(NSDAC_i / neff);
            fif_phit     =  FIF_i * 1.25e-6 * phit;
            // Thermal resistance
            tf_rth       =  exp(STRTH_i * lnrTn);
            RTH_i        =  RTH_t * tf_rth;
            // Noise
            nt0_4KT      =  4.0 * `KBOL * TKC;
            nt           =  FNT_i * nt0_4KT;
        end

    // *********** Bias affectation ***********
        if (TYPE == `NMOS) begin
            Vgsu         =  V(gp, si);
            Vdsu         =  V(di, si);
            Vsbu         =  V(si, bp);
        end else begin
            Vgsu         = -V(gp, si);
            Vdsu         = -V(di, si);
            Vsbu         = -V(si, bp);
        end

    // *********** Unswapped biases ***********
        Vsdu         = -Vdsu;
        Vgdu         =  Vgsu + Vsdu;
        Vdbu         =  Vdsu + Vsbu;

    // *********** Source-drain interchange ***********
        if (Vdsu < 0.0) begin
            sigVds       = -1.0;
            Vds          =  Vsdu;
            Vgs          =  Vgdu;
            Vsb          =  Vdbu;
        end else begin
            sigVds       =  1.0;
            Vds          =  Vdsu;
            Vgs          =  Vgsu;
            Vsb          =  Vsbu;
        end
        Vgb          =  Vgs + Vsb;
        xd           =  Vds * inv_phit;
        xdsx         =  (sqrt(Vds * Vds + 0.01) - 0.1) * inv_phit;
        dxdsx        =  0.5 * (xd - xdsx);

    // *********** Core's model calculation for DC ***********
        begin : Qcalc_dc

            // Declaration of local variables
            `CoreLocalVarDecl

            // Core's model calculation
            vfb1_loc     =  VFB1_i;
            vfb2_loc     =  VFB2_i;
            psce1_loc    =  PSCE1_i;
            psce2_loc    =  PSCE2_i;
            cf1_loc      =  CF1_i;
            cf2_loc      =  CF2_i;
            sat_phit_loc =  sat_phit;
            gamAX_loc    =  gamAX;
            alp_loc      =  ALP_i;
            `QCalculation
            xg20shift_dc =  xg20shift;
            diff_min_dc  =  diff_min;
            A0_dc        =  A0;
            inv_k1_dc    =  inv_k1;
            inv_k2_dc    =  inv_k2;
            keq_dc       =  keq;
            Dx_WI_dc     =  Dx_WI;
            CsiPrime_dc  =  CsiPrime;
            Dx_WI_1D_dc  =  Dx_WI_1D;
            q1s_dc       =  q1s;
            dleff_dc     =  dleff;
            xedge_dc     =  xedge;
            sce1_dc      =  sce1;
            sce2_dc      =  sce2;
            dxg1_dibl_dc =  dxg1_dibl;
            xg2_dc       =  xg2;
            xg2x_dc      =  xg2x;
            xg1x_dc      =  xg1x;
            k1_dc        =  k1;
            k2_dc        =  k2;
            qis_dc       =  qis;
            k1q1s_dc     =  k1q1s;
            k2q2s_dc     =  k2q2s;
            xdrifts_dc   =  xdrifts;
            ds_dc        =  ds;
            k1q1d_dc     =  k1q1d;
            k2q2d_dc     =  k2q2d;
            xndssat_dc   =  xndssat;
            xdeff_dc     =  xdeff;
            q1d_dc       =  q1d;
            qid_dc       =  qid;
            xdriftd_dc   =  xdriftd;
            qim_dc       =  qim;
            ratio_pd_dc  =  ratio_pd;
            esurf1_dc    =  esurf1;
            esurf2_dc    =  esurf2;
            qi1m_dc      =  qi1m;
            qi2m_dc      =  qi2m;
            csum_dc      =  csum;
            Gmob_dc      =  Gmob;
            inv_qimstar1_dc =  inv_qimstar1;
            dL_L_fact_dc =  dL_L_fact;
            GdL_dc       =  GdL;
            vsat_fact_dc =  vsat_fact;
            Ggamma_dc    =  Ggamma;
            zsat_dc      =  zsat;
            hsat_dc      =  hsat;
            qmfact1_dc   =  qmfact1;
            qmfact2_dc   =  qmfact2;
            dd_dc        =  dd;
            norm_Ids_dc  =  norm_Ids;
            inv_k1h1_dc  =  inv_k1h1;
            inv_k1h1_0_dc =  inv_k1h1_0;
            delta_k1q1_dc =  delta_k1q1;
            delta_k2q2_dc =  delta_k2q2;
            prod1_dc     =  prod1;
            prod2_dc     =  prod2;

        end // Qcalc_dc

    // *********** Drain-source current ***********
        // Mobility attenuation and series resistance
        betneff      =  csum_dc * FACTUO / (esurf1_dc + esurf2_dc);
        // Channel length modulation
        dL1_L        =  (ALP_i + alp1_phit * inv_qimstar1_dc) * dL_L_fact_dc;
        FdL          =  (1.0 + dL1_L * (1.0 + dL1_L)) * GdL_dc;
        // Velocity saturation
        Gvsat        =  Gmob_dc * GdL_dc * vsat_fact_dc;
        // Quantum mechanical corrections
        if (QMC > 0.0) begin
            qmfact       =  (esurf1_dc + esurf2_dc) / (esurf1_dc / qmfact1_dc + esurf2_dc / qmfact2_dc);
        end else begin
            qmfact       =  1.0;
        end
        fact_Ids     =  phit * phit * betneff;
        Ids          =  fact_Ids * CsiPrime_dc * norm_Ids_dc * FdL / Gvsat / qmfact;

    // *********** Conditioning of terminal voltages for overlap current and charge ***********
        xgs_ov       = -Vgsu * inv_phit0;
        xgd_ov       = -Vgdu * inv_phit0;
        temp         =  TYPE * DVFBOV_i * inv_phit0 + Eg_2phit0;
        xgs_ovcv     =  xgs_ov + temp;
        xgd_ovcv     =  xgd_ov + temp;

    // *********** Surface potential in gate overlap regions ***********
        xs_ov        =  0.0;
        xd_ov        =  0.0;
        xs_ovcv      =  0.0;
        xd_ovcv      =  0.0;
        GOV          =  sqrt(2.0 * `QELE * NOV_i * epsch * inv_phit0) / Cox1Prime;
        GOV2         =  GOV * GOV;
        xi_ov        =  1.0 + GOV / `SQRT2;
        x_mrg_ov     =  1.0e-5 * xi_ov;
        inv_xi_ov    =  1.0 / xi_ov;
        inv_xg1      =  1.0 / (`X1OV + GOV * 7.324648775608221e-1);
        if (((SWIGATE > 0) && ((IGOVINV_i > 0.0) || (IGOVACC_i > 0.0))) || ((SWGIDL > 0) && (AGIDL_i > 0.0))) begin
            `sp_fdsoi_ov(xs_ov, xgs_ov)
        end
        if (COV_i > 0.0) begin
            `sp_fdsoi_ov(xs_ovcv, xgs_ovcv)
        end
        GOV          =  sqrt(2.0 * `QELE * NOVD_i * epsch * inv_phit0) / Cox1Prime;
        GOV2         =  GOV * GOV;
        xi_ov        =  1.0 + GOV / `SQRT2;
        x_mrg_ov     =  1.0e-5 * xi_ov;
        inv_xi_ov    =  1.0 / xi_ov;
        inv_xg1      =  1.0 / (`X1OV + GOV * 7.324648775608221e-1);
        if (((SWIGATE > 0) && ((IGOVINVD_i > 0.0) || (IGOVACCD_i > 0.0))) || ((SWGIDL > 0) && (AGIDLD_i > 0.0))) begin
            `sp_fdsoi_ov(xd_ov, xgd_ov)
        end
        if (COVD_i > 0.0) begin
            `sp_fdsoi_ov(xd_ovcv, xgd_ovcv)
        end
        Vovs         = -phit0 * (xgs_ov + xs_ov);
        Vovd         = -phit0 * (xgd_ov + xd_ov);
        Vovscv       = -phit0 * (xgs_ovcv + xs_ovcv);
        Vovdcv       = -phit0 * (xgd_ovcv + xd_ovcv);

        // *********** Gate currents ***********
        Igsov        =  0.0;
        Igdov        =  0.0;
        Igc          =  0.0;
        Igs          =  0.0;
        Igd          =  0.0;
        Igcs         =  0.0;
        Igcd         =  0.0;
        if (SWIGATE > 0) begin
            //  Gate-source overlap-LDD component of gate current
            if ((IGOVINV_i > 0.0) || (IGOVACC_i > 0.0)) begin
                arg2mina     =  Vovs + Dov;
                psi_t        = `MIN_FUNC(0.0, arg2mina, 0.01);
                zg           =  sqrt(Vovs * Vovs + 1.0e-4) * inv_CHIB;
                `lin_exp(0.5 * xgs_ov, temp)
                temp1        =  1.0 / (1.0 + temp);
                temp2        =  1.0 - temp1;
                gc2oveff     =  GC2OVACC_i * temp1 + GC2OVINV_i * temp2;
                gc3oveff     =  GC3OVACC_i * temp1 + GC3OVINV_i * temp2;
                gcqoveff     =  GCQOVACC * temp1 + GCQOVINV * temp2;
                igoveff      =  IGOVACC_i * temp1 + IGOVINV_i * temp2;
                igovefffowler =  FNOVINV_i * temp2 * 1.0e-6;
                temp1        =  BOV * (-1.0 * GCOVINVFN_i/zg);
                if (gc3oveff < 0.0) begin
                    zg           = `MIN_FUNC(zg, gcqoveff, 1.0e-6);
                end
                arg1         =  3.0 + xs_ov + psi_t * inv_phit0;
                `lin_exp(arg1, Dsi)
                arg1         =  3.0 + xs_ov + psi_t * inv_phit0 + xgs_ov;
                `lin_exp(arg1, Dgate)
                temp         =  BOV * (-1.5 + zg * (gc2oveff + gc3oveff * zg));
                if (temp > 0.0) begin
                    TP           = `dev3_exp(temp);
                end else begin
                    `linmin_exp(temp, TP)
                end
                if (temp1 > 0.0) begin
                    TP2          = `dev3_exp(temp1);
                end else begin
                    `linmin_exp(temp1, TP2)
                end
                temp         =  (1.0 + Dsi) / (1.0 + Dgate);
                if (temp < 1.0e-80) begin
                    temp        =  1.0e-80;
                end
                temp1        =  GCDOV_i * (Vgdu - GCVDOV_i);
                `lin_exp(temp1, temp2)
                temp3        =  GCDOV_i * Vsdu + temp1;
                `lin_exp(temp3, temp4)
                Igsov        =  igoveff * TP * ln(temp) * (1.0 + temp2) / (1.0 + temp4) - igovefffowler * TP2 * (1.0 + temp2) / (1.0 + temp4);
            end
            //  Gate-drain overlap-LDD component of gate current
            if ((IGOVINVD_i > 0.0) || (IGOVACCD_i > 0.0)) begin
                arg2mina     =  Vovd + Dov;
                psi_t        = `MIN_FUNC(0.0, arg2mina, 0.01);
                zg           =  sqrt(Vovd * Vovd + 1.0e-4) * inv_CHIB;
                `lin_exp(0.5 * xgd_ov, temp)
                temp1        =  1.0 / (1.0 + temp);
                temp2        =  1.0 - temp1;
                gc2oveff     =  GC2OVACC_i * temp1 + GC2OVINV_i * temp2;
                gc3oveff     =  GC3OVACC_i * temp1 + GC3OVINV_i * temp2;
                gcqoveff     =  GCQOVACC * temp1 + GCQOVINV * temp2;
                igoveff      =  IGOVACCD_i * temp1 + IGOVINVD_i * temp2;
                igovefffowler =  FNOVINVD_i * temp2 * 1.0e-6;
                temp1        =  BOV * (-1.0 * GCOVINVFN_i/zg);
                if (gc3oveff < 0.0) begin
                    zg           = `MIN_FUNC(zg, gcqoveff, 1.0e-6);
                end
                arg1         =  3.0 + xd_ov + psi_t * inv_phit0;
                `lin_exp(arg1, Dsi)
                arg1         =  3.0 + xd_ov + psi_t * inv_phit0 + xgd_ov;
                `lin_exp(arg1, Dgate)
                temp         =  BOV * (-1.5 + zg * (gc2oveff + gc3oveff * zg));
                if (temp > 0.0) begin
                    TP           = `dev3_exp(temp);
                end else begin
                    `linmin_exp(temp, TP)
                end
                if (temp1 > 0.0) begin
                    TP2          = `dev3_exp(temp1);
                end else begin
                    `linmin_exp(temp1, TP2)
                end
                temp         =  (1.0 + Dsi) / (1.0 + Dgate);
                if (temp < 1.0e-80) begin
                    temp         =  1.0e-80;
                end
                temp1        =  GCDOV_i * (Vgsu - GCVDOV_i);
                `lin_exp(temp1, temp2)
                temp3        =  GCDOV_i * Vdsu + temp1;
                `lin_exp(temp3, temp4)
                Igdov        =  igoveff * TP * ln(temp) * (1.0 + temp2) / (1.0 + temp4) - igovefffowler * TP2 * (1.0 + temp2) / (1.0 + temp4);
            end
        //  Gate-channel component of gate current (no gate to bulk current in FDSOI)
            if (IGINV_i > 0.0) begin
                half_x_ds    = -delta_k1q1_dc * inv_k1_dc;
                `lin_exp((2.0 * half_x_ds - xdeff_dc), temp)
                Vm           =  phit * (half_x_ds + `LN2 - ln(1.0 + temp));
                q1m          =  0.5 * (q1s_dc + q1d_dc);
                Voxm         =  phit * q1m;
                arg2mina     =  Voxm + Dch;
                psi_t        = `MIN_FUNC(0.0, arg2mina, 0.01);
                zg           =  sqrt(Voxm * Voxm + 1.0e-4) * inv_CHIB;
                if (GC3CH_i < 0.0) begin
                    zg           = `MIN_FUNC(zg, GCQCH, 1.0e-06);
                end
                xg1xshift    =  xg1x_dc + Eg_2phit0;
                x_m          =  xg1xshift - q1m;
                arg1         = (x_m + (psi_t - alpha_b - Vm) * inv_phit) * n_iginv;
                `lin_exp(arg1,Dsi)
                arg1         = -(Vgs - Vm) * inv_phit * n_iginv;
                `lin_exp(arg1,temp)
                Dgate        =  Dsi * temp;
                temp         =  BCH * (-1.5 + zg * (GC2CH_i + GC3CH_i * zg));
                if (temp > 0.0) begin
                    TP           = `dev3_exp(temp);
                end else begin
                    `lin_exp(temp, TP)
                end
                Igc0         =  IGINV_i * TP * ln((1.0 + Dsi) / (1.0 + Dgate));
                // Source/drain partitioning of gate-channel current
                if ((xg1xshift <= 0.0) || ((GC2CH_i == 0.0) && (GC3CH_i == 0.0))) begin
                    igc          =  1.0;
                    igcd_h       =  0.5;
                end else begin
                    temp         =  GC2CH_i + 2.0 * GC3CH_i * zg;
                    u0           =  CHIB_i / (temp * BCH) * inv_phit;
                    x            =  half_x_ds / u0;
                    u0_div_H     =  u0 * inv_k1h1_dc * k1_dc;
                    Bg           =  u0_div_H * (1.0 - u0_div_H) * 0.5;
                    Ag           =  0.5 - 3.0 * Bg;
                    if (x < 1.0e-3) begin
                        xsq          =  x * x;
                        igc          =  1.0 + xsq * (`INV6 + u0_div_H * `INV3 + xsq * `INV6 * (0.05 + 0.2 * u0_div_H));
                        igcd_h       =  0.5 * igc - x * `INV6 * (1.0 + xsq * (0.4 * (Bg + 0.25) + 0.0285714285714 * xsq * (0.125 + Bg)));
                    end else begin
                        inv_x        =  1.0 / x;
                        `lin_exp(x, ex)
                        inv_ex       =  1.0 / ex;
                        temp         =  ex - inv_ex;
                        temp2        =  ex + inv_ex;
                        igc          =  0.5 * ((1.0 - u0_div_H) * temp * inv_x + u0_div_H * temp2);
                        igcd_h       =  0.5 * (igc - temp * (Bg - Ag * inv_x * inv_x) - Ag * temp2 * inv_x);
                    end
                end
                Igc          =  Igc0 * igc;
                Igcd         =  Igc0 * igcd_h;
                Igcs         =  Igc - Igcd;
            end
            if (sigVds < 0.0) begin
                Igs          =  Igcd + Igsov;
                Igd          =  Igcs + Igdov;
            end else begin
                Igs          =  Igcs + Igsov;
                Igd          =  Igcd + Igdov;
            end
        end

    // *********** GIDL/GISL current ***********
        Igisl        =  0.0;
        // GISL current computation
        if ((SWGIDL > 0) && (AGIDL_i > 0.0) && (Vovs < 0.0)) begin
            Vtovs        =  sqrt(Vovs * Vovs + CGIDL_i * CGIDL_i * Vsbu * Vsbu + 1.0e-6);
            temp         = -BGIDL_i / Vtovs;
            `lin_exp(temp, temp2)
            temp3        =  DGIDL_i * Vsdu;
            `lin_exp(temp3, temp4)
            Igisl        = -AGIDL_i * Vsdu * Vovs * Vtovs * temp2 * 0.5 * (1.0 + temp4);
        end
        Igidl        =  0.0;
        // GIDL current computation
        if ((SWGIDL > 0) && (AGIDLD_i > 0.0) && (Vovd < 0.0)) begin
            Vtovd        =  sqrt(Vovd * Vovd + CGIDLD_i * CGIDLD_i * Vdbu * Vdbu + 1.0e-6);
            temp         = -BGIDLD_i / Vtovd;
            `lin_exp(temp, temp2)
            temp3        =  DGIDLD_i * Vdsu;
            `lin_exp(temp3, temp4)
            Igidl        = -AGIDLD_i * Vdsu * Vovd * Vtovd * temp2 * 0.5 * (1.0 + temp4);
        end

    // *********** Edge transistor ***********
        Ids_edge     =  0.0;
        if (SWEDGE > 0) begin
            // Conditioning of terminal voltages
            xd_edge      =  Vds * inv_phit_edge;
            xdsx_edge    =  (sqrt(Vds * Vds + 0.01) - 0.1) * inv_phit_edge;
            dxdsx_edge   =  0.5 * (xd_edge - xdsx_edge);
            xg10_edge    =  (Vgs - VFB1EDGE_i) * inv_phit_edge - dxdsx_edge - Eg_2phit0;
            xg20_edge    =  (-Vsb - VFB2EDGE_i) * inv_phit_edge - dxdsx_edge - Eg_2phit0;
            sce1_edge    =  1.0 / (1.0 + PSCE1EDGE_i);
            sce2_edge    =  1.0 / (1.0 + PSCE2EDGE_i);
            xd0_edge     =  CFDEDGE_i * inv_phit_edge;
            temp         =  2.0 * xd0_edge * (sqrt(1.0 + xdsx_edge / xd0_edge) - 1.0);
            dxg1_dibl_edge =  CF1EDGE_i * temp;
            dxg2_dibl_edge =  CF2EDGE_i * temp;
            xg1_edge     =  (xg10_edge + dxg1_dibl_edge) * sce1_edge + dxdsx_edge;
            xg2_edge     =  (xg20_edge + dxg2_dibl_edge) * sce2_edge + dxdsx_edge;
            xg1x_edge    = `MIN_FUNC(xg2_edge + CIC1EDGE_i * (xg1_edge - xg2_edge), xsatmax, 0.01);
            xg2x_edge    = `MIN_FUNC(xg1_edge + CIC2EDGE_i * (xg2_edge - xg1_edge), xsatmax, 0.01);
            k1_edge      =  k1_1D / sce1_edge;
            k2_edge      =  k2_1D / sce2_edge;
            inv_k1_edge  =  1.0 / k1_edge;
            inv_k2_edge  =  1.0 / k2_edge;
            keq_edge     =  1.0 / (1.0 + inv_k1_edge + inv_k2_edge);
            A0_edge      =  A0_Csisq_edge / (CsiPrime_dc * CsiPrime_dc);
            Dx_WI_edge   =  keq_edge * (xg1x_edge - xg2x_edge);
            // prefactor of inversion charge in weak inversion (ie. qilow / exp(xg1x_edge))
            if (abs(xg2x_edge - xg1x_edge) <= 1.0e-12) begin
                temp1        =  (1.0 - keq_edge * inv_k1_edge - keq_edge * inv_k2_edge);
                temp2        =  (inv_k2_edge + 0.5 * inv_k1_edge * keq_edge * inv_k1_edge - 0.5 * inv_k2_edge * keq_edge * inv_k2_edge - 0.5 / keq_edge) * Dx_WI_edge;
                temp3        =  0.5 * (temp1 - temp2) * A0_edge / keq_edge;
            end else begin
                temp1        =  exp(-inv_k1_edge * Dx_WI_edge);
                temp2        =  exp((inv_k2_edge - 1.0  / keq_edge) * Dx_WI_edge);
                temp3        =  A0_edge * (temp1 - temp2) / (2.0 * Dx_WI_edge);
            end
            prefac_qilow_edge   =  temp3;
            // Inversion charge at source side
            `Wfunc(prefac_qilow_edge, xg1x_edge, temp)
            qis_edge     =  temp;
            // Inversion charge at drain side
            `Wfunc(prefac_qilow_edge, (xg1x_edge - xdeff_dc), temp)
            qid_edge     =  temp;
            // Edge transistors current
            norm_Ids_edge =  (0.5 * (qis_edge + qid_edge) + 1.0) * (qis_edge - qid_edge);
            fact_Ids_edge =  phit_edge * phit_edge * BETNEDGE_i;
            Ids_edge     =  fact_Ids_edge * Cox1Prime * norm_Ids_edge / Gmob_dc;
        end

    // *********** Impact Ionization current adapted from PSP 103 ***********
        mavl         =  0.0;
        Iimpact      =  0.0;
        if (SWIMPACT != 0) begin
            delVsat      =  (xd - A3_i * xdeff_dc) / inv_phit;
            if (delVsat > 0) begin
                temp2        = -1.0 * A2_i / (delVsat + 1.0e-30);
                `lin_exp(temp2, temp)
                mavl         =  A1_i * delVsat * temp;
                Iimpact      =  mavl * (Ids + Ids_edge);
            end
        end

     // *********** Self heating effect ***********
        if (SWSHE_i > 0) begin
            temp         =  abs((Ids + Ids_edge) * Vds) * RTH_i;
            if (temp > 1.0e8 * TMAX) begin
                Ithpwr       = -(TMAX + 0.25 / TMAX) / RTH_i;
            end else begin
                Ithpwr       = -(1.0 * `MIN_FUNC(temp, TMAX, 1.0) + 0.25 / TMAX) / RTH_i;
            end
            Ithrc        =  DTC / RTH_i;
        end else begin
            Ithpwr       =  0.0;
            Ithrc        =  0.001 * Temp(THPWR);
        end

     // *********** Parasitic resistances (including noise) ***********
        rgatenoise   =  nt0_4KT * ggate;
        rsourcenoise =  nt0_4KT * gsource;
        rdrainnoise  =  nt0_4KT * gdrain;
        rwellnoise   =  nt0_4KT * gwell;

    end    // evaluateStatic

    //  Calculation of All Charges
    //  *************************************************************************************************************
    begin : evaluateDynamic

    // *********** Declaration of local variables ***********
        real k1q1m, k2q2m, k1q1eff, k2q2eff, k1q1deff, k2q2deff, xeffs, xeffd, xstars, xstard, lambdaf, lambdab;
        real xalphaf, xalphab, xedgefs, xedgefd, xedgebs, xedgebd;

        //  Core's model calculation for AC
        begin : Qcalc_ac

            // Declaration of local variables
            `CoreLocalVarDecl

            // Core's model calculation
            if (SWQMOD > 0) begin
                vfb1_loc     =  VFBAC1_i;
                vfb2_loc     =  VFBAC2_i;
                psce1_loc    =  PSCEAC1_i;
                psce2_loc    =  PSCEAC2_i;
                cf1_loc      =  CFAC1_i;
                cf2_loc      =  CFAC2_i;
                sat_phit_loc =  sat_phit_ac;
                gamAX_loc    =  gamAX_ac;
                alp_loc      =  ALPAC_i;
                `QCalculation
                xg20shift_ac =  xg20shift;
                diff_min_ac  =  diff_min;
                A0_ac        =  A0;
                inv_k1_ac    =  inv_k1;
                inv_k2_ac    =  inv_k2;
                keq_ac       =  keq;
                Dx_WI_ac     =  Dx_WI;
                CsiPrime_ac  =  CsiPrime;
                Dx_WI_1D_ac  =  Dx_WI_1D;
                dleff_ac     =  dleff;
                xedge_ac     =  xedge;
                sce1_ac      =  sce1;
                sce2_ac      =  sce2;
                dxg1_dibl_ac =  dxg1_dibl;
                xg2_ac       =  xg2;
                xg2x_ac      =  xg2x;
                k1_ac        =  k1;
                k2_ac        =  k2;
                k1q1s_ac     =  k1q1s;
                k2q2s_ac     =  k2q2s;
                xdrifts_ac   =  xdrifts;
                k1q1d_ac     =  k1q1d;
                k2q2d_ac     =  k2q2d;
                xdriftd_ac   =  xdriftd;
                qim_ac       =  qim;
                ratio_pd_ac  =  ratio_pd;
                qi1m_ac      =  qi1m;
                qi2m_ac      =  qi2m;
                zsat_ac      =  zsat;
                qmfact1_ac   =  qmfact1;
                qmfact2_ac   =  qmfact2;
                delta_k1q1_ac =  delta_k1q1;
                delta_k2q2_ac =  delta_k2q2;
                prod1_ac     =  prod1;
                prod2_ac     =  prod2;
            end else begin
                xg20shift_ac =  xg20shift_dc;
                diff_min_ac  =  diff_min_dc;
                A0_ac        =  A0_dc;
                inv_k1_ac    =  inv_k1_dc;
                inv_k2_ac    =  inv_k2_dc;
                keq_ac       =  keq_dc;
                Dx_WI_ac     =  Dx_WI_dc;
                CsiPrime_ac  =  CsiPrime_dc;
                Dx_WI_1D_ac  =  Dx_WI_1D_dc;
                dleff_ac     =  dleff_dc;
                xedge_ac     =  xedge_dc;
                sce1_ac      =  sce1_dc;
                sce2_ac      =  sce2_dc;
                dxg1_dibl_ac =  dxg1_dibl_dc;
                xg2_ac       =  xg2_dc;
                xg2x_ac      =  xg2x_dc;
                k1_ac        =  k1_dc;
                k2_ac        =  k2_dc;
                k1q1s_ac     =  k1q1s_dc;
                k2q2s_ac     =  k2q2s_dc;
                xdrifts_ac   =  xdrifts_dc;
                k1q1d_ac     =  k1q1d_dc;
                k2q2d_ac     =  k2q2d_dc;
                xdriftd_ac   =  xdriftd_dc;
                qim_ac       =  qim_dc;
                ratio_pd_ac  =  ratio_pd_dc;
                qi1m_ac      =  qi1m_dc;
                qi2m_ac      =  qi2m_dc;
                zsat_ac      =  zsat_dc;
                qmfact1_ac   =  qmfact1_dc;
                qmfact2_ac   =  qmfact2_dc;
                delta_k1q1_ac =  delta_k1q1_dc;
                delta_k2q2_ac =  delta_k2q2_dc;
                prod1_ac     =  prod1_dc;
                prod2_ac     =  prod2_dc;

            end
        end // Qcalc_ac

    // *********** Quantum mechanical corrections ***********
        temp         =  FSCEAC_i * (Dx_WI_1D_ac - Dx_WI_ac) / (1.0 + 0.25 * qim_ac);
        k1q1m        =  0.5 * (k1q1s_ac + k1q1d_ac) + temp;
        k2q2m        =  0.5 * (k2q2s_ac + k2q2d_ac) - temp;
        if (QMC > 0.0) begin
            k1q1eff      =  k1q1m + qi1m_ac / qmfact1_ac - qi1m_ac;
            k2q2eff      =  k2q2m + qi2m_ac / qmfact2_ac - qi2m_ac;
        end else begin
            k1q1eff      =  k1q1m;
            k2q2eff      =  k2q2m;
        end

    // *********** Intrinsic charge model ***********
        // Front interface
        temp1        =  delta_k1q1_ac * prod1_ac * `INV3;
        temp2        =  delta_k1q1_ac * `INV6 * (1.0 + prod1_ac * (1.0 - 0.2 * prod1_ac));
        k1q1deff     =  0.5 * k1q1eff * ratio_pd_ac + temp2;
        k1q1eff      =  k1q1eff * ratio_pd_ac + temp1;
        // Back interface
        temp1        =  delta_k2q2_ac * prod2_ac * `INV3;
        temp2        =  delta_k2q2_ac * `INV6 * (1.0 + prod2_ac * (1.0 - 0.2 * prod2_ac));
        k2q2deff     =  0.5 * k2q2eff + temp2;
        k2q2eff      =  k2q2eff + temp1;
        // Electrode charges
        temp         =  CsiPrime_ac * area_phit;
        Qg           =  temp * k1q1eff;
        Qb           =  temp * k2q2eff;
        Qd           = -temp * (k1q1deff + k2q2deff);

    // *********** Inner fringe charge ***********
        if (FIF_i > 0.0) begin
            temp         =  xth_1D + 2.0 * `LN2;
            xeffs        =  xdrifts_ac + temp;
            xeffd        =  xdriftd_ac + temp;
            xstars       = `MIN_FUNC(xeffs, xth_1D, 9.0);
            xstard       = `MIN_FUNC(xeffd, xth_1D + xd, 9.0);
            lambdaf      =  lambda2D * sqrt(keq_ac * (0.5 + inv_k2_ac));
            lambdab      =  lambda2D * sqrt(keq_ac * k1_ac * inv_k2_ac * (0.5 + inv_k1_ac));
            xalphaf      =  lambdaf * lambdaf * inner_sd;
            xalphab      =  lambdab * lambdab * inner_sd;
            temp1        =  xsd - xstars;
            temp2        =  xsd + xd - xstard;
            temp         =  2.0 * xalphaf;
            xedgefs      =  xstars + temp * (sqrt(1.0 + temp1 / xalphaf) - 1.0);
            xedgefd      =  xstard + temp * (sqrt(1.0 + temp2 / xalphaf) - 1.0);
            temp         =  2.0 * xalphab;
            xedgebs      =  xstars + temp * (sqrt(1.0 + temp1 / xalphab) - 1.0);
            xedgebd      =  xstard + temp * (sqrt(1.0 + temp2 / xalphab) - 1.0);
            temp         =  fif_phit * CsiPrime_ac;
            temp1        = -temp * lambdaf * k1_ac * sce1_ac;
            temp2        = -temp * lambdab * k2_ac * sce2_ac;
            temp         = `MAX_FUNC(xedgefs - xeffs, 0.0, 1.0);
            Qgsif        =  temp1 * temp * temp / (xedgefs - xstars);
            temp         = `MAX_FUNC(xedgefd - xeffd, 0.0, 1.0);
            Qgdif        =  temp1 * temp * temp / (xedgefd - xstard);
            temp         = `MAX_FUNC(xedgebs - xeffs, 0.0, 1.0);
            Qbsif        =  temp2 * temp * temp / (xedgebs - xstars);
            temp         = `MAX_FUNC(xedgebd - xeffd, 0.0, 1.0);
            Qbdif        =  temp2 * temp * temp / (xedgebd - xstard);
        end else begin
            Qgsif        =  0.0;
            Qgdif        =  0.0;
            Qbsif        =  0.0;
            Qbdif        =  0.0;
        end

    // *********** Outer fringe and overlaps charges ***********
        Qgse         =  CFR_i * Vgsu;
        Qgde         =  CFRD_i * Vgdu;
        temp         = `MAX_FUNC(1.0 - COVDL_i * dleff_ac * (1.0 - COVDLB_i * xg20shift_ac), 0.0, 0.2);
        Qovs         =  COV_i * Vovscv * temp;
        Qovd         =  COVD_i * Vovdcv * temp;
        Qgbe         =  CGBOV_i * Vgb;

    // *********** Drain-source coupling charge ***********
        Qdse         =  CSD_i * Vds;

    // *********** Substrate extrinsic charge model ***********
        Qssub        = -(Cox2Init * ASOURCE_i + CSDBP_i * PSOURCE_i) * Vsbu;
        Qdsub        = -(Cox2Init * ADRAIN_i + CSDBP_i * PDRAIN_i) * Vdbu;

    // *********** Self heating effect ***********
        if (SWSHE_i > 0) begin
            Qth          =  CTH_i * DTC;
        end else begin
            Qth          =  0.0;
        end

    end    // evaluateDynamic

    //  Currents contributions
    //  *************************************************************************************************************
    begin : loadStatic

    // *********** Declaration of local variables ***********
        real Ithpwre, Ithrce;

    // *********** Intrinsic MOSFET current and Impact Ionization ***********
        Idse         =  MULT_I * MULT_i_int * (Ids + Ids_edge + Iimpact);

    // *********** Gate currents ***********
        Igse         =  MULT_I * MULT_i_int * Igs;
        Igde         =  MULT_I * MULT_i_int * Igd;

    // *********** GIDL/GISL currents ***********
        Igidle       =  MULT_I * MULT_i_int * Igidl;
        Igisle       =  MULT_I * MULT_i_int * Igisl;

    // *********** Self heating power ***********
        Ithpwre      =  MULT_i_int * Ithpwr;
        Ithrce       =  MULT_i_int * Ithrc;

    // *********** Convert back for NMOS-PMOS and Source-Drain interchange ***********
        if (sigVds < 0) begin
            I(si, di)    <+  TYPE * Idse;
        end else begin
            I(di, si)    <+  TYPE * Idse;
        end
        I(di, si)    <+  TYPE * (Igidle - Igisle);
        I(gp, si)    <+  TYPE * Igse;
        I(gp, di)    <+  TYPE * Igde;
        I(si, bp)    <+  0.0;
        I(di, bp)    <+  0.0;
        I(gp, bp)    <+  0.0;
        I(di, si)    <+  MULT_I * gmin * V(di, si);

        // *********** Self heating effect ***********
        Pwr(THPWR)   <+  Ithpwre;
        Pwr(THRC)    <+  Ithrce;

        // *********** Parasitic resistances (including noise) ***********
        // gate parasitic resistance
        if ((RG_i) > 0.0) begin
            I(g, gp)    <+  MULT_I * MULT_i_int * (ggate) * V(g, gp);
            I(g, gp)    <+  white_noise(MULT_I * MULT_i_int * (rgatenoise), "rgate");
        end else begin
            V(g, gp)    <+  0.0;
        end
        // source resistance
        if ((RSE_i) > 0.0) begin
            I(s, si)    <+  MULT_I * MULT_i_int * (gsource) * V(s, si);
            I(s, si)    <+  white_noise(MULT_I * MULT_i_int * (rsourcenoise), "rsource");
        end else begin
            V(s, si)    <+  0.0;
        end
        // drain resistance
        if ((RDE_i) > 0.0) begin
            I(d, di)    <+  MULT_I * MULT_i_int * (gdrain) * V(d, di);
            I(d, di)    <+  white_noise(MULT_I * MULT_i_int * (rdrainnoise), "rdrain");
        end else begin
            V(d, di)    <+  0.0;
        end
        // well resistance
        if ((RWELL_i) > 0.0) begin
            I(b, bp)    <+  MULT_I * MULT_i_int * (gwell) * V(b, bp);
            I(b, bp)    <+  white_noise(MULT_I * MULT_i_int * (rwellnoise), "rwell");
        end else begin
            V(b, bp)    <+  0.0;
        end

    end    // loadStatic

    //  Charges contributions
    //  *************************************************************************************************************
    begin : loadDynamic

    // *********** Declaration of local variables ***********
        real temp_q;
`ifdef NQSmodel
            real itaueff, Qg_wo_mult, Qb_wo_mult, Qd_wo_mult;
            Qg_wo_mult   =  Qg;
            Qb_wo_mult   =  Qb;
            Qd_wo_mult   =  Qd;
            Qs           = -(Qg + Qb + Qd);
            if (sigVds < 0.0) begin
                Qd_wo_mult   =  Qs;
            end
`endif // NQSmodel

    // *********** Intrinsic MOSFET charges ***********
        Qg           =  MULT_Q * MULT_i_int * Qg;
        Qb           =  MULT_Q * MULT_i_int * Qb;
        Qd           =  MULT_Q * MULT_i_int * Qd;
        Qs           = -(Qg + Qb + Qd);

    // *********** Inner fringe charges ***********
        Qgsif        =  MULT_Q * MULT_i_int * Qgsif;
        Qgdif        =  MULT_Q * MULT_i_int * Qgdif;
        Qbsif        =  MULT_Q * MULT_i_int * Qbsif;
        Qbdif        =  MULT_Q * MULT_i_int * Qbdif;

    // *********** Fringe/overlap charges ***********
        Qgse         =  MULT_Q * MULT_i_int * Qgse;
        Qgde         =  MULT_Q * MULT_i_int * Qgde;
        Qovs         =  MULT_Q * MULT_i_int * Qovs;
        Qovd         =  MULT_Q * MULT_i_int * Qovd;

    // *********** Gate-bulk overlap charge ***********
        Qgbe         =  MULT_Q * MULT_i_int * Qgbe;

    // *********** Substrate extrinsic charge ***********
        Qssub        =  MULT_Q * MULT_i_int * Qssub;
        Qdsub        =  MULT_Q * MULT_i_int * Qdsub;

    // *********** Drain-source coupling charge ***********
        Qdse         =  MULT_Q * MULT_i_int * Qdse;

    // *********** Self heating energy ***********
        Qth          =  MULT_i_int * Qth;

    // *********** Convert back Source-Drain interchange ***********
        if (sigVds < 0.0) begin
            temp_q       =  Qd;      // Qd <--> Qs
            Qd           =  Qs;
            Qs           =  temp_q;
            Qdse         = -Qdse;    // Qdse <--> -Qdse
            temp_q       =  Qgdif;   // Qgdif <--> Qgsif
            Qgdif        =  Qgsif;
            Qgsif        =  temp_q;
            temp_q       =  Qbdif;   // Qbdif <--> Qbsif
            Qbdif        =  Qbsif;
            Qbsif        =  temp_q;
        end

`ifdef NQSmodel
    // *********** NQS subcircuit model ***********
            if (MULT_i_int > 0.0) begin
                itaueff      =  1.0e-9 * betneff / (Gvsat * AREAQ_i) * ( (KDRIFT_i) * (Qg_wo_mult + Qb_wo_mult) / (AREAQ_i * Cox1Init) + KDIFF_i * phit);
            end else begin
                itaueff      =  0.0;
            end
            I(Gnqs, gndnqs)  <+  ddt(FRACINV_i * (Qg_wo_mult + Qb_wo_mult));
            I(Gnqs, gndnqs)  <+  itaueff * V(Gnqs, gndnqs);
            I(Gnqs, gndnqs)  <+  ddt(1.0e-9 * V(Gnqs, gndnqs));
            I(Dnqs, gndnqs)  <+  ddt(Qd_wo_mult);
            I(Dnqs, gndnqs)  <+  itaueff * V(Dnqs, gndnqs);
            I(Dnqs, gndnqs)  <+  ddt(1.0e-9 * V(Dnqs, gndnqs));
            I(Gnqs2, gndnqs) <+  sqrt(KFRACINV_i) * ddt((1.0 - FRACINV_i) * (Qg_wo_mult + Qb_wo_mult));
            I(Gnqs2, gndnqs) <+  itaueff * V(Gnqs2, gndnqs);
            I(Gnqs2, gndnqs) <+  KFRACINV_i * ddt(1.0e-9 * V(Gnqs2, gndnqs));
`endif // NQSmodel

    // *********** Introduction of dynamic currents ***********
        I(bp, si)    <+  TYPE * (ddt(Qb) + ddt(Qssub) + ddt(Qbsif));
        I(gp, di)    <+  TYPE * (ddt(Qgde) + ddt(Qovd) + ddt(Qgdif));
        I(bp, di)    <+  TYPE * (ddt(Qdsub) + ddt(Qbdif));
        I(gp, bp)    <+  TYPE * ddt(Qgbe);

`ifdef NQSmodel
            I(gp, si)    <+  TYPE * (-itaueff * MULT_Q * MULT_i_int * (V(Gnqs, gndnqs) + V(Gnqs2, gndnqs) / sqrt(KFRACINV_i)) - ddt(Qb) + ddt(Qgse) + ddt(Qovs) + ddt(Qgsif));
            I(di, si)    <+  TYPE * (-itaueff * MULT_I * MULT_i_int * V(Dnqs, gndnqs) + ddt(Qdse));
`else
            I(gp, si)    <+  TYPE * (ddt(Qg) + ddt(Qgse) + ddt(Qovs) + ddt(Qgsif));
            I(di, si)    <+  TYPE * (ddt(Qd) + ddt(Qdse));
`endif // NQSmodel

        // *********** Self heating effect ***********
        Pwr(THRC)   <+  ddt(Qth);

    end    // loadDynamic

    //  Noise
    //  *************************************************************************************************************
    begin : noise

    // *********** Declaration of local variables ***********
        real Nunit, dm, qimstar, Nstar, Nmstar, DeltaN, Sids_fl, t1, sqrt_t2, t2, r, lc, lcinv2, g_ideal, t2x12;
        real gSid, sqrt_zsatexc, Sidexc, Sids_th, COX_qm, CGeff, CSGeff, CDGeff, gSig, SigR_th, migid, cigid2;
        real Sids_th_u, Sigs_sh, Sigd_sh, Sids_sh, shot_iavl;

    // *********** Noise variable calculation ***********
        Nunit         =  CsiPrime_dc / `QELE * phit;
        dm            = -0.5 * (ds_dc + dd_dc);
        qimstar       =  qim_dc + dm;

    // *********** Channel current thermal noise ***********
        temp          =  qim_dc / qimstar;
        t1            = `MAX_FUNC(temp, 0.0, 1.0e-20);
        sqrt_t2       = -`INV6 * delta_k1q1_dc * inv_k1h1_0_dc;
        t2            =  sqrt_t2 * sqrt_t2;
        r             =  hsat_dc - 1.0;
        lc            =  max(1.0 - 12.0 * r * t2, 1.0e-20);
        lcinv2        =  1.0 / (lc * lc);
        g_ideal       =  betneff * CsiPrime_dc * phit * qimstar * FdL / Gvsat / qmfact;
        t2x12         =  12.0 * t2;
        temp1         =  t1 + t2x12 - 2.0 * (1.0 + t1) * t2x12 * r;
        temp2         =  max(temp1, 1.0e-40);
        gSid          =  g_ideal * lcinv2 * temp2;
        if (FNTEXC_i > 0.0) begin
            // Introduction of excess noise
            sqrt_zsatexc  =  Ggamma_dc / Gmob_dc;
            Sidexc        =  fac_exc * Ids * xdeff_dc * phit0 / ((1.0 + sqrt_zsatexc * sqrt_zsatexc) * lc * lc);
            gSid          =  gSid + Sidexc / nt0;
        end
        Sids_th       =  MULT_I * MULT_i_int * nt * gSid;

    // *********** Induced gate noise and correlation ***********
        COX_qm        =  k1_ac * CsiPrime_ac * AREAQ_i / qmfact1_ac;
        CGeff         =  (1.0 + zsat_ac) * COX_qm;
        CDGeff        =  CGeff * (0.5 - 0.25 * sigVds * sqrt_t2);
        CSGeff        =  CGeff - CDGeff;
        migid         =  0.0;
        cigid2        =  0.0;
        if (SWIGN > 0) begin
            temp1         =  t1 / 12.0 - t2 * (t1 + 0.2 - t2x12) - 1.6 * t2 * (t1 + 1.0 - t2x12) * r;
            temp2         =  max(temp1, 1.0e-40);
            gSig          =  g_ideal * lc * lc / temp2;
            SigR_th       =  MULT_I * MULT_i_int * nt * gSig;
            if (gSid > 0) begin
                migid         =  lcinv2 * sqrt_t2 * (1.0 - t2x12 - (t1 + 19.2 * t2 - t1 * t2x12) * r);
                cigid2        =  migid * migid * gSig / gSid;
                cigid2        = `MIN_FUNC(`MAX_FUNC(cigid2, 0.0, 1.0e-40), 1.0, 1.0e-40);
            end
        end else begin
            gSig          =  1.0;
            SigR_th       =  0.0;
        end
        Sids_th_u     =  Sids_th * (1.0 - cigid2);

    // *********** Channel current flicker noise ***********
        Nstar         =  Nunit;
        Nmstar        =  Nunit * (qim_dc + 1.0);
        DeltaN        =  Nunit * (qis_dc - qid_dc);
        temp1         = (NFA_i - NFB_i * Nstar + NFC_i * Nstar * Nstar) * ln((Nmstar + 0.5 * DeltaN) / (Nmstar - 0.5 * DeltaN));
        temp2         =  temp1 + (NFB_i + NFC_i * (Nmstar - 2.0 * Nstar)) * DeltaN;
        temp          =  1.0 + (NFE_i * esurf1_dc + NFEB_i * esurf2_dc) / (qim_dc + 1.0);
        temp3         = `MAX_FUNC(temp, 0.01, 1.0e-4);
        temp          = `QELE * fact_Ids * Ids / Gvsat * temp2 / Nstar * temp3;
        Sids_fl       =  MULT_FN * MULT_i_int * max(temp, 0.0);

    // *********** Gate currents shot noise ***********
        Sigs_sh       =  2.0 * `QELE * MULT_I * MULT_i_int * abs(Igs);
        Sigd_sh       =  2.0 * `QELE * MULT_I * MULT_i_int * abs(Igd);

    // *********** Noise related impact ionization currents ***********
        shot_iavl     =  2.0 * `QELE * ((mavl + 1.0) * abs(Iimpact));

        // *********** GIDL/GISL shot noise ***********
        Sids_sh       =  2.0 * `QELE * MULT_I * MULT_i_int * abs(Igidl - Igisl) + MULT_I * MULT_i_int * shot_iavl;

    // *********** Noise contributions ***********
        // Thermal induced gate noise
        I(NOII)       <+  white_noise(SigR_th, "ign_g");
        I(NOIR)       <+  gSig * V(NOIR);
        I(NOIC)       <+  ddt(CGeff * V(NOIC));
        I(gp, si)     <+  ddt(-CSGeff * V(NOIC));
        I(gp, di)     <+  ddt(-CDGeff * V(NOIC));
        // Drain current thermal noise
        I(di, si)     <+  white_noise(Sids_th_u, "thermal_ids");
        I(di, si)     <+  sigVds * migid * I(NOII);
        // Drain current flicker noise
        I(di, si)     <+  flicker_noise(sigVds * Sids_fl, EF_i, "flicker");
        // Gate currents shot noise
        I(gp, si)     <+  white_noise(Sigs_sh, "shot_igs");
        I(gp, di)     <+  white_noise(Sigd_sh, "shot_igd");
        // GIDL/GISL shot noise
        I(di, si)     <+  white_noise(Sids_sh, "shot_ids");
    end    // noise

    //  Operating point info
    //  *************************************************************************************************************
    begin : OPinfo

`ifdef OP_CALC
        // *********** Declaration of local variables ***********
            real r1init_op, r2init_op, x1init_op, x2init_op, xth1init_op, xth2init_op, xg1thinit_op, vthinit_op;
            real inv_phit0_op, EgSi_op, EgGe_op, dEg_op, Eg_op, Eg_2phit0_op, dVfbch_op, neff_op, inv_phit_op;
            real dVfbpdep_op, A0_Csisq_op, xth_1D_op, xSDdep_op, CF1_op, CF2_op, xd0_op, qq_op, VFB1_op, VFB2_op;
            real xd_op, xdsx_op, dxdsx_op, xg10_op, xg20_op, xg2eff_op, e1_op, e2_op, CsiPrime_op, k1_1D_QM_op;
            real k2_1D_QM_op, keq_1D_QM_op, Dx_WI_1D_op, x_WI_1D_op, x_1D_op, dleff_op, xedge_op, sce1_op, sce2_op;
            real dxg1_dibl_op, dxg2_dibl_op, xg1_op, xg2_op, xg2x_op, k1_op, k2_op, A0_op, exp_dxth_op, dxth_op;
            real diff_min_op, r1_op, r2_op, x1sat_op, x2sat_op, xth1_op, xth2_op, xg1th_op, vth_op, Vdsat, qde, qge;
            real qbe;

        // *********** Operation point output variables **********

        // Device type
            type          =  TYPE;

        // Threshold voltages
            inv_phit0_op  =  1.0 / (TKD * `KBOL_QELE);
            EgSi_op       = `EG0SI - `ALPHASI * TKD * TKD / (`BETASI + TKD);
            EgGe_op       = `EG0GE - `ALPHAGE * TKD * TKD / (`BETAGE + TKD);
            dEg_op        =  (EgGe_op - EgSi_op + `CG * one_m_xge) * XGE_i;
            Eg_op         =  EgSi_op + dEg_op;
            Eg_2phit0_op  =  0.5 * Eg_op * inv_phit0_op;
            dVfbch_op     =  0.05 * XGE_i - 0.5 * dEg_op;
            temp          =  sqrt(TKD * `INV300);
            temp1         = `NIFACT300 * temp * temp * temp;
            neff_op       =  temp1 * niratio;
            inv_phit_op   =  inv_phit0_op / (1.0 + CT_i * TKR / TKD);
            A0_Csisq_op   =  2.0 * `QELE * neff_op * epsch * inv_phit_op;
            xth_1D_op     =  ln((CsiPrime_0 * CsiPrime_0) / A0_Csisq_op) - `LN2 + Eg_2phit0_op;
            xSDdep_op     =  0.5 * `QELE * NSDDC_i * TSI_i / (Cox1Prime + Cox2Prime) * inv_phit_op;
            xd0_op        =  CFD_i * inv_phit_op;
            qq_op         =  0.0;
            dVfbpdep_op   =  0.0;
            if (SWPDEP > 0) begin
                dVfbpdep_op       =  (1.0 / inv_phit0_op) * ln(NP_i / neff_poly);
            end
            if (QMC > 0.0) begin
                if (TYPE == `NMOS) begin
                    qq_op         =  0.4 * QMC * `QMN * exp(-`INV3 * ln(tsisq / inv_phit_op));
                end else begin
                    qq_op         =  0.4 * QMC * `QMP * exp(-`INV3 * ln(tsisq / inv_phit_op));
                end
            end
            xd_op         =  Vds * inv_phit_op;
            xdsx_op       =  (sqrt(Vds * Vds + 0.01) - 0.1) * inv_phit_op;
            dxdsx_op      =  0.5 * (xd_op - xdsx_op);
            `vth(VFB1_t, VFB2_t, VFB1_i, PSCE1_i, PSCE2_i, CF1_t, CF2_t, k1_dc, k2_dc, A0_dc, diff_min_dc, xg2x_dc, xg2_dc, xedge_dc, sce1_dc, dxg1_dibl_dc)
            vth           =  vth_op;
            vthac         =  vth_op;
            if (SWQMOD > 0) begin
                `vth(VFBAC1_t, VFBAC2_t, VFBAC1_i, PSCEAC1_i, PSCEAC2_i, CFAC1_t, CFAC2_t, k1_ac, k2_ac, A0_ac, diff_min_ac, xg2x_ac, xg2_ac, xedge_ac, sce1_ac, dxg1_dibl_ac)
                vthac         =  vth_op;
            end

        // Saturation voltage calculation
            Vdsat         =  phit * xndssat_dc;

        // Calculation of output variables
            // Output voltages
            vds           =  Vds;
            vsb           =  Vsb;
            vgs           =  Vgs;
            vth_drive     =  vgs - vth;
            vdsat         =  Vdsat;
            vdsat_marg    =  vds - vdsat;
            // Output currents
            if (sigVds < 0) begin
                igidl         =  Igisle;
                igisl         =  Igidle;
                igs           =  Igde;
                igd           =  Igse;
            end else begin
                igidl         =  Igidle;
                igisl         =  Igisle;
                igs           =  Igse;
                igd           =  Igde;
            end
            ids           =  Idse;
            id            =  Idse + igidl - igisl - igd;
            is            = -Idse - igidl + igisl - igs;
            ig            =  Igse + Igde;
            iavl          =  MULT_I * MULT_i_int * Iimpact;
            idsedge       =  MULT_I * MULT_i_int * Ids_edge;
            ib            =  0.0;
            idb           =  0.0;
            isb           =  0.0;
            // Conductances and transconductances
            gm            =  TYPE * ddx(id, V(gp));
            gmb           =  TYPE * ddx(id, V(bp));
            if (sigVds < 0.0) begin
                gds           =  TYPE * ddx(id, V(si));
            end else begin
                gds           =  TYPE * ddx(id, V(di));
            end
            // Capacitances and transcapacitances
            if (sigVds < 0.0) begin
                qde           =  Qs - Qdse - Qgse - Qovs - Qssub - Qgsif - Qbsif;
            end else begin
                qde           =  Qd + Qdse - Qgde - Qovd - Qdsub - Qgdif - Qbdif;
            end
            qge           =  Qg + Qgse + Qgde + Qovs + Qovd + Qgbe + Qgsif + Qgdif;
            qbe           =  Qb + Qssub + Qdsub - Qgbe + Qbsif + Qbdif;
            if (sigVds < 0.0) begin
                cdd           =  TYPE * ddx(qde, V(si));
                cgd           = -TYPE * ddx(qge, V(si));
                cbd           = -TYPE * ddx(qbe, V(si));
            end else begin
                cdd           =  TYPE * ddx(qde, V(di));
                cgd           = -TYPE * ddx(qge, V(di));
                cbd           = -TYPE * ddx(qbe, V(di));
            end
            cdg           = -TYPE * ddx(qde, V(gp));
            cgg           =  TYPE * ddx(qge, V(gp));
            cbg           = -TYPE * ddx(qbe, V(gp));
            cdb           = -TYPE * ddx(qde, V(bp));
            cgb           = -TYPE * ddx(qge, V(bp));
            cbb           =  TYPE * ddx(qbe, V(bp));
            cds           =  cdd - cdg - cdb;
            cgs           =  cgg - cgd - cgb;
            cbs           =  cbb - cbd - cbg;
            csd           =  cdd - cgd - cbd;
            csg           =  cgg - cdg - cbg;
            csb           =  cbb - cgb - cdb;
            css           =  csg + csd + csb;

         // Miscellaneous
            // Channel temperature and self-heating elevation
            tk            =  TKC;
            dtsh          =  DTC;
            // Analog gain, output resistance and Early voltage
            if (abs(gds) < 1.0e-40) begin
                self_gain     =  0.0;
                rout          =  0.0;
                vearly        =  0.0;
            end else begin
                self_gain     =  gm / gds;
                rout          =  1.0 / gds;
                vearly        =  id / gds;
            end
            // Gain factor
            if (abs(vth_drive) < 1.0e-40) begin
                beff          =  0.0;
            end else begin
                beff          =  2.0 * abs(id) / (vth_drive * vth_drive);
            end
            // Unity gain frequency
            if (abs(cgg) < 1.0e-40) begin
                ft            =  0.0;
            end else begin
                ft            =  gm / (2.0 * `PI * cgg);
            end
            // Gate resistance
            rgate         =  RG_i;
            // Source and Drain resistance
            if (sigVds < 0.0) begin
                rdrain   =  RSE_i;
                rsource  =  RDE_i;
            end else begin
                rdrain   =  RDE_i;
                rsource  =  RSE_i;
            end
            // Well resistance
            rbwell       =  RWELL_i;
            // Transconductance over drain current ratio
            if (abs(id) < 1.0e-40) begin
                gmoverid      =  0.0;
            end else begin
                gmoverid      =  gm / id;
            end
`endif

    end    // OPinfo

end    // analog block

// ---- end `include "L_UTSOI_102_module.include" ----

endmodule
