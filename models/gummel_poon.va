// BJT: SPICE Gummel-Poon bipolar transistor (ngspice Q, level 1/2).
//
// Verilog-A implementation: Omar El-Sawy, University of Waterloo.
// Based on: ngspice Q element (bjt/bjtload.c, bjttemp.c, bjtsetup.c,
//   bjtnoise.c), the Gummel-Poon integral-charge model (H. K. Gummel and
//   H. C. Poon, 1970) as implemented in Berkeley SPICE3.
//   ngspice: Copyright Regents of the University of California and others,
//   modified BSD license.
//
// Topology: C-RC-ci, B-Rbb'-bi, E-RE-ei, substrate S. Junction voltages live
// on the primed nodes; the extrinsic BC cap sits outside RB. Currents and
// voltages are in the npn frame, so PNP is type = -1.
//
// Conductances are not written out: each is the derivative of a contributed
// current, so the AD Jacobian is the stamp. pnjlim is applied through $limit
// as in diode.va; the junction exponent is also clamped so a wild iterate
// cannot return inf. Excess phase is the xf1/xf2 filter network.

`include "constants.vams"
`include "disciplines.vams"

module gummel_poon(c, b, e, s);
    inout c, b, e, s;
    electrical c, b, e, s;
    electrical ci, bi, ei;   // c', b', e' — collapsed when RC/RB/RE are 0
    electrical xf1, xf2;     // excess-phase filter states (Weil, 2-pole)

    // ---- ngspice .model parameters (bjtset.c names, defaults, units) -------
    parameter integer type = 1  from [-1:1] exclude 0;   // +1 npn, -1 pnp
    parameter integer subs = 1  from [-1:1] exclude 0;   // +1 vertical, -1 lateral
    parameter real is   = 1e-16 from [0:inf);   // A   transport saturation current
    parameter real bf   = 100.0 from [0:inf);   //     ideal forward beta
    parameter real nf   = 1.0   from (0:inf);   //     forward emission coeff
    parameter real vaf  = 0.0   from [0:inf);   // V   forward Early voltage (0 = inf)
    parameter real ikf  = 0.0   from [0:inf);   // A   forward knee current (0 = inf)
    parameter real ise  = 0.0   from [0:inf);   // A   BE leakage saturation current
    parameter real c2   = 0.0   from [0:inf);   //     legacy ise as multiple of is (bjttemp.c:46)
    parameter real ne   = 1.5   from (0:inf);   //     BE leakage emission coeff
    parameter real br   = 1.0   from [0:inf);   //     ideal reverse beta
    parameter real nr   = 1.0   from (0:inf);   //     reverse emission coeff
    // ngspice card name is `var`, a Zig keyword in the generated field name;
    // card binding is case-insensitive, so `var=200` binds.
    parameter real VAR  = 0.0   from [0:inf);   // V   reverse Early voltage (0 = inf)
    parameter real ikr  = 0.0   from [0:inf);   // A   reverse knee current (0 = inf)
    parameter real isc  = 0.0   from [0:inf);   // A   BC leakage saturation current
    parameter real c4   = 0.0   from [0:inf);   //     legacy isc as multiple of is (bjttemp.c:53)
    parameter real nc   = 2.0   from (0:inf);   //     BC leakage emission coeff
    parameter real nkf  = 0.5   from (0:1];     //     high-injection rolloff exponent
    parameter real rb   = 0.0   from [0:inf);   // Ohm zero-bias base resistance
    parameter real irb  = 0.0   from [0:inf);   // A   current where rb halves (0 = off)
    parameter real rbm  = 0.0   from [0:inf);   // Ohm minimum base resistance (0 = rb)
    parameter real re   = 0.0   from [0:inf);   // Ohm emitter resistance
    parameter real rc   = 0.0   from [0:inf);   // Ohm collector resistance
    parameter real cje  = 0.0   from [0:inf);   // F   zero-bias BE depletion cap
    parameter real pe   = 0.75  from (0:inf);   // V   BE built-in potential
    parameter real mje  = 0.33  from [0:1);     //     BE grading coefficient
    parameter real tf   = 0.0   from [0:inf);   // s   forward transit time
    parameter real xtf  = 0.0   from [0:inf);   //     tf bias dependence coeff
    parameter real vtf  = 0.0   from [0:inf);   // V   tf dependence on vbc (0 = off)
    parameter real itf  = 0.0   from [0:inf);   // A   tf dependence on ic
    parameter real ptf  = 0.0;                  // deg excess phase at 1/(2 pi tf)
    parameter real cjc  = 0.0   from [0:inf);   // F   zero-bias BC depletion cap
    parameter real pc   = 0.75  from (0:inf);   // V   BC built-in potential
    parameter real mjc  = 0.33  from [0:1);     //     BC grading coefficient
    parameter real xcjc = 1.0   from [0:1];     //     fraction of cjc on b' (0 = all on ext base)
    parameter real tr   = 0.0   from [0:inf);   // s   reverse transit time
    parameter real cjs  = 0.0   from [0:inf);   // F   zero-bias substrate cap
    parameter real ps   = 0.75  from (0:inf);   // V   substrate built-in potential
    parameter real mjs  = 0.0   from [0:1);     //     substrate grading coefficient
    parameter real iss  = 0.0   from [0:inf);   // A   substrate saturation current
    parameter real ns   = 1.0   from (0:inf);   //     substrate emission coeff
    parameter real fc   = 0.5   from [0:1);     //     forward-bias cap switchover
    parameter real eg   = 1.11  from (0:inf);   // eV  activation energy
    parameter real xti  = 3.0;                  //     is temperature exponent
    parameter real xtb  = 0.0;                  //     beta temperature exponent
    parameter real tnom = $simparam("tnom") + 273.15 from (0:inf);  // K   parameter extraction temperature
    parameter real gmin = $simparam("gmin") from [0:inf);   // S   leakage-branch conductance floor
    // Resistance/knee temperature maps: X(T) = X*(1 + t1*dt + t2*dt^2),
    // dt = T - Tnom (bjttemp.c)
    parameter real trb1  = 0.0;                 // 1/K rb linear tempco
    parameter real trb2  = 0.0;                 // 1/K^2
    parameter real trm1  = 0.0;                 // 1/K rbm linear tempco
    parameter real trm2  = 0.0;                 // 1/K^2
    parameter real tre1  = 0.0;                 // 1/K re linear tempco
    parameter real tre2  = 0.0;                 // 1/K^2
    parameter real trc1  = 0.0;                 // 1/K rc linear tempco
    parameter real trc2  = 0.0;                 // 1/K^2
    parameter real tikf1 = 0.0;                 // 1/K ikf linear tempco
    parameter real tikf2 = 0.0;                 // 1/K^2
    parameter real tikr1 = 0.0;                 // 1/K ikr linear tempco
    parameter real tikr2 = 0.0;                 // 1/K^2
    // noise (bjtnoise.c): flicker on b'-e', KF*|IB|^AF/f
    parameter real kf = 0.0 from [0:inf);       //     flicker noise coefficient
    parameter real af = 1.0 from (0:inf);       //     flicker noise exponent
    // instance card
    parameter real area  = 1.0 from (0:inf);    //     emitter (BE junction) area
    parameter real areab = 1.0 from (0:inf);    //     base area (lateral BC/sub caps)
    parameter real areac = 1.0 from (0:inf);    //     collector area (vertical sub cap)
    parameter real m     = 1.0 from (0:inf);    //     device multiplicity

    // Junction current with the smooth-cubic reverse continuation: the
    // -3*Vtn branch keeps i and di/dv C1, so g never collapses in reverse.
    analog function real pnj;
        input v, isat, vtn;
        real v, isat, vtn;
        real u, e;
        begin
            // Exponent tangent-continued above 80, not flat-clamped: pnjlim
            // can still admit a step past 80*vtn, and a flat clamp has
            // dI/dV = 0, which leaves stacked junctions without a restoring
            // force. The tangent keeps the slope.
            if (v >= -3.0 * vtn) begin
                u = min(v / vtn, 80.0);
                e = exp(u);
                pnj = isat * (e * (1.0 + (v / vtn - u)) - 1.0);
            end else begin
                u = 3.0 * vtn / (2.718281828459045 * v);
                pnj = -isat * (1.0 + u * u * u);
            end
        end
    endfunction

    // Depletion charge, the standard SPICE F1/F2/F3 two-branch form.
    // fc = 0 degenerates to the substrate case (depletion below 0, quadratic
    // extension above), so all four junctions share this one law.
    analog function real depq;
        input v, cj, pj, mj, fcx;
        real v, cj, pj, mj, fcx;
        real fcp, f1, f2, f3;
        begin
            fcp = fcx * pj;
            if (v < fcp) begin
                depq = cj * pj * (1.0 - pow(1.0 - v / pj, 1.0 - mj)) / (1.0 - mj);
            end else begin
                f1 = pj * (1.0 - pow(1.0 - fcx, 1.0 - mj)) / (1.0 - mj);
                f2 = pow(1.0 - fcx, 1.0 + mj);
                f3 = 1.0 - fcx * (1.0 + mj);
                depq = cj * (f1 + (f3 * (v - fcp)
                     + 0.5 * mj * (v * v - fcp * fcp) / pj) / f2);
            end
        end
    endfunction

    real tdev, vt, vtn, dt, fact1, fact2, egt, egn, argt, argn, pbft, pbfn;
    real ratlog, factlog, factor, bfac;
    real ise_x, isc_x, is_t, ise_t, isc_t, iss_t, bf_t, br_t;
    real pbo, gold, gnew, tcap, pe_t, cje_t, pc_t, cjc_t, ps_t, cjs_t;
    real ai, abc, asb, vert, inv_vaf, inv_var, inv_ikf, inv_ikr;
    real rbtot, rbpr, rbpi, rbb, zc, tanz, xjrb, rc_t, re_t;
    real vbe, vbc, vbx, vsub, vcrit, cbe, cben, cbc, cbcn, cdsub;
    real q1, q2, qb, td, icc, ic, ib, argtf, tmp;
    real qbe, qbc, qbx, qsub, fourkt;

    analog begin
        // ---- temperature and geometry: bias independent (bjttemp.c) -------
        tdev  = $temperature;
        dt    = tdev - tnom;
        vt    = 1.38064852e-23 / 1.6021766208e-19 * tdev;   // bjttemp.c:149 CONSTKoverQ
        vtn   = 1.38064852e-23 / 1.6021766208e-19 * tnom;
        fact1 = tnom / 300.15;
        fact2 = tdev / 300.15;
        egt   = 1.16 - 7.02e-4 * tdev * tdev / (tdev + 1108.0);
        egn   = 1.16 - 7.02e-4 * tnom * tnom / (tnom + 1108.0);
        argt  = -egt / (2.0 * 1.38064852e-23 * tdev)
              + 1.1150877 / (1.38064852e-23 * (300.15 + 300.15));
        argn  = -egn / (2.0 * 1.38064852e-23 * tnom)
              + 1.1150877 / (1.38064852e-23 * (300.15 + 300.15));
        pbft  = -2.0 * vt  * (1.5 * ln(fact2) + 1.6021766208e-19 * argt);
        pbfn  = -2.0 * vtn * (1.5 * ln(fact1) + 1.6021766208e-19 * argn);

        ratlog  = ln(tdev / tnom);
        factlog = (tdev / tnom - 1.0) * eg / vt + xti * ratlog;
        factor  = exp(factlog);
        bfac    = exp(xtb * ratlog);
        is_t    = is * factor;
        iss_t   = iss * factor;
        bf_t    = bf * bfac;
        br_t    = br * bfac;
        // Legacy Gummel-Poon cards give the leakage currents as C2/C4
        // multiples of IS (bjttemp.c); ise/isc win when both are set.
        ise_x   = ise;
        isc_x   = isc;
        if (ise <= 0.0) ise_x = c2 * is;
        if (isc <= 0.0) isc_x = c4 * is;
        // Leakage currents carry their own emission coeff and divide by the
        // beta factor (bjttemp.c).
        ise_t   = ise_x * exp(factlog / ne) / bfac;
        isc_t   = isc_x * exp(factlog / nc) / bfac;

        // Junction potentials/caps: SPICE intrinsic-shift mapping (as diode.va).
        pbo   = (pe - pbfn) / fact1;
        gold  = (pe - pbo) / pbo;
        gnew  = (fact2 * pbo + pbft - pbo) / pbo;
        pe_t  = fact2 * pbo + pbft;
        tcap  = (1.0 + mje * (4e-4 * (tdev - 300.15) - gnew))
              / (1.0 + mje * (4e-4 * (tnom - 300.15) - gold));
        cje_t = cje * tcap;

        pbo   = (pc - pbfn) / fact1;
        gold  = (pc - pbo) / pbo;
        gnew  = (fact2 * pbo + pbft - pbo) / pbo;
        pc_t  = fact2 * pbo + pbft;
        tcap  = (1.0 + mjc * (4e-4 * (tdev - 300.15) - gnew))
              / (1.0 + mjc * (4e-4 * (tnom - 300.15) - gold));
        cjc_t = cjc * tcap;

        pbo   = (ps - pbfn) / fact1;
        gold  = (ps - pbo) / pbo;
        gnew  = (fact2 * pbo + pbft - pbo) / pbo;
        ps_t  = fact2 * pbo + pbft;
        tcap  = (1.0 + mjs * (4e-4 * (tdev - 300.15) - gnew))
              / (1.0 + mjs * (4e-4 * (tnom - 300.15) - gold));
        cjs_t = cjs * tcap;

        // Area/multiplicity scaling; `subs` picks which area carries the
        // substrate junction and where it lands.
        ai   = area * m;   // emitter area: transport/BE junction, caps, rb/rc/re
        vert = 0.0;
        if (subs > 0) vert = 1.0;
        // bjtload.c: the BC leakage and BC depletion caps take areab
        // vertical / areac lateral; the substrate cap is the other way round.
        abc = m * (vert * areab + (1.0 - vert) * areac);
        asb = m * (vert * areac + (1.0 - vert) * areab);

        // 0 means "infinite" for the Early and knee currents. The knee currents
        // are per unit area, so the inverse carries 1/(area*m) (bjtload.c
        // `oik = tinvRollOffF/area` against an area-scaled cbe).
        inv_vaf = 0.0;
        inv_var = 0.0;
        inv_ikf = 0.0;
        inv_ikr = 0.0;
        if (vaf > 0.0) inv_vaf = 1.0 / vaf;
        if (VAR > 0.0) inv_var = 1.0 / VAR;
        if (ikf > 0.0) inv_ikf = 1.0 / (ikf * (1.0 + tikf1 * dt + tikf2 * dt * dt) * ai);
        if (ikr > 0.0) inv_ikr = 1.0 / (ikr * (1.0 + tikr1 * dt + tikr2 * dt * dt) * ai);

        rbtot = rb * (1.0 + trb1 * dt + trb2 * dt * dt) / ai;
        rbpr  = rbtot;
        if (rbm > 0.0) rbpr = rbm * (1.0 + trm1 * dt + trm2 * dt * dt) / ai;
        rbpi = rbtot - rbpr;
        xjrb = irb * ai;
        rc_t = rc * (1.0 + trc1 * dt + trc2 * dt * dt) / ai;
        re_t = re * (1.0 + tre1 * dt + tre2 * dt * dt) / ai;

        // ---- bias, pnjlim'd where bjtload.c does -----------------------------
        // pnjlim assumes forward = positive; the trailing `type` argument is
        // VerA's frame sign, so the clamp runs on type*v like ngspice's
        // `type*vbe`. $limit cannot sit under `if (type > 0)` (the clamp list
        // carries no control flow) and `$limit(type*V(...))` has no node pair.
        vcrit = vt * ln(vt / (1.4142135623730951 * is_t * ai));
        vbe = type * $limit(V(bi, ei), "pnjlim", vt, vcrit, type);
        vbc = type * $limit(V(bi, ci), "pnjlim", vt, vcrit, type);
        // vbx/vsub stay raw, as in bjtload.c; both feed clamped laws only.
        vbx  = type * V(b, ci);
        vsub = type * (vert * V(s, ci) + (1.0 - vert) * V(s, bi));

        // ---- junction currents; GMIN on the leakage/substrate parts --------
        cbe   = pnj(vbe, is_t * ai, nf * vt);
        cben  = pnj(vbe, ise_t * ai, ne * vt) + m * gmin * vbe;
        cbc   = pnj(vbc, is_t * ai, nr * vt);
        cbcn  = pnj(vbc, isc_t * abc, nc * vt) + m * gmin * vbc;
        // The substrate current keeps the emitter area (bjtload.c); only the
        // substrate cap swaps to areac/areab.
        cdsub = pnj(vsub, iss_t * ai, ns * vt) + m * gmin * vsub;

        // ---- base charge: Early + Webster high injection -------------------
        q1 = 1.0 / (1.0 - vbc * inv_vaf - vbe * inv_var);
        q2 = cbe * inv_ikf + cbc * inv_ikr;
        qb = 0.5 * q1 * (1.0 + pow(max(1e-30, 1.0 + 4.0 * q2), nkf));

        // ---- excess phase (Weil), on the forward transport term only -------
        // bjtload.c's backward-Euler recurrence (arg2 = 3dt/td,
        // arg1 = arg2*dt/td) is the BE discretization of
        //   H(s) = 1/(1 + s*td + s^2*td^2/3)   on   cbe/qb,
        // realised by the VBIC xf1/xf2 two-node network so ddt() carries the
        // history.
        //   node xf1: V(xf2) - u + d(td*V(xf1))/dt = 0
        //   node xf2: V(xf2) - V(xf1) + d(td/3*V(xf2))/dt = 0  ->  V(xf2) = H*u
        // At td = 0, transport is algebraic.
        td = ptf * 0.017453292519943295 * tf;   // deg -> rad, bjttemp.c
        if (td == 0.0) begin
            icc = cbe / qb - cbc / qb;
        end else begin
            I(xf1) <+ V(xf2) - cbe / qb;
            (* vera_lte = 0 *) I(xf1) <+ ddt(td * V(xf1));
            I(xf2) <+ V(xf2) - V(xf1);
            (* vera_lte = 0 *) I(xf2) <+ ddt(td * V(xf2) / 3.0);
            icc = V(xf2) - cbc / qb;
        end

        // ---- transport current, split per branch so node KCL matches
        // ic = icc - cbc/br - cbcn and ib = cbe/bf + cben + cbc/br + cbcn ----
        ib  = cbe / bf_t + cben + cbc / br_t + cbcn;
        ic  = icc - cbc / br_t - cbcn;

        // ---- bias-dependent forward transit time --------------------------
        argtf = 0.0;
        if (tf > 0.0 && vbe > 0.0 && xtf > 0.0) begin
            argtf = xtf;
            if (vtf > 0.0) argtf = argtf * exp(vbc / (1.44 * vtf));
            if (itf > 0.0) begin
                tmp   = cbe / (cbe + itf * ai);
                argtf = argtf * tmp * tmp;
            end
        end

        // Diffusion charge keeps the 1/qb base-widening division, so ddt()
        // reproduces both capbe and the geqcb cross term of bjtload.c.
        qbe  = tf * cbe * (1.0 + argtf) / qb + depq(vbe, cje_t * ai, pe_t, mje, fc);
        qbc  = tr * cbc + depq(vbc, cjc_t * xcjc * abc, pc_t, mjc, fc);
        qbx  = depq(vbx, cjc_t * (1.0 - xcjc) * abc, pc_t, mjc, fc);
        qsub = depq(vsub, cjs_t * asb, ps_t, mjs, 0.0);

        // ---- stamps ---------------------------------------------------------
        // ddt() has to sit on its own multiplicative spine (LRM 5.6.1.2), so
        // each reactive term is a separate contribution on the same branch.
        I(ci, ei) <+ type * icc;
        I(bi, ei) <+ type * (cbe / bf_t + cben);
        I(bi, ei) <+ type * ddt(qbe);
        I(bi, ci) <+ type * (cbc / br_t + cbcn);
        I(bi, ci) <+ type * ddt(qbc);
        // bjttrunc.c truncates qbe, qbc and qsub, not qbx (nor the excess
        // phase network above).
        (* vera_lte = 0 *) I(b, ci)  <+ type * ddt(qbx);
        I(s, ci)  <+ vert * type * cdsub;
        I(s, ci)  <+ vert * type * ddt(qsub);
        I(s, bi)  <+ (1.0 - vert) * type * cdsub;
        I(s, bi)  <+ (1.0 - vert) * type * ddt(qsub);

        // ---- noise (bjtnoise.c) ---------------------------------------------
        // Currents/conductances here already carry area*m, and ngspice's table
        // is (area-scaled quantity)*m — so no extra factor except the flicker
        // row, which is m*KF*|IB/m|^AF (IB there excludes m).
        fourkt = 4.0 * 1.38064852e-23 * tdev;
        I(ci, ei) <+ white_noise(2.0 * 1.6021766208e-19 * abs(ic), "ic");
        I(bi, ei) <+ white_noise(2.0 * 1.6021766208e-19 * abs(ib), "ib");
        I(bi, ei) <+ flicker_noise(m * kf * pow(abs(ib / m), af), 1.0, "flicker");

        // ---- bias-dependent base resistance ---------------------------------
        if (rbtot > 0.0) begin
            if (xjrb > 0.0) begin
                // Current-crowding form; ngspice floors ib/(irb*A) at 1e-9 so
                // z stays finite at zero base current.
                tmp  = max(ib / xjrb, 1e-9);
                zc   = (sqrt(1.0 + 14.59025 * tmp) - 1.0) / (2.4317 * sqrt(tmp));
                tanz = tan(zc);
                rbb  = rbpr + 3.0 * rbpi * (tanz - zc) / (zc * tanz * tanz);
            end else begin
                rbb = rbpr + rbpi / qb;
            end
            I(b, bi) <+ V(b, bi) / rbb;
            // Thermal noise on the modulated gx (bjtnoise.c).
            I(b, bi) <+ white_noise(fourkt / rbb, "rb");
        end else begin
            V(b, bi) <+ 0.0;
        end
        if (rc_t > 0.0) begin
            I(c, ci) <+ V(c, ci) / rc_t;
            I(c, ci) <+ white_noise(fourkt / rc_t, "rc");
        end else begin
            V(c, ci) <+ 0.0;
        end
        if (re_t > 0.0) begin
            I(e, ei) <+ V(e, ei) / re_t;
            I(e, ei) <+ white_noise(fourkt / re_t, "re");
        end else begin
            V(e, ei) <+ 0.0;
        end
        // Unused filter nodes short onto the substrate port so setup can drop
        // them. ponytail: kept last until VerA proves parameter-only
        // retention through the later bias-dependent phis.
        if (td == 0.0) begin
            V(xf1, s) <+ 0.0;
            V(xf2, s) <+ 0.0;
        end
    end
endmodule
