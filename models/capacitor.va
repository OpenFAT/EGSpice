// Capacitor: linear, i(p,n) = c * d/dt V(p,n).
//
// Verilog-A implementation: Omar El-Sawy, University of Waterloo.

`include "constants.vams"
`include "disciplines.vams"

module capacitor(p, n);
    inout p, n;
    electrical p, n;
    parameter real c = 1e-12 from [0:inf);  // F  capacitance

    analog I(p, n) <+ c * ddt(V(p, n));
endmodule
