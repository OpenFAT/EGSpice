// Mutual inductance (K element): pure cross-flux between two inductor branches.
//
// Verilog-A implementation: Omar El-Sawy, University of Waterloo.
// Based on: ngspice K element (src/spicelib/devices/ind/, mut*.c).
//   ngspice: Copyright Regents of the University of California and others,
//   modified BSD license.
//
//   q_br1 = -M * I_br2,   q_br2 = -M * I_br1   (no self terms)
// L1 and L2 own their self flux, so a self term here would count the winding
// inductance twice; a flipped sign breaks passivity.
//
// `k` holds the MUTUAL INDUCTANCE M = k*sqrt(L1*L2) in henries, not the
// dimensionless coefficient: only the builder knows L1/L2, and it writes M
// back into `model.k`. The default 0 leaves an unresolved coupling inert.
//
// `br1`/`br2` are terminals because that is Verilog-A's only handle on an
// unknown the module does not own. The builder (addKinduc) binds them to
// L1/L2's branch-current unknowns, so V(brX) reads that current and I(brX)
// writes that inductor's KVL row: `I(br1) <+ -k*ddt(V(br2))` is Q[br1] = -k*x.br2.

`include "constants.vams"
`include "disciplines.vams"

module kinduc(br1, br2);
    inout br1, br2;
    electrical br1, br2;

    parameter real k = 0.0;  // H  resolved mutual inductance M (sign = polarity)

    analog begin
        I(br1) <+ -k * ddt(V(br2));
        I(br2) <+ -k * ddt(V(br1));
    end
endmodule
