// CCCS: current-controlled current source (F element), i(p,n) = m * gain * I(ctrl).
//
// Verilog-A implementation: Omar El-Sawy, University of Waterloo.
// Based on: ngspice F element (cccs/cccsload.c, cccspar.c).
//   ngspice: Copyright Regents of the University of California and others,
//   modified BSD license.
//
// Ports in card order: F<name> p n <vnam> <gain>, with (cp,cn) standing in for
// `vnam`. ngspice reads the named V-source's branch unknown (cccsset.c
// CKTfndBranch); a Verilog-A module has no cross-instance handle, so the
// builder puts (cp,cn) in series with that source, and `ctrl` at `vsense`
// = 0 is an ammeter carrying its whole current. Several sensors of one
// source chain in series. `m` folds into the transfer as in cccspar.c.
// Constant stamp.

`include "constants.vams"
`include "disciplines.vams"

module cccs(p, n, cp, cn);
    inout p, n, cp, cn;
    electrical p, n, cp, cn;
    branch (cp, cn) ctrl;

    parameter real gain   = 1.0;               // A/A  current gain
    parameter real m      = 1.0 from (0:inf);  //      parallel multiplier
    parameter real vsense = 0.0;               // V    ammeter voltage; the builder leaves it 0

    real k;
    analog begin
        k = m * gain;
        V(ctrl) <+ vsense;
        I(p, n) <+ k * I(ctrl);
    end
endmodule
