// VCVS: voltage-controlled voltage source (E element), V(p,n) = gain * V(cp,cn).
//
// Verilog-A implementation: Omar El-Sawy, University of Waterloo.
// Based on: ngspice E element (vcvs/vcvsload.c).
//   ngspice: Copyright Regents of the University of California and others,
//   modified BSD license.
//
// Ports in card order: n+ n- nc+ nc-. The named branch gives the output its
// branch-current unknown (KVL row). Constant stamp: no bias dependence, no
// limiting, no charge.
//
// ponytail: no POLY ladder. The polynomial subset belongs to bsource.va and the
// builder fills only `gain` for letter E. Route E POLY(n) through bsource if it
// is ever needed.

`include "constants.vams"
`include "disciplines.vams"

module vcvs(p, n, cp, cn);
    inout p, n, cp, cn;
    electrical p, n, cp, cn;
    branch (p, n) br;

    parameter real gain = 0.0;  // V/V  card VALUE (POLY p1); ngspice has no default

    analog begin
        V(br) <+ gain * V(cp, cn);
    end
endmodule
