`include "disciplines.vams"
// #218's stalled gmin descent in one node. The root V = T, with
// T = 10 * lambda * ln(1e-2/gmin) / ln(1e10), is 10 V at the deck's gmin and
// full sources. Cold Newton on atan diverges past |V - T| = 1.39, so the
// plain rung fails, and source stepping walks lambda to 1 in steps under
// that. Under a stepping gmin (above 1e-11) V moves at most 4e-4 per
// iteration after a solve's first (the limiter's memory outlives a solve),
// so gmin steps converge slowly: the descent fails four steps, then holds a
// factor of 1.009 at 44-61 iterations a step, in gminFactor's dead band.
module va_gmin_crawl(p, n);
    inout p, n;
    electrical p, n;
    analog function real crawl;
        input value, previous;
        real value, previous, limited;
        begin
            limited = value;
            if ($simparam("gmin") > 1e-11 && $simparam("iteration") > 1)
                limited = min(max(value, previous - 4e-4), previous + 4e-4);
            if (abs(limited - value) > 1e-12) $discontinuity(-1);
            crawl = limited;
        end
    endfunction
    analog begin
        I(p,n) <+ atan($limit(V(p,n), crawl) - $simparam("sourceScaleFactor") * 10.0 * ln(1e-2 / max($simparam("gmin"), 1e-12)) / ln(1e10));
    end
endmodule
