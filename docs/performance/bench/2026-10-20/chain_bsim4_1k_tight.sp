* postlayout chain bsim4 1k
* Generated by tests/benchmark/postlayout/gen.py: 1000 transistors, 4078 R, 6428 C. Synthetic extraction, no oracle.
.model nch NMOS(LEVEL=54 TOXE=1.8e-9 TOXP=1.5e-9 TOXM=1.8e-9 VTH0=0.3 K1=0.5 K2=-0.1 VSAT=1.5e5 U0=300 UA=1e-9 UB=1e-18 UC=-4.6e-11 RDSW=200 NFACTOR=1.5 VOFF=-0.1 CDSC=0 CDSCD=0)
.model pch PMOS(LEVEL=54 TOXE=1.8e-9 TOXP=1.5e-9 TOXM=1.8e-9 VTH0=-0.35 K1=0.5 K2=-0.1 VSAT=1.2e5 U0=100 RDSW=400)
.subckt inv a y vdd vss
mp y a vdd vdd pch W=0.8u L=0.1u AD=0.2p AS=0.2p PD=2.1u PS=2.1u
mn y a vss vss nch W=0.4u L=0.1u AD=0.1p AS=0.1p PD=1.3u PS=1.3u
.ends
.subckt inv8 a y vdd vss
mp y a vdd vdd pch W=6.4u L=0.1u AD=1.6p AS=1.6p PD=13.3u PS=13.3u
mn y a vss vss nch W=3.2u L=0.1u AD=0.8p AS=0.8p PD=6.9u PS=6.9u
.ends
.subckt nand2 a b y vdd vss
mp1 y a vdd vdd pch W=0.8u L=0.1u AD=0.2p AS=0.2p PD=2.1u PS=2.1u
mp2 y b vdd vdd pch W=0.8u L=0.1u AD=0.2p AS=0.2p PD=2.1u PS=2.1u
mn1 y a x vss nch W=0.8u L=0.1u AD=0.2p AS=0.2p PD=2.1u PS=2.1u
mn2 x b vss vss nch W=0.8u L=0.1u AD=0.2p AS=0.2p PD=2.1u PS=2.1u
.ends
.subckt nor2 a b y vdd vss
mp1 x a vdd vdd pch W=1.6u L=0.1u AD=0.4p AS=0.4p PD=3.7u PS=3.7u
mp2 y b x vdd pch W=1.6u L=0.1u AD=0.4p AS=0.4p PD=3.7u PS=3.7u
mn1 y a vss vss nch W=0.4u L=0.1u AD=0.1p AS=0.1p PD=1.3u PS=1.3u
mn2 y b vss vss nch W=0.4u L=0.1u AD=0.1p AS=0.1p PD=1.3u PS=1.3u
.ends
.subckt bit6t bl blb wl vdd vss
mu1 q qb vdd vdd pch W=0.4u L=0.1u AD=0.1p AS=0.1p PD=1.3u PS=1.3u
md1 q qb vss vss nch W=0.6u L=0.1u AD=0.15p AS=0.15p PD=1.7u PS=1.7u
mu2 qb q vdd vdd pch W=0.4u L=0.1u AD=0.1p AS=0.1p PD=1.3u PS=1.3u
md2 qb q vss vss nch W=0.6u L=0.1u AD=0.15p AS=0.15p PD=1.7u PS=1.7u
mg1 bl wl q vss nch W=0.4u L=0.1u AD=0.1p AS=0.1p PD=1.3u PS=1.3u
mg2 blb wl qb vss nch W=0.4u L=0.1u AD=0.1p AS=0.1p PD=1.3u PS=1.3u
.ends
.subckt pre bl blb pb vdd
mp1 bl pb vdd vdd pch W=3.2u L=0.1u AD=0.8p AS=0.8p PD=6.9u PS=6.9u
mp2 blb pb vdd vdd pch W=3.2u L=0.1u AD=0.8p AS=0.8p PD=6.9u PS=6.9u
mp3 bl pb blb vdd pch W=1.6u L=0.1u AD=0.4p AS=0.4p PD=3.7u PS=3.7u
.ends
.subckt wdrv bl we vss
mn bl we vss vss nch W=12.8u L=0.1u AD=3.2p AS=3.2p PD=26.1u PS=26.1u
.ends
Vdd vdd 0 DC 1.0
Vclk clk_0 0 PULSE(0 1.0 20p 20p 20p 230p 500p)
Rvd0_0 vd0_0 vd0_1 0.3
Cvd0_0 vd0_0 0 0.3f
Rvd0_1 vd0_1 vd0_2 0.3
Cvd0_1 vd0_1 0 0.3f
Rvd0_2 vd0_2 vd0_3 0.3
Cvd0_2 vd0_2 0 0.3f
Rvd0_3 vd0_3 vd0_4 0.3
Cvd0_3 vd0_3 0 0.3f
Rvd0_4 vd0_4 vd0_5 0.3
Cvd0_4 vd0_4 0 0.3f
Rvd0_5 vd0_5 vd0_6 0.3
Cvd0_5 vd0_5 0 0.3f
Rvd0_6 vd0_6 vd0_7 0.3
Cvd0_6 vd0_6 0 0.3f
Rvd0_7 vd0_7 vd0_8 0.3
Cvd0_7 vd0_7 0 0.3f
Rvd0_8 vd0_8 vd0_9 0.3
Cvd0_8 vd0_8 0 0.3f
Rvd0_9 vd0_9 vd0_10 0.3
Cvd0_9 vd0_9 0 0.3f
Rvd0_10 vd0_10 vd0_11 0.3
Cvd0_10 vd0_10 0 0.3f
Rvd0_11 vd0_11 vd0_12 0.3
Cvd0_11 vd0_11 0 0.3f
Rvd0_12 vd0_12 vd0_13 0.3
Cvd0_12 vd0_12 0 0.3f
Rvd0_13 vd0_13 vd0_14 0.3
Cvd0_13 vd0_13 0 0.3f
Rvd0_14 vd0_14 vd0_15 0.3
Cvd0_14 vd0_14 0 0.3f
Rvd0_15 vd0_15 vd0_16 0.3
Cvd0_15 vd0_15 0 0.3f
Rvd0_16 vd0_16 vd0_17 0.3
Cvd0_16 vd0_16 0 0.3f
Rvd0_17 vd0_17 vd0_18 0.3
Cvd0_17 vd0_17 0 0.3f
Rvd0_18 vd0_18 vd0_19 0.3
Cvd0_18 vd0_18 0 0.3f
Rvd0_19 vd0_19 vd0_20 0.3
Cvd0_19 vd0_19 0 0.3f
Rvd0_20 vd0_20 vd0_21 0.3
Cvd0_20 vd0_20 0 0.3f
Rvd0_21 vd0_21 vd0_22 0.3
Cvd0_21 vd0_21 0 0.3f
Rvd0_22 vd0_22 vd0_23 0.3
Cvd0_22 vd0_22 0 0.3f
Rvd0_23 vd0_23 vd0_24 0.3
Cvd0_23 vd0_23 0 0.3f
Rvd0_24 vd0_24 vd0_25 0.3
Cvd0_24 vd0_24 0 0.3f
Rvd0_25 vd0_25 vd0_26 0.3
Cvd0_25 vd0_25 0 0.3f
Rvd0_26 vd0_26 vd0_27 0.3
Cvd0_26 vd0_26 0 0.3f
Rvd0_27 vd0_27 vd0_28 0.3
Cvd0_27 vd0_27 0 0.3f
Rvd0_28 vd0_28 vd0_29 0.3
Cvd0_28 vd0_28 0 0.3f
Rvd0_29 vd0_29 vd0_30 0.3
Cvd0_29 vd0_29 0 0.3f
Rvd0_30 vd0_30 vd0_31 0.3
Cvd0_30 vd0_30 0 0.3f
Rvd0_31 vd0_31 vd0_32 0.3
Cvd0_31 vd0_31 0 0.3f
Rvds0_0 vd0_0 vd1_0 0.2
Rvds0_16 vd0_16 vd1_16 0.2
Rvds0_32 vd0_32 vd1_32 0.2
Rvd1_0 vd1_0 vd1_1 0.3
Cvd1_0 vd1_0 0 0.3f
Rvd1_1 vd1_1 vd1_2 0.3
Cvd1_1 vd1_1 0 0.3f
Rvd1_2 vd1_2 vd1_3 0.3
Cvd1_2 vd1_2 0 0.3f
Rvd1_3 vd1_3 vd1_4 0.3
Cvd1_3 vd1_3 0 0.3f
Rvd1_4 vd1_4 vd1_5 0.3
Cvd1_4 vd1_4 0 0.3f
Rvd1_5 vd1_5 vd1_6 0.3
Cvd1_5 vd1_5 0 0.3f
Rvd1_6 vd1_6 vd1_7 0.3
Cvd1_6 vd1_6 0 0.3f
Rvd1_7 vd1_7 vd1_8 0.3
Cvd1_7 vd1_7 0 0.3f
Rvd1_8 vd1_8 vd1_9 0.3
Cvd1_8 vd1_8 0 0.3f
Rvd1_9 vd1_9 vd1_10 0.3
Cvd1_9 vd1_9 0 0.3f
Rvd1_10 vd1_10 vd1_11 0.3
Cvd1_10 vd1_10 0 0.3f
Rvd1_11 vd1_11 vd1_12 0.3
Cvd1_11 vd1_11 0 0.3f
Rvd1_12 vd1_12 vd1_13 0.3
Cvd1_12 vd1_12 0 0.3f
Rvd1_13 vd1_13 vd1_14 0.3
Cvd1_13 vd1_13 0 0.3f
Rvd1_14 vd1_14 vd1_15 0.3
Cvd1_14 vd1_14 0 0.3f
Rvd1_15 vd1_15 vd1_16 0.3
Cvd1_15 vd1_15 0 0.3f
Rvd1_16 vd1_16 vd1_17 0.3
Cvd1_16 vd1_16 0 0.3f
Rvd1_17 vd1_17 vd1_18 0.3
Cvd1_17 vd1_17 0 0.3f
Rvd1_18 vd1_18 vd1_19 0.3
Cvd1_18 vd1_18 0 0.3f
Rvd1_19 vd1_19 vd1_20 0.3
Cvd1_19 vd1_19 0 0.3f
Rvd1_20 vd1_20 vd1_21 0.3
Cvd1_20 vd1_20 0 0.3f
Rvd1_21 vd1_21 vd1_22 0.3
Cvd1_21 vd1_21 0 0.3f
Rvd1_22 vd1_22 vd1_23 0.3
Cvd1_22 vd1_22 0 0.3f
Rvd1_23 vd1_23 vd1_24 0.3
Cvd1_23 vd1_23 0 0.3f
Rvd1_24 vd1_24 vd1_25 0.3
Cvd1_24 vd1_24 0 0.3f
Rvd1_25 vd1_25 vd1_26 0.3
Cvd1_25 vd1_25 0 0.3f
Rvd1_26 vd1_26 vd1_27 0.3
Cvd1_26 vd1_26 0 0.3f
Rvd1_27 vd1_27 vd1_28 0.3
Cvd1_27 vd1_27 0 0.3f
Rvd1_28 vd1_28 vd1_29 0.3
Cvd1_28 vd1_28 0 0.3f
Rvd1_29 vd1_29 vd1_30 0.3
Cvd1_29 vd1_29 0 0.3f
Rvd1_30 vd1_30 vd1_31 0.3
Cvd1_30 vd1_30 0 0.3f
Rvd1_31 vd1_31 vd1_32 0.3
Cvd1_31 vd1_31 0 0.3f
Rvds1_0 vd1_0 vd2_0 0.2
Rvds1_16 vd1_16 vd2_16 0.2
Rvds1_32 vd1_32 vd2_32 0.2
Rvd2_0 vd2_0 vd2_1 0.3
Cvd2_0 vd2_0 0 0.3f
Rvd2_1 vd2_1 vd2_2 0.3
Cvd2_1 vd2_1 0 0.3f
Rvd2_2 vd2_2 vd2_3 0.3
Cvd2_2 vd2_2 0 0.3f
Rvd2_3 vd2_3 vd2_4 0.3
Cvd2_3 vd2_3 0 0.3f
Rvd2_4 vd2_4 vd2_5 0.3
Cvd2_4 vd2_4 0 0.3f
Rvd2_5 vd2_5 vd2_6 0.3
Cvd2_5 vd2_5 0 0.3f
Rvd2_6 vd2_6 vd2_7 0.3
Cvd2_6 vd2_6 0 0.3f
Rvd2_7 vd2_7 vd2_8 0.3
Cvd2_7 vd2_7 0 0.3f
Rvd2_8 vd2_8 vd2_9 0.3
Cvd2_8 vd2_8 0 0.3f
Rvd2_9 vd2_9 vd2_10 0.3
Cvd2_9 vd2_9 0 0.3f
Rvd2_10 vd2_10 vd2_11 0.3
Cvd2_10 vd2_10 0 0.3f
Rvd2_11 vd2_11 vd2_12 0.3
Cvd2_11 vd2_11 0 0.3f
Rvd2_12 vd2_12 vd2_13 0.3
Cvd2_12 vd2_12 0 0.3f
Rvd2_13 vd2_13 vd2_14 0.3
Cvd2_13 vd2_13 0 0.3f
Rvd2_14 vd2_14 vd2_15 0.3
Cvd2_14 vd2_14 0 0.3f
Rvd2_15 vd2_15 vd2_16 0.3
Cvd2_15 vd2_15 0 0.3f
Rvd2_16 vd2_16 vd2_17 0.3
Cvd2_16 vd2_16 0 0.3f
Rvd2_17 vd2_17 vd2_18 0.3
Cvd2_17 vd2_17 0 0.3f
Rvd2_18 vd2_18 vd2_19 0.3
Cvd2_18 vd2_18 0 0.3f
Rvd2_19 vd2_19 vd2_20 0.3
Cvd2_19 vd2_19 0 0.3f
Rvd2_20 vd2_20 vd2_21 0.3
Cvd2_20 vd2_20 0 0.3f
Rvd2_21 vd2_21 vd2_22 0.3
Cvd2_21 vd2_21 0 0.3f
Rvd2_22 vd2_22 vd2_23 0.3
Cvd2_22 vd2_22 0 0.3f
Rvd2_23 vd2_23 vd2_24 0.3
Cvd2_23 vd2_23 0 0.3f
Rvd2_24 vd2_24 vd2_25 0.3
Cvd2_24 vd2_24 0 0.3f
Rvd2_25 vd2_25 vd2_26 0.3
Cvd2_25 vd2_25 0 0.3f
Rvd2_26 vd2_26 vd2_27 0.3
Cvd2_26 vd2_26 0 0.3f
Rvd2_27 vd2_27 vd2_28 0.3
Cvd2_27 vd2_27 0 0.3f
Rvd2_28 vd2_28 vd2_29 0.3
Cvd2_28 vd2_28 0 0.3f
Rvd2_29 vd2_29 vd2_30 0.3
Cvd2_29 vd2_29 0 0.3f
Rvd2_30 vd2_30 vd2_31 0.3
Cvd2_30 vd2_30 0 0.3f
Rvd2_31 vd2_31 vd2_32 0.3
Cvd2_31 vd2_31 0 0.3f
Rvds2_0 vd2_0 vd3_0 0.2
Rvds2_16 vd2_16 vd3_16 0.2
Rvds2_32 vd2_32 vd3_32 0.2
Rvd3_0 vd3_0 vd3_1 0.3
Cvd3_0 vd3_0 0 0.3f
Rvd3_1 vd3_1 vd3_2 0.3
Cvd3_1 vd3_1 0 0.3f
Rvd3_2 vd3_2 vd3_3 0.3
Cvd3_2 vd3_2 0 0.3f
Rvd3_3 vd3_3 vd3_4 0.3
Cvd3_3 vd3_3 0 0.3f
Rvd3_4 vd3_4 vd3_5 0.3
Cvd3_4 vd3_4 0 0.3f
Rvd3_5 vd3_5 vd3_6 0.3
Cvd3_5 vd3_5 0 0.3f
Rvd3_6 vd3_6 vd3_7 0.3
Cvd3_6 vd3_6 0 0.3f
Rvd3_7 vd3_7 vd3_8 0.3
Cvd3_7 vd3_7 0 0.3f
Rvd3_8 vd3_8 vd3_9 0.3
Cvd3_8 vd3_8 0 0.3f
Rvd3_9 vd3_9 vd3_10 0.3
Cvd3_9 vd3_9 0 0.3f
Rvd3_10 vd3_10 vd3_11 0.3
Cvd3_10 vd3_10 0 0.3f
Rvd3_11 vd3_11 vd3_12 0.3
Cvd3_11 vd3_11 0 0.3f
Rvd3_12 vd3_12 vd3_13 0.3
Cvd3_12 vd3_12 0 0.3f
Rvd3_13 vd3_13 vd3_14 0.3
Cvd3_13 vd3_13 0 0.3f
Rvd3_14 vd3_14 vd3_15 0.3
Cvd3_14 vd3_14 0 0.3f
Rvd3_15 vd3_15 vd3_16 0.3
Cvd3_15 vd3_15 0 0.3f
Rvd3_16 vd3_16 vd3_17 0.3
Cvd3_16 vd3_16 0 0.3f
Rvd3_17 vd3_17 vd3_18 0.3
Cvd3_17 vd3_17 0 0.3f
Rvd3_18 vd3_18 vd3_19 0.3
Cvd3_18 vd3_18 0 0.3f
Rvd3_19 vd3_19 vd3_20 0.3
Cvd3_19 vd3_19 0 0.3f
Rvd3_20 vd3_20 vd3_21 0.3
Cvd3_20 vd3_20 0 0.3f
Rvd3_21 vd3_21 vd3_22 0.3
Cvd3_21 vd3_21 0 0.3f
Rvd3_22 vd3_22 vd3_23 0.3
Cvd3_22 vd3_22 0 0.3f
Rvd3_23 vd3_23 vd3_24 0.3
Cvd3_23 vd3_23 0 0.3f
Rvd3_24 vd3_24 vd3_25 0.3
Cvd3_24 vd3_24 0 0.3f
Rvd3_25 vd3_25 vd3_26 0.3
Cvd3_25 vd3_25 0 0.3f
Rvd3_26 vd3_26 vd3_27 0.3
Cvd3_26 vd3_26 0 0.3f
Rvd3_27 vd3_27 vd3_28 0.3
Cvd3_27 vd3_27 0 0.3f
Rvd3_28 vd3_28 vd3_29 0.3
Cvd3_28 vd3_28 0 0.3f
Rvd3_29 vd3_29 vd3_30 0.3
Cvd3_29 vd3_29 0 0.3f
Rvd3_30 vd3_30 vd3_31 0.3
Cvd3_30 vd3_30 0 0.3f
Rvd3_31 vd3_31 vd3_32 0.3
Cvd3_31 vd3_31 0 0.3f
Rvds3_0 vd3_0 vd4_0 0.2
Rvds3_16 vd3_16 vd4_16 0.2
Rvds3_32 vd3_32 vd4_32 0.2
Rvd4_0 vd4_0 vd4_1 0.3
Cvd4_0 vd4_0 0 0.3f
Rvd4_1 vd4_1 vd4_2 0.3
Cvd4_1 vd4_1 0 0.3f
Rvd4_2 vd4_2 vd4_3 0.3
Cvd4_2 vd4_2 0 0.3f
Rvd4_3 vd4_3 vd4_4 0.3
Cvd4_3 vd4_3 0 0.3f
Rvd4_4 vd4_4 vd4_5 0.3
Cvd4_4 vd4_4 0 0.3f
Rvd4_5 vd4_5 vd4_6 0.3
Cvd4_5 vd4_5 0 0.3f
Rvd4_6 vd4_6 vd4_7 0.3
Cvd4_6 vd4_6 0 0.3f
Rvd4_7 vd4_7 vd4_8 0.3
Cvd4_7 vd4_7 0 0.3f
Rvd4_8 vd4_8 vd4_9 0.3
Cvd4_8 vd4_8 0 0.3f
Rvd4_9 vd4_9 vd4_10 0.3
Cvd4_9 vd4_9 0 0.3f
Rvd4_10 vd4_10 vd4_11 0.3
Cvd4_10 vd4_10 0 0.3f
Rvd4_11 vd4_11 vd4_12 0.3
Cvd4_11 vd4_11 0 0.3f
Rvd4_12 vd4_12 vd4_13 0.3
Cvd4_12 vd4_12 0 0.3f
Rvd4_13 vd4_13 vd4_14 0.3
Cvd4_13 vd4_13 0 0.3f
Rvd4_14 vd4_14 vd4_15 0.3
Cvd4_14 vd4_14 0 0.3f
Rvd4_15 vd4_15 vd4_16 0.3
Cvd4_15 vd4_15 0 0.3f
Rvd4_16 vd4_16 vd4_17 0.3
Cvd4_16 vd4_16 0 0.3f
Rvd4_17 vd4_17 vd4_18 0.3
Cvd4_17 vd4_17 0 0.3f
Rvd4_18 vd4_18 vd4_19 0.3
Cvd4_18 vd4_18 0 0.3f
Rvd4_19 vd4_19 vd4_20 0.3
Cvd4_19 vd4_19 0 0.3f
Rvd4_20 vd4_20 vd4_21 0.3
Cvd4_20 vd4_20 0 0.3f
Rvd4_21 vd4_21 vd4_22 0.3
Cvd4_21 vd4_21 0 0.3f
Rvd4_22 vd4_22 vd4_23 0.3
Cvd4_22 vd4_22 0 0.3f
Rvd4_23 vd4_23 vd4_24 0.3
Cvd4_23 vd4_23 0 0.3f
Rvd4_24 vd4_24 vd4_25 0.3
Cvd4_24 vd4_24 0 0.3f
Rvd4_25 vd4_25 vd4_26 0.3
Cvd4_25 vd4_25 0 0.3f
Rvd4_26 vd4_26 vd4_27 0.3
Cvd4_26 vd4_26 0 0.3f
Rvd4_27 vd4_27 vd4_28 0.3
Cvd4_27 vd4_27 0 0.3f
Rvd4_28 vd4_28 vd4_29 0.3
Cvd4_28 vd4_28 0 0.3f
Rvd4_29 vd4_29 vd4_30 0.3
Cvd4_29 vd4_29 0 0.3f
Rvd4_30 vd4_30 vd4_31 0.3
Cvd4_30 vd4_30 0 0.3f
Rvd4_31 vd4_31 vd4_32 0.3
Cvd4_31 vd4_31 0 0.3f
Rvds4_0 vd4_0 vd5_0 0.2
Rvds4_16 vd4_16 vd5_16 0.2
Rvds4_32 vd4_32 vd5_32 0.2
Rvd5_0 vd5_0 vd5_1 0.3
Cvd5_0 vd5_0 0 0.3f
Rvd5_1 vd5_1 vd5_2 0.3
Cvd5_1 vd5_1 0 0.3f
Rvd5_2 vd5_2 vd5_3 0.3
Cvd5_2 vd5_2 0 0.3f
Rvd5_3 vd5_3 vd5_4 0.3
Cvd5_3 vd5_3 0 0.3f
Rvd5_4 vd5_4 vd5_5 0.3
Cvd5_4 vd5_4 0 0.3f
Rvd5_5 vd5_5 vd5_6 0.3
Cvd5_5 vd5_5 0 0.3f
Rvd5_6 vd5_6 vd5_7 0.3
Cvd5_6 vd5_6 0 0.3f
Rvd5_7 vd5_7 vd5_8 0.3
Cvd5_7 vd5_7 0 0.3f
Rvd5_8 vd5_8 vd5_9 0.3
Cvd5_8 vd5_8 0 0.3f
Rvd5_9 vd5_9 vd5_10 0.3
Cvd5_9 vd5_9 0 0.3f
Rvd5_10 vd5_10 vd5_11 0.3
Cvd5_10 vd5_10 0 0.3f
Rvd5_11 vd5_11 vd5_12 0.3
Cvd5_11 vd5_11 0 0.3f
Rvd5_12 vd5_12 vd5_13 0.3
Cvd5_12 vd5_12 0 0.3f
Rvd5_13 vd5_13 vd5_14 0.3
Cvd5_13 vd5_13 0 0.3f
Rvd5_14 vd5_14 vd5_15 0.3
Cvd5_14 vd5_14 0 0.3f
Rvd5_15 vd5_15 vd5_16 0.3
Cvd5_15 vd5_15 0 0.3f
Rvd5_16 vd5_16 vd5_17 0.3
Cvd5_16 vd5_16 0 0.3f
Rvd5_17 vd5_17 vd5_18 0.3
Cvd5_17 vd5_17 0 0.3f
Rvd5_18 vd5_18 vd5_19 0.3
Cvd5_18 vd5_18 0 0.3f
Rvd5_19 vd5_19 vd5_20 0.3
Cvd5_19 vd5_19 0 0.3f
Rvd5_20 vd5_20 vd5_21 0.3
Cvd5_20 vd5_20 0 0.3f
Rvd5_21 vd5_21 vd5_22 0.3
Cvd5_21 vd5_21 0 0.3f
Rvd5_22 vd5_22 vd5_23 0.3
Cvd5_22 vd5_22 0 0.3f
Rvd5_23 vd5_23 vd5_24 0.3
Cvd5_23 vd5_23 0 0.3f
Rvd5_24 vd5_24 vd5_25 0.3
Cvd5_24 vd5_24 0 0.3f
Rvd5_25 vd5_25 vd5_26 0.3
Cvd5_25 vd5_25 0 0.3f
Rvd5_26 vd5_26 vd5_27 0.3
Cvd5_26 vd5_26 0 0.3f
Rvd5_27 vd5_27 vd5_28 0.3
Cvd5_27 vd5_27 0 0.3f
Rvd5_28 vd5_28 vd5_29 0.3
Cvd5_28 vd5_28 0 0.3f
Rvd5_29 vd5_29 vd5_30 0.3
Cvd5_29 vd5_29 0 0.3f
Rvd5_30 vd5_30 vd5_31 0.3
Cvd5_30 vd5_30 0 0.3f
Rvd5_31 vd5_31 vd5_32 0.3
Cvd5_31 vd5_31 0 0.3f
Rvds5_0 vd5_0 vd6_0 0.2
Rvds5_16 vd5_16 vd6_16 0.2
Rvds5_32 vd5_32 vd6_32 0.2
Rvd6_0 vd6_0 vd6_1 0.3
Cvd6_0 vd6_0 0 0.3f
Rvd6_1 vd6_1 vd6_2 0.3
Cvd6_1 vd6_1 0 0.3f
Rvd6_2 vd6_2 vd6_3 0.3
Cvd6_2 vd6_2 0 0.3f
Rvd6_3 vd6_3 vd6_4 0.3
Cvd6_3 vd6_3 0 0.3f
Rvd6_4 vd6_4 vd6_5 0.3
Cvd6_4 vd6_4 0 0.3f
Rvd6_5 vd6_5 vd6_6 0.3
Cvd6_5 vd6_5 0 0.3f
Rvd6_6 vd6_6 vd6_7 0.3
Cvd6_6 vd6_6 0 0.3f
Rvd6_7 vd6_7 vd6_8 0.3
Cvd6_7 vd6_7 0 0.3f
Rvd6_8 vd6_8 vd6_9 0.3
Cvd6_8 vd6_8 0 0.3f
Rvd6_9 vd6_9 vd6_10 0.3
Cvd6_9 vd6_9 0 0.3f
Rvd6_10 vd6_10 vd6_11 0.3
Cvd6_10 vd6_10 0 0.3f
Rvd6_11 vd6_11 vd6_12 0.3
Cvd6_11 vd6_11 0 0.3f
Rvd6_12 vd6_12 vd6_13 0.3
Cvd6_12 vd6_12 0 0.3f
Rvd6_13 vd6_13 vd6_14 0.3
Cvd6_13 vd6_13 0 0.3f
Rvd6_14 vd6_14 vd6_15 0.3
Cvd6_14 vd6_14 0 0.3f
Rvd6_15 vd6_15 vd6_16 0.3
Cvd6_15 vd6_15 0 0.3f
Rvd6_16 vd6_16 vd6_17 0.3
Cvd6_16 vd6_16 0 0.3f
Rvd6_17 vd6_17 vd6_18 0.3
Cvd6_17 vd6_17 0 0.3f
Rvd6_18 vd6_18 vd6_19 0.3
Cvd6_18 vd6_18 0 0.3f
Rvd6_19 vd6_19 vd6_20 0.3
Cvd6_19 vd6_19 0 0.3f
Rvd6_20 vd6_20 vd6_21 0.3
Cvd6_20 vd6_20 0 0.3f
Rvd6_21 vd6_21 vd6_22 0.3
Cvd6_21 vd6_21 0 0.3f
Rvd6_22 vd6_22 vd6_23 0.3
Cvd6_22 vd6_22 0 0.3f
Rvd6_23 vd6_23 vd6_24 0.3
Cvd6_23 vd6_23 0 0.3f
Rvd6_24 vd6_24 vd6_25 0.3
Cvd6_24 vd6_24 0 0.3f
Rvd6_25 vd6_25 vd6_26 0.3
Cvd6_25 vd6_25 0 0.3f
Rvd6_26 vd6_26 vd6_27 0.3
Cvd6_26 vd6_26 0 0.3f
Rvd6_27 vd6_27 vd6_28 0.3
Cvd6_27 vd6_27 0 0.3f
Rvd6_28 vd6_28 vd6_29 0.3
Cvd6_28 vd6_28 0 0.3f
Rvd6_29 vd6_29 vd6_30 0.3
Cvd6_29 vd6_29 0 0.3f
Rvd6_30 vd6_30 vd6_31 0.3
Cvd6_30 vd6_30 0 0.3f
Rvd6_31 vd6_31 vd6_32 0.3
Cvd6_31 vd6_31 0 0.3f
Rvds6_0 vd6_0 vd7_0 0.2
Rvds6_16 vd6_16 vd7_16 0.2
Rvds6_32 vd6_32 vd7_32 0.2
Rvd7_0 vd7_0 vd7_1 0.3
Cvd7_0 vd7_0 0 0.3f
Rvd7_1 vd7_1 vd7_2 0.3
Cvd7_1 vd7_1 0 0.3f
Rvd7_2 vd7_2 vd7_3 0.3
Cvd7_2 vd7_2 0 0.3f
Rvd7_3 vd7_3 vd7_4 0.3
Cvd7_3 vd7_3 0 0.3f
Rvd7_4 vd7_4 vd7_5 0.3
Cvd7_4 vd7_4 0 0.3f
Rvd7_5 vd7_5 vd7_6 0.3
Cvd7_5 vd7_5 0 0.3f
Rvd7_6 vd7_6 vd7_7 0.3
Cvd7_6 vd7_6 0 0.3f
Rvd7_7 vd7_7 vd7_8 0.3
Cvd7_7 vd7_7 0 0.3f
Rvd7_8 vd7_8 vd7_9 0.3
Cvd7_8 vd7_8 0 0.3f
Rvd7_9 vd7_9 vd7_10 0.3
Cvd7_9 vd7_9 0 0.3f
Rvd7_10 vd7_10 vd7_11 0.3
Cvd7_10 vd7_10 0 0.3f
Rvd7_11 vd7_11 vd7_12 0.3
Cvd7_11 vd7_11 0 0.3f
Rvd7_12 vd7_12 vd7_13 0.3
Cvd7_12 vd7_12 0 0.3f
Rvd7_13 vd7_13 vd7_14 0.3
Cvd7_13 vd7_13 0 0.3f
Rvd7_14 vd7_14 vd7_15 0.3
Cvd7_14 vd7_14 0 0.3f
Rvd7_15 vd7_15 vd7_16 0.3
Cvd7_15 vd7_15 0 0.3f
Rvd7_16 vd7_16 vd7_17 0.3
Cvd7_16 vd7_16 0 0.3f
Rvd7_17 vd7_17 vd7_18 0.3
Cvd7_17 vd7_17 0 0.3f
Rvd7_18 vd7_18 vd7_19 0.3
Cvd7_18 vd7_18 0 0.3f
Rvd7_19 vd7_19 vd7_20 0.3
Cvd7_19 vd7_19 0 0.3f
Rvd7_20 vd7_20 vd7_21 0.3
Cvd7_20 vd7_20 0 0.3f
Rvd7_21 vd7_21 vd7_22 0.3
Cvd7_21 vd7_21 0 0.3f
Rvd7_22 vd7_22 vd7_23 0.3
Cvd7_22 vd7_22 0 0.3f
Rvd7_23 vd7_23 vd7_24 0.3
Cvd7_23 vd7_23 0 0.3f
Rvd7_24 vd7_24 vd7_25 0.3
Cvd7_24 vd7_24 0 0.3f
Rvd7_25 vd7_25 vd7_26 0.3
Cvd7_25 vd7_25 0 0.3f
Rvd7_26 vd7_26 vd7_27 0.3
Cvd7_26 vd7_26 0 0.3f
Rvd7_27 vd7_27 vd7_28 0.3
Cvd7_27 vd7_27 0 0.3f
Rvd7_28 vd7_28 vd7_29 0.3
Cvd7_28 vd7_28 0 0.3f
Rvd7_29 vd7_29 vd7_30 0.3
Cvd7_29 vd7_29 0 0.3f
Rvd7_30 vd7_30 vd7_31 0.3
Cvd7_30 vd7_30 0 0.3f
Rvd7_31 vd7_31 vd7_32 0.3
Cvd7_31 vd7_31 0 0.3f
Rvds7_0 vd7_0 vd8_0 0.2
Rvds7_16 vd7_16 vd8_16 0.2
Rvds7_32 vd7_32 vd8_32 0.2
Rvd8_0 vd8_0 vd8_1 0.3
Cvd8_0 vd8_0 0 0.3f
Rvd8_1 vd8_1 vd8_2 0.3
Cvd8_1 vd8_1 0 0.3f
Rvd8_2 vd8_2 vd8_3 0.3
Cvd8_2 vd8_2 0 0.3f
Rvd8_3 vd8_3 vd8_4 0.3
Cvd8_3 vd8_3 0 0.3f
Rvd8_4 vd8_4 vd8_5 0.3
Cvd8_4 vd8_4 0 0.3f
Rvd8_5 vd8_5 vd8_6 0.3
Cvd8_5 vd8_5 0 0.3f
Rvd8_6 vd8_6 vd8_7 0.3
Cvd8_6 vd8_6 0 0.3f
Rvd8_7 vd8_7 vd8_8 0.3
Cvd8_7 vd8_7 0 0.3f
Rvd8_8 vd8_8 vd8_9 0.3
Cvd8_8 vd8_8 0 0.3f
Rvd8_9 vd8_9 vd8_10 0.3
Cvd8_9 vd8_9 0 0.3f
Rvd8_10 vd8_10 vd8_11 0.3
Cvd8_10 vd8_10 0 0.3f
Rvd8_11 vd8_11 vd8_12 0.3
Cvd8_11 vd8_11 0 0.3f
Rvd8_12 vd8_12 vd8_13 0.3
Cvd8_12 vd8_12 0 0.3f
Rvd8_13 vd8_13 vd8_14 0.3
Cvd8_13 vd8_13 0 0.3f
Rvd8_14 vd8_14 vd8_15 0.3
Cvd8_14 vd8_14 0 0.3f
Rvd8_15 vd8_15 vd8_16 0.3
Cvd8_15 vd8_15 0 0.3f
Rvd8_16 vd8_16 vd8_17 0.3
Cvd8_16 vd8_16 0 0.3f
Rvd8_17 vd8_17 vd8_18 0.3
Cvd8_17 vd8_17 0 0.3f
Rvd8_18 vd8_18 vd8_19 0.3
Cvd8_18 vd8_18 0 0.3f
Rvd8_19 vd8_19 vd8_20 0.3
Cvd8_19 vd8_19 0 0.3f
Rvd8_20 vd8_20 vd8_21 0.3
Cvd8_20 vd8_20 0 0.3f
Rvd8_21 vd8_21 vd8_22 0.3
Cvd8_21 vd8_21 0 0.3f
Rvd8_22 vd8_22 vd8_23 0.3
Cvd8_22 vd8_22 0 0.3f
Rvd8_23 vd8_23 vd8_24 0.3
Cvd8_23 vd8_23 0 0.3f
Rvd8_24 vd8_24 vd8_25 0.3
Cvd8_24 vd8_24 0 0.3f
Rvd8_25 vd8_25 vd8_26 0.3
Cvd8_25 vd8_25 0 0.3f
Rvd8_26 vd8_26 vd8_27 0.3
Cvd8_26 vd8_26 0 0.3f
Rvd8_27 vd8_27 vd8_28 0.3
Cvd8_27 vd8_27 0 0.3f
Rvd8_28 vd8_28 vd8_29 0.3
Cvd8_28 vd8_28 0 0.3f
Rvd8_29 vd8_29 vd8_30 0.3
Cvd8_29 vd8_29 0 0.3f
Rvd8_30 vd8_30 vd8_31 0.3
Cvd8_30 vd8_30 0 0.3f
Rvd8_31 vd8_31 vd8_32 0.3
Cvd8_31 vd8_31 0 0.3f
Rvds8_0 vd8_0 vd9_0 0.2
Rvds8_16 vd8_16 vd9_16 0.2
Rvds8_32 vd8_32 vd9_32 0.2
Rvd9_0 vd9_0 vd9_1 0.3
Cvd9_0 vd9_0 0 0.3f
Rvd9_1 vd9_1 vd9_2 0.3
Cvd9_1 vd9_1 0 0.3f
Rvd9_2 vd9_2 vd9_3 0.3
Cvd9_2 vd9_2 0 0.3f
Rvd9_3 vd9_3 vd9_4 0.3
Cvd9_3 vd9_3 0 0.3f
Rvd9_4 vd9_4 vd9_5 0.3
Cvd9_4 vd9_4 0 0.3f
Rvd9_5 vd9_5 vd9_6 0.3
Cvd9_5 vd9_5 0 0.3f
Rvd9_6 vd9_6 vd9_7 0.3
Cvd9_6 vd9_6 0 0.3f
Rvd9_7 vd9_7 vd9_8 0.3
Cvd9_7 vd9_7 0 0.3f
Rvd9_8 vd9_8 vd9_9 0.3
Cvd9_8 vd9_8 0 0.3f
Rvd9_9 vd9_9 vd9_10 0.3
Cvd9_9 vd9_9 0 0.3f
Rvd9_10 vd9_10 vd9_11 0.3
Cvd9_10 vd9_10 0 0.3f
Rvd9_11 vd9_11 vd9_12 0.3
Cvd9_11 vd9_11 0 0.3f
Rvd9_12 vd9_12 vd9_13 0.3
Cvd9_12 vd9_12 0 0.3f
Rvd9_13 vd9_13 vd9_14 0.3
Cvd9_13 vd9_13 0 0.3f
Rvd9_14 vd9_14 vd9_15 0.3
Cvd9_14 vd9_14 0 0.3f
Rvd9_15 vd9_15 vd9_16 0.3
Cvd9_15 vd9_15 0 0.3f
Rvd9_16 vd9_16 vd9_17 0.3
Cvd9_16 vd9_16 0 0.3f
Rvd9_17 vd9_17 vd9_18 0.3
Cvd9_17 vd9_17 0 0.3f
Rvd9_18 vd9_18 vd9_19 0.3
Cvd9_18 vd9_18 0 0.3f
Rvd9_19 vd9_19 vd9_20 0.3
Cvd9_19 vd9_19 0 0.3f
Rvd9_20 vd9_20 vd9_21 0.3
Cvd9_20 vd9_20 0 0.3f
Rvd9_21 vd9_21 vd9_22 0.3
Cvd9_21 vd9_21 0 0.3f
Rvd9_22 vd9_22 vd9_23 0.3
Cvd9_22 vd9_22 0 0.3f
Rvd9_23 vd9_23 vd9_24 0.3
Cvd9_23 vd9_23 0 0.3f
Rvd9_24 vd9_24 vd9_25 0.3
Cvd9_24 vd9_24 0 0.3f
Rvd9_25 vd9_25 vd9_26 0.3
Cvd9_25 vd9_25 0 0.3f
Rvd9_26 vd9_26 vd9_27 0.3
Cvd9_26 vd9_26 0 0.3f
Rvd9_27 vd9_27 vd9_28 0.3
Cvd9_27 vd9_27 0 0.3f
Rvd9_28 vd9_28 vd9_29 0.3
Cvd9_28 vd9_28 0 0.3f
Rvd9_29 vd9_29 vd9_30 0.3
Cvd9_29 vd9_29 0 0.3f
Rvd9_30 vd9_30 vd9_31 0.3
Cvd9_30 vd9_30 0 0.3f
Rvd9_31 vd9_31 vd9_32 0.3
Cvd9_31 vd9_31 0 0.3f
Rvds9_0 vd9_0 vd10_0 0.2
Rvds9_16 vd9_16 vd10_16 0.2
Rvds9_32 vd9_32 vd10_32 0.2
Rvd10_0 vd10_0 vd10_1 0.3
Cvd10_0 vd10_0 0 0.3f
Rvd10_1 vd10_1 vd10_2 0.3
Cvd10_1 vd10_1 0 0.3f
Rvd10_2 vd10_2 vd10_3 0.3
Cvd10_2 vd10_2 0 0.3f
Rvd10_3 vd10_3 vd10_4 0.3
Cvd10_3 vd10_3 0 0.3f
Rvd10_4 vd10_4 vd10_5 0.3
Cvd10_4 vd10_4 0 0.3f
Rvd10_5 vd10_5 vd10_6 0.3
Cvd10_5 vd10_5 0 0.3f
Rvd10_6 vd10_6 vd10_7 0.3
Cvd10_6 vd10_6 0 0.3f
Rvd10_7 vd10_7 vd10_8 0.3
Cvd10_7 vd10_7 0 0.3f
Rvd10_8 vd10_8 vd10_9 0.3
Cvd10_8 vd10_8 0 0.3f
Rvd10_9 vd10_9 vd10_10 0.3
Cvd10_9 vd10_9 0 0.3f
Rvd10_10 vd10_10 vd10_11 0.3
Cvd10_10 vd10_10 0 0.3f
Rvd10_11 vd10_11 vd10_12 0.3
Cvd10_11 vd10_11 0 0.3f
Rvd10_12 vd10_12 vd10_13 0.3
Cvd10_12 vd10_12 0 0.3f
Rvd10_13 vd10_13 vd10_14 0.3
Cvd10_13 vd10_13 0 0.3f
Rvd10_14 vd10_14 vd10_15 0.3
Cvd10_14 vd10_14 0 0.3f
Rvd10_15 vd10_15 vd10_16 0.3
Cvd10_15 vd10_15 0 0.3f
Rvd10_16 vd10_16 vd10_17 0.3
Cvd10_16 vd10_16 0 0.3f
Rvd10_17 vd10_17 vd10_18 0.3
Cvd10_17 vd10_17 0 0.3f
Rvd10_18 vd10_18 vd10_19 0.3
Cvd10_18 vd10_18 0 0.3f
Rvd10_19 vd10_19 vd10_20 0.3
Cvd10_19 vd10_19 0 0.3f
Rvd10_20 vd10_20 vd10_21 0.3
Cvd10_20 vd10_20 0 0.3f
Rvd10_21 vd10_21 vd10_22 0.3
Cvd10_21 vd10_21 0 0.3f
Rvd10_22 vd10_22 vd10_23 0.3
Cvd10_22 vd10_22 0 0.3f
Rvd10_23 vd10_23 vd10_24 0.3
Cvd10_23 vd10_23 0 0.3f
Rvd10_24 vd10_24 vd10_25 0.3
Cvd10_24 vd10_24 0 0.3f
Rvd10_25 vd10_25 vd10_26 0.3
Cvd10_25 vd10_25 0 0.3f
Rvd10_26 vd10_26 vd10_27 0.3
Cvd10_26 vd10_26 0 0.3f
Rvd10_27 vd10_27 vd10_28 0.3
Cvd10_27 vd10_27 0 0.3f
Rvd10_28 vd10_28 vd10_29 0.3
Cvd10_28 vd10_28 0 0.3f
Rvd10_29 vd10_29 vd10_30 0.3
Cvd10_29 vd10_29 0 0.3f
Rvd10_30 vd10_30 vd10_31 0.3
Cvd10_30 vd10_30 0 0.3f
Rvd10_31 vd10_31 vd10_32 0.3
Cvd10_31 vd10_31 0 0.3f
Rvds10_0 vd10_0 vd11_0 0.2
Rvds10_16 vd10_16 vd11_16 0.2
Rvds10_32 vd10_32 vd11_32 0.2
Rvd11_0 vd11_0 vd11_1 0.3
Cvd11_0 vd11_0 0 0.3f
Rvd11_1 vd11_1 vd11_2 0.3
Cvd11_1 vd11_1 0 0.3f
Rvd11_2 vd11_2 vd11_3 0.3
Cvd11_2 vd11_2 0 0.3f
Rvd11_3 vd11_3 vd11_4 0.3
Cvd11_3 vd11_3 0 0.3f
Rvd11_4 vd11_4 vd11_5 0.3
Cvd11_4 vd11_4 0 0.3f
Rvd11_5 vd11_5 vd11_6 0.3
Cvd11_5 vd11_5 0 0.3f
Rvd11_6 vd11_6 vd11_7 0.3
Cvd11_6 vd11_6 0 0.3f
Rvd11_7 vd11_7 vd11_8 0.3
Cvd11_7 vd11_7 0 0.3f
Rvd11_8 vd11_8 vd11_9 0.3
Cvd11_8 vd11_8 0 0.3f
Rvd11_9 vd11_9 vd11_10 0.3
Cvd11_9 vd11_9 0 0.3f
Rvd11_10 vd11_10 vd11_11 0.3
Cvd11_10 vd11_10 0 0.3f
Rvd11_11 vd11_11 vd11_12 0.3
Cvd11_11 vd11_11 0 0.3f
Rvd11_12 vd11_12 vd11_13 0.3
Cvd11_12 vd11_12 0 0.3f
Rvd11_13 vd11_13 vd11_14 0.3
Cvd11_13 vd11_13 0 0.3f
Rvd11_14 vd11_14 vd11_15 0.3
Cvd11_14 vd11_14 0 0.3f
Rvd11_15 vd11_15 vd11_16 0.3
Cvd11_15 vd11_15 0 0.3f
Rvd11_16 vd11_16 vd11_17 0.3
Cvd11_16 vd11_16 0 0.3f
Rvd11_17 vd11_17 vd11_18 0.3
Cvd11_17 vd11_17 0 0.3f
Rvd11_18 vd11_18 vd11_19 0.3
Cvd11_18 vd11_18 0 0.3f
Rvd11_19 vd11_19 vd11_20 0.3
Cvd11_19 vd11_19 0 0.3f
Rvd11_20 vd11_20 vd11_21 0.3
Cvd11_20 vd11_20 0 0.3f
Rvd11_21 vd11_21 vd11_22 0.3
Cvd11_21 vd11_21 0 0.3f
Rvd11_22 vd11_22 vd11_23 0.3
Cvd11_22 vd11_22 0 0.3f
Rvd11_23 vd11_23 vd11_24 0.3
Cvd11_23 vd11_23 0 0.3f
Rvd11_24 vd11_24 vd11_25 0.3
Cvd11_24 vd11_24 0 0.3f
Rvd11_25 vd11_25 vd11_26 0.3
Cvd11_25 vd11_25 0 0.3f
Rvd11_26 vd11_26 vd11_27 0.3
Cvd11_26 vd11_26 0 0.3f
Rvd11_27 vd11_27 vd11_28 0.3
Cvd11_27 vd11_27 0 0.3f
Rvd11_28 vd11_28 vd11_29 0.3
Cvd11_28 vd11_28 0 0.3f
Rvd11_29 vd11_29 vd11_30 0.3
Cvd11_29 vd11_29 0 0.3f
Rvd11_30 vd11_30 vd11_31 0.3
Cvd11_30 vd11_30 0 0.3f
Rvd11_31 vd11_31 vd11_32 0.3
Cvd11_31 vd11_31 0 0.3f
Rvds11_0 vd11_0 vd12_0 0.2
Rvds11_16 vd11_16 vd12_16 0.2
Rvds11_32 vd11_32 vd12_32 0.2
Rvd12_0 vd12_0 vd12_1 0.3
Cvd12_0 vd12_0 0 0.3f
Rvd12_1 vd12_1 vd12_2 0.3
Cvd12_1 vd12_1 0 0.3f
Rvd12_2 vd12_2 vd12_3 0.3
Cvd12_2 vd12_2 0 0.3f
Rvd12_3 vd12_3 vd12_4 0.3
Cvd12_3 vd12_3 0 0.3f
Rvd12_4 vd12_4 vd12_5 0.3
Cvd12_4 vd12_4 0 0.3f
Rvd12_5 vd12_5 vd12_6 0.3
Cvd12_5 vd12_5 0 0.3f
Rvd12_6 vd12_6 vd12_7 0.3
Cvd12_6 vd12_6 0 0.3f
Rvd12_7 vd12_7 vd12_8 0.3
Cvd12_7 vd12_7 0 0.3f
Rvd12_8 vd12_8 vd12_9 0.3
Cvd12_8 vd12_8 0 0.3f
Rvd12_9 vd12_9 vd12_10 0.3
Cvd12_9 vd12_9 0 0.3f
Rvd12_10 vd12_10 vd12_11 0.3
Cvd12_10 vd12_10 0 0.3f
Rvd12_11 vd12_11 vd12_12 0.3
Cvd12_11 vd12_11 0 0.3f
Rvd12_12 vd12_12 vd12_13 0.3
Cvd12_12 vd12_12 0 0.3f
Rvd12_13 vd12_13 vd12_14 0.3
Cvd12_13 vd12_13 0 0.3f
Rvd12_14 vd12_14 vd12_15 0.3
Cvd12_14 vd12_14 0 0.3f
Rvd12_15 vd12_15 vd12_16 0.3
Cvd12_15 vd12_15 0 0.3f
Rvd12_16 vd12_16 vd12_17 0.3
Cvd12_16 vd12_16 0 0.3f
Rvd12_17 vd12_17 vd12_18 0.3
Cvd12_17 vd12_17 0 0.3f
Rvd12_18 vd12_18 vd12_19 0.3
Cvd12_18 vd12_18 0 0.3f
Rvd12_19 vd12_19 vd12_20 0.3
Cvd12_19 vd12_19 0 0.3f
Rvd12_20 vd12_20 vd12_21 0.3
Cvd12_20 vd12_20 0 0.3f
Rvd12_21 vd12_21 vd12_22 0.3
Cvd12_21 vd12_21 0 0.3f
Rvd12_22 vd12_22 vd12_23 0.3
Cvd12_22 vd12_22 0 0.3f
Rvd12_23 vd12_23 vd12_24 0.3
Cvd12_23 vd12_23 0 0.3f
Rvd12_24 vd12_24 vd12_25 0.3
Cvd12_24 vd12_24 0 0.3f
Rvd12_25 vd12_25 vd12_26 0.3
Cvd12_25 vd12_25 0 0.3f
Rvd12_26 vd12_26 vd12_27 0.3
Cvd12_26 vd12_26 0 0.3f
Rvd12_27 vd12_27 vd12_28 0.3
Cvd12_27 vd12_27 0 0.3f
Rvd12_28 vd12_28 vd12_29 0.3
Cvd12_28 vd12_28 0 0.3f
Rvd12_29 vd12_29 vd12_30 0.3
Cvd12_29 vd12_29 0 0.3f
Rvd12_30 vd12_30 vd12_31 0.3
Cvd12_30 vd12_30 0 0.3f
Rvd12_31 vd12_31 vd12_32 0.3
Cvd12_31 vd12_31 0 0.3f
Rvds12_0 vd12_0 vd13_0 0.2
Rvds12_16 vd12_16 vd13_16 0.2
Rvds12_32 vd12_32 vd13_32 0.2
Rvd13_0 vd13_0 vd13_1 0.3
Cvd13_0 vd13_0 0 0.3f
Rvd13_1 vd13_1 vd13_2 0.3
Cvd13_1 vd13_1 0 0.3f
Rvd13_2 vd13_2 vd13_3 0.3
Cvd13_2 vd13_2 0 0.3f
Rvd13_3 vd13_3 vd13_4 0.3
Cvd13_3 vd13_3 0 0.3f
Rvd13_4 vd13_4 vd13_5 0.3
Cvd13_4 vd13_4 0 0.3f
Rvd13_5 vd13_5 vd13_6 0.3
Cvd13_5 vd13_5 0 0.3f
Rvd13_6 vd13_6 vd13_7 0.3
Cvd13_6 vd13_6 0 0.3f
Rvd13_7 vd13_7 vd13_8 0.3
Cvd13_7 vd13_7 0 0.3f
Rvd13_8 vd13_8 vd13_9 0.3
Cvd13_8 vd13_8 0 0.3f
Rvd13_9 vd13_9 vd13_10 0.3
Cvd13_9 vd13_9 0 0.3f
Rvd13_10 vd13_10 vd13_11 0.3
Cvd13_10 vd13_10 0 0.3f
Rvd13_11 vd13_11 vd13_12 0.3
Cvd13_11 vd13_11 0 0.3f
Rvd13_12 vd13_12 vd13_13 0.3
Cvd13_12 vd13_12 0 0.3f
Rvd13_13 vd13_13 vd13_14 0.3
Cvd13_13 vd13_13 0 0.3f
Rvd13_14 vd13_14 vd13_15 0.3
Cvd13_14 vd13_14 0 0.3f
Rvd13_15 vd13_15 vd13_16 0.3
Cvd13_15 vd13_15 0 0.3f
Rvd13_16 vd13_16 vd13_17 0.3
Cvd13_16 vd13_16 0 0.3f
Rvd13_17 vd13_17 vd13_18 0.3
Cvd13_17 vd13_17 0 0.3f
Rvd13_18 vd13_18 vd13_19 0.3
Cvd13_18 vd13_18 0 0.3f
Rvd13_19 vd13_19 vd13_20 0.3
Cvd13_19 vd13_19 0 0.3f
Rvd13_20 vd13_20 vd13_21 0.3
Cvd13_20 vd13_20 0 0.3f
Rvd13_21 vd13_21 vd13_22 0.3
Cvd13_21 vd13_21 0 0.3f
Rvd13_22 vd13_22 vd13_23 0.3
Cvd13_22 vd13_22 0 0.3f
Rvd13_23 vd13_23 vd13_24 0.3
Cvd13_23 vd13_23 0 0.3f
Rvd13_24 vd13_24 vd13_25 0.3
Cvd13_24 vd13_24 0 0.3f
Rvd13_25 vd13_25 vd13_26 0.3
Cvd13_25 vd13_25 0 0.3f
Rvd13_26 vd13_26 vd13_27 0.3
Cvd13_26 vd13_26 0 0.3f
Rvd13_27 vd13_27 vd13_28 0.3
Cvd13_27 vd13_27 0 0.3f
Rvd13_28 vd13_28 vd13_29 0.3
Cvd13_28 vd13_28 0 0.3f
Rvd13_29 vd13_29 vd13_30 0.3
Cvd13_29 vd13_29 0 0.3f
Rvd13_30 vd13_30 vd13_31 0.3
Cvd13_30 vd13_30 0 0.3f
Rvd13_31 vd13_31 vd13_32 0.3
Cvd13_31 vd13_31 0 0.3f
Rvds13_0 vd13_0 vd14_0 0.2
Rvds13_16 vd13_16 vd14_16 0.2
Rvds13_32 vd13_32 vd14_32 0.2
Rvd14_0 vd14_0 vd14_1 0.3
Cvd14_0 vd14_0 0 0.3f
Rvd14_1 vd14_1 vd14_2 0.3
Cvd14_1 vd14_1 0 0.3f
Rvd14_2 vd14_2 vd14_3 0.3
Cvd14_2 vd14_2 0 0.3f
Rvd14_3 vd14_3 vd14_4 0.3
Cvd14_3 vd14_3 0 0.3f
Rvd14_4 vd14_4 vd14_5 0.3
Cvd14_4 vd14_4 0 0.3f
Rvd14_5 vd14_5 vd14_6 0.3
Cvd14_5 vd14_5 0 0.3f
Rvd14_6 vd14_6 vd14_7 0.3
Cvd14_6 vd14_6 0 0.3f
Rvd14_7 vd14_7 vd14_8 0.3
Cvd14_7 vd14_7 0 0.3f
Rvd14_8 vd14_8 vd14_9 0.3
Cvd14_8 vd14_8 0 0.3f
Rvd14_9 vd14_9 vd14_10 0.3
Cvd14_9 vd14_9 0 0.3f
Rvd14_10 vd14_10 vd14_11 0.3
Cvd14_10 vd14_10 0 0.3f
Rvd14_11 vd14_11 vd14_12 0.3
Cvd14_11 vd14_11 0 0.3f
Rvd14_12 vd14_12 vd14_13 0.3
Cvd14_12 vd14_12 0 0.3f
Rvd14_13 vd14_13 vd14_14 0.3
Cvd14_13 vd14_13 0 0.3f
Rvd14_14 vd14_14 vd14_15 0.3
Cvd14_14 vd14_14 0 0.3f
Rvd14_15 vd14_15 vd14_16 0.3
Cvd14_15 vd14_15 0 0.3f
Rvd14_16 vd14_16 vd14_17 0.3
Cvd14_16 vd14_16 0 0.3f
Rvd14_17 vd14_17 vd14_18 0.3
Cvd14_17 vd14_17 0 0.3f
Rvd14_18 vd14_18 vd14_19 0.3
Cvd14_18 vd14_18 0 0.3f
Rvd14_19 vd14_19 vd14_20 0.3
Cvd14_19 vd14_19 0 0.3f
Rvd14_20 vd14_20 vd14_21 0.3
Cvd14_20 vd14_20 0 0.3f
Rvd14_21 vd14_21 vd14_22 0.3
Cvd14_21 vd14_21 0 0.3f
Rvd14_22 vd14_22 vd14_23 0.3
Cvd14_22 vd14_22 0 0.3f
Rvd14_23 vd14_23 vd14_24 0.3
Cvd14_23 vd14_23 0 0.3f
Rvd14_24 vd14_24 vd14_25 0.3
Cvd14_24 vd14_24 0 0.3f
Rvd14_25 vd14_25 vd14_26 0.3
Cvd14_25 vd14_25 0 0.3f
Rvd14_26 vd14_26 vd14_27 0.3
Cvd14_26 vd14_26 0 0.3f
Rvd14_27 vd14_27 vd14_28 0.3
Cvd14_27 vd14_27 0 0.3f
Rvd14_28 vd14_28 vd14_29 0.3
Cvd14_28 vd14_28 0 0.3f
Rvd14_29 vd14_29 vd14_30 0.3
Cvd14_29 vd14_29 0 0.3f
Rvd14_30 vd14_30 vd14_31 0.3
Cvd14_30 vd14_30 0 0.3f
Rvd14_31 vd14_31 vd14_32 0.3
Cvd14_31 vd14_31 0 0.3f
Rvds14_0 vd14_0 vd15_0 0.2
Rvds14_16 vd14_16 vd15_16 0.2
Rvds14_32 vd14_32 vd15_32 0.2
Rvd15_0 vd15_0 vd15_1 0.3
Cvd15_0 vd15_0 0 0.3f
Rvd15_1 vd15_1 vd15_2 0.3
Cvd15_1 vd15_1 0 0.3f
Rvd15_2 vd15_2 vd15_3 0.3
Cvd15_2 vd15_2 0 0.3f
Rvd15_3 vd15_3 vd15_4 0.3
Cvd15_3 vd15_3 0 0.3f
Rvd15_4 vd15_4 vd15_5 0.3
Cvd15_4 vd15_4 0 0.3f
Rvd15_5 vd15_5 vd15_6 0.3
Cvd15_5 vd15_5 0 0.3f
Rvd15_6 vd15_6 vd15_7 0.3
Cvd15_6 vd15_6 0 0.3f
Rvd15_7 vd15_7 vd15_8 0.3
Cvd15_7 vd15_7 0 0.3f
Rvd15_8 vd15_8 vd15_9 0.3
Cvd15_8 vd15_8 0 0.3f
Rvd15_9 vd15_9 vd15_10 0.3
Cvd15_9 vd15_9 0 0.3f
Rvd15_10 vd15_10 vd15_11 0.3
Cvd15_10 vd15_10 0 0.3f
Rvd15_11 vd15_11 vd15_12 0.3
Cvd15_11 vd15_11 0 0.3f
Rvd15_12 vd15_12 vd15_13 0.3
Cvd15_12 vd15_12 0 0.3f
Rvd15_13 vd15_13 vd15_14 0.3
Cvd15_13 vd15_13 0 0.3f
Rvd15_14 vd15_14 vd15_15 0.3
Cvd15_14 vd15_14 0 0.3f
Rvd15_15 vd15_15 vd15_16 0.3
Cvd15_15 vd15_15 0 0.3f
Rvd15_16 vd15_16 vd15_17 0.3
Cvd15_16 vd15_16 0 0.3f
Rvd15_17 vd15_17 vd15_18 0.3
Cvd15_17 vd15_17 0 0.3f
Rvd15_18 vd15_18 vd15_19 0.3
Cvd15_18 vd15_18 0 0.3f
Rvd15_19 vd15_19 vd15_20 0.3
Cvd15_19 vd15_19 0 0.3f
Rvd15_20 vd15_20 vd15_21 0.3
Cvd15_20 vd15_20 0 0.3f
Rvd15_21 vd15_21 vd15_22 0.3
Cvd15_21 vd15_21 0 0.3f
Rvd15_22 vd15_22 vd15_23 0.3
Cvd15_22 vd15_22 0 0.3f
Rvd15_23 vd15_23 vd15_24 0.3
Cvd15_23 vd15_23 0 0.3f
Rvd15_24 vd15_24 vd15_25 0.3
Cvd15_24 vd15_24 0 0.3f
Rvd15_25 vd15_25 vd15_26 0.3
Cvd15_25 vd15_25 0 0.3f
Rvd15_26 vd15_26 vd15_27 0.3
Cvd15_26 vd15_26 0 0.3f
Rvd15_27 vd15_27 vd15_28 0.3
Cvd15_27 vd15_27 0 0.3f
Rvd15_28 vd15_28 vd15_29 0.3
Cvd15_28 vd15_28 0 0.3f
Rvd15_29 vd15_29 vd15_30 0.3
Cvd15_29 vd15_29 0 0.3f
Rvd15_30 vd15_30 vd15_31 0.3
Cvd15_30 vd15_30 0 0.3f
Rvd15_31 vd15_31 vd15_32 0.3
Cvd15_31 vd15_31 0 0.3f
Rvdp0 vdd vd0_0 0.5
Rvdp32 vdd vd0_32 0.5
Rvs0_0 vs0_0 vs0_1 0.3
Cvs0_0 vs0_0 0 0.3f
Rvs0_1 vs0_1 vs0_2 0.3
Cvs0_1 vs0_1 0 0.3f
Rvs0_2 vs0_2 vs0_3 0.3
Cvs0_2 vs0_2 0 0.3f
Rvs0_3 vs0_3 vs0_4 0.3
Cvs0_3 vs0_3 0 0.3f
Rvs0_4 vs0_4 vs0_5 0.3
Cvs0_4 vs0_4 0 0.3f
Rvs0_5 vs0_5 vs0_6 0.3
Cvs0_5 vs0_5 0 0.3f
Rvs0_6 vs0_6 vs0_7 0.3
Cvs0_6 vs0_6 0 0.3f
Rvs0_7 vs0_7 vs0_8 0.3
Cvs0_7 vs0_7 0 0.3f
Rvs0_8 vs0_8 vs0_9 0.3
Cvs0_8 vs0_8 0 0.3f
Rvs0_9 vs0_9 vs0_10 0.3
Cvs0_9 vs0_9 0 0.3f
Rvs0_10 vs0_10 vs0_11 0.3
Cvs0_10 vs0_10 0 0.3f
Rvs0_11 vs0_11 vs0_12 0.3
Cvs0_11 vs0_11 0 0.3f
Rvs0_12 vs0_12 vs0_13 0.3
Cvs0_12 vs0_12 0 0.3f
Rvs0_13 vs0_13 vs0_14 0.3
Cvs0_13 vs0_13 0 0.3f
Rvs0_14 vs0_14 vs0_15 0.3
Cvs0_14 vs0_14 0 0.3f
Rvs0_15 vs0_15 vs0_16 0.3
Cvs0_15 vs0_15 0 0.3f
Rvs0_16 vs0_16 vs0_17 0.3
Cvs0_16 vs0_16 0 0.3f
Rvs0_17 vs0_17 vs0_18 0.3
Cvs0_17 vs0_17 0 0.3f
Rvs0_18 vs0_18 vs0_19 0.3
Cvs0_18 vs0_18 0 0.3f
Rvs0_19 vs0_19 vs0_20 0.3
Cvs0_19 vs0_19 0 0.3f
Rvs0_20 vs0_20 vs0_21 0.3
Cvs0_20 vs0_20 0 0.3f
Rvs0_21 vs0_21 vs0_22 0.3
Cvs0_21 vs0_21 0 0.3f
Rvs0_22 vs0_22 vs0_23 0.3
Cvs0_22 vs0_22 0 0.3f
Rvs0_23 vs0_23 vs0_24 0.3
Cvs0_23 vs0_23 0 0.3f
Rvs0_24 vs0_24 vs0_25 0.3
Cvs0_24 vs0_24 0 0.3f
Rvs0_25 vs0_25 vs0_26 0.3
Cvs0_25 vs0_25 0 0.3f
Rvs0_26 vs0_26 vs0_27 0.3
Cvs0_26 vs0_26 0 0.3f
Rvs0_27 vs0_27 vs0_28 0.3
Cvs0_27 vs0_27 0 0.3f
Rvs0_28 vs0_28 vs0_29 0.3
Cvs0_28 vs0_28 0 0.3f
Rvs0_29 vs0_29 vs0_30 0.3
Cvs0_29 vs0_29 0 0.3f
Rvs0_30 vs0_30 vs0_31 0.3
Cvs0_30 vs0_30 0 0.3f
Rvs0_31 vs0_31 vs0_32 0.3
Cvs0_31 vs0_31 0 0.3f
Rvss0_0 vs0_0 vs1_0 0.2
Rvss0_16 vs0_16 vs1_16 0.2
Rvss0_32 vs0_32 vs1_32 0.2
Rvs1_0 vs1_0 vs1_1 0.3
Cvs1_0 vs1_0 0 0.3f
Rvs1_1 vs1_1 vs1_2 0.3
Cvs1_1 vs1_1 0 0.3f
Rvs1_2 vs1_2 vs1_3 0.3
Cvs1_2 vs1_2 0 0.3f
Rvs1_3 vs1_3 vs1_4 0.3
Cvs1_3 vs1_3 0 0.3f
Rvs1_4 vs1_4 vs1_5 0.3
Cvs1_4 vs1_4 0 0.3f
Rvs1_5 vs1_5 vs1_6 0.3
Cvs1_5 vs1_5 0 0.3f
Rvs1_6 vs1_6 vs1_7 0.3
Cvs1_6 vs1_6 0 0.3f
Rvs1_7 vs1_7 vs1_8 0.3
Cvs1_7 vs1_7 0 0.3f
Rvs1_8 vs1_8 vs1_9 0.3
Cvs1_8 vs1_8 0 0.3f
Rvs1_9 vs1_9 vs1_10 0.3
Cvs1_9 vs1_9 0 0.3f
Rvs1_10 vs1_10 vs1_11 0.3
Cvs1_10 vs1_10 0 0.3f
Rvs1_11 vs1_11 vs1_12 0.3
Cvs1_11 vs1_11 0 0.3f
Rvs1_12 vs1_12 vs1_13 0.3
Cvs1_12 vs1_12 0 0.3f
Rvs1_13 vs1_13 vs1_14 0.3
Cvs1_13 vs1_13 0 0.3f
Rvs1_14 vs1_14 vs1_15 0.3
Cvs1_14 vs1_14 0 0.3f
Rvs1_15 vs1_15 vs1_16 0.3
Cvs1_15 vs1_15 0 0.3f
Rvs1_16 vs1_16 vs1_17 0.3
Cvs1_16 vs1_16 0 0.3f
Rvs1_17 vs1_17 vs1_18 0.3
Cvs1_17 vs1_17 0 0.3f
Rvs1_18 vs1_18 vs1_19 0.3
Cvs1_18 vs1_18 0 0.3f
Rvs1_19 vs1_19 vs1_20 0.3
Cvs1_19 vs1_19 0 0.3f
Rvs1_20 vs1_20 vs1_21 0.3
Cvs1_20 vs1_20 0 0.3f
Rvs1_21 vs1_21 vs1_22 0.3
Cvs1_21 vs1_21 0 0.3f
Rvs1_22 vs1_22 vs1_23 0.3
Cvs1_22 vs1_22 0 0.3f
Rvs1_23 vs1_23 vs1_24 0.3
Cvs1_23 vs1_23 0 0.3f
Rvs1_24 vs1_24 vs1_25 0.3
Cvs1_24 vs1_24 0 0.3f
Rvs1_25 vs1_25 vs1_26 0.3
Cvs1_25 vs1_25 0 0.3f
Rvs1_26 vs1_26 vs1_27 0.3
Cvs1_26 vs1_26 0 0.3f
Rvs1_27 vs1_27 vs1_28 0.3
Cvs1_27 vs1_27 0 0.3f
Rvs1_28 vs1_28 vs1_29 0.3
Cvs1_28 vs1_28 0 0.3f
Rvs1_29 vs1_29 vs1_30 0.3
Cvs1_29 vs1_29 0 0.3f
Rvs1_30 vs1_30 vs1_31 0.3
Cvs1_30 vs1_30 0 0.3f
Rvs1_31 vs1_31 vs1_32 0.3
Cvs1_31 vs1_31 0 0.3f
Rvss1_0 vs1_0 vs2_0 0.2
Rvss1_16 vs1_16 vs2_16 0.2
Rvss1_32 vs1_32 vs2_32 0.2
Rvs2_0 vs2_0 vs2_1 0.3
Cvs2_0 vs2_0 0 0.3f
Rvs2_1 vs2_1 vs2_2 0.3
Cvs2_1 vs2_1 0 0.3f
Rvs2_2 vs2_2 vs2_3 0.3
Cvs2_2 vs2_2 0 0.3f
Rvs2_3 vs2_3 vs2_4 0.3
Cvs2_3 vs2_3 0 0.3f
Rvs2_4 vs2_4 vs2_5 0.3
Cvs2_4 vs2_4 0 0.3f
Rvs2_5 vs2_5 vs2_6 0.3
Cvs2_5 vs2_5 0 0.3f
Rvs2_6 vs2_6 vs2_7 0.3
Cvs2_6 vs2_6 0 0.3f
Rvs2_7 vs2_7 vs2_8 0.3
Cvs2_7 vs2_7 0 0.3f
Rvs2_8 vs2_8 vs2_9 0.3
Cvs2_8 vs2_8 0 0.3f
Rvs2_9 vs2_9 vs2_10 0.3
Cvs2_9 vs2_9 0 0.3f
Rvs2_10 vs2_10 vs2_11 0.3
Cvs2_10 vs2_10 0 0.3f
Rvs2_11 vs2_11 vs2_12 0.3
Cvs2_11 vs2_11 0 0.3f
Rvs2_12 vs2_12 vs2_13 0.3
Cvs2_12 vs2_12 0 0.3f
Rvs2_13 vs2_13 vs2_14 0.3
Cvs2_13 vs2_13 0 0.3f
Rvs2_14 vs2_14 vs2_15 0.3
Cvs2_14 vs2_14 0 0.3f
Rvs2_15 vs2_15 vs2_16 0.3
Cvs2_15 vs2_15 0 0.3f
Rvs2_16 vs2_16 vs2_17 0.3
Cvs2_16 vs2_16 0 0.3f
Rvs2_17 vs2_17 vs2_18 0.3
Cvs2_17 vs2_17 0 0.3f
Rvs2_18 vs2_18 vs2_19 0.3
Cvs2_18 vs2_18 0 0.3f
Rvs2_19 vs2_19 vs2_20 0.3
Cvs2_19 vs2_19 0 0.3f
Rvs2_20 vs2_20 vs2_21 0.3
Cvs2_20 vs2_20 0 0.3f
Rvs2_21 vs2_21 vs2_22 0.3
Cvs2_21 vs2_21 0 0.3f
Rvs2_22 vs2_22 vs2_23 0.3
Cvs2_22 vs2_22 0 0.3f
Rvs2_23 vs2_23 vs2_24 0.3
Cvs2_23 vs2_23 0 0.3f
Rvs2_24 vs2_24 vs2_25 0.3
Cvs2_24 vs2_24 0 0.3f
Rvs2_25 vs2_25 vs2_26 0.3
Cvs2_25 vs2_25 0 0.3f
Rvs2_26 vs2_26 vs2_27 0.3
Cvs2_26 vs2_26 0 0.3f
Rvs2_27 vs2_27 vs2_28 0.3
Cvs2_27 vs2_27 0 0.3f
Rvs2_28 vs2_28 vs2_29 0.3
Cvs2_28 vs2_28 0 0.3f
Rvs2_29 vs2_29 vs2_30 0.3
Cvs2_29 vs2_29 0 0.3f
Rvs2_30 vs2_30 vs2_31 0.3
Cvs2_30 vs2_30 0 0.3f
Rvs2_31 vs2_31 vs2_32 0.3
Cvs2_31 vs2_31 0 0.3f
Rvss2_0 vs2_0 vs3_0 0.2
Rvss2_16 vs2_16 vs3_16 0.2
Rvss2_32 vs2_32 vs3_32 0.2
Rvs3_0 vs3_0 vs3_1 0.3
Cvs3_0 vs3_0 0 0.3f
Rvs3_1 vs3_1 vs3_2 0.3
Cvs3_1 vs3_1 0 0.3f
Rvs3_2 vs3_2 vs3_3 0.3
Cvs3_2 vs3_2 0 0.3f
Rvs3_3 vs3_3 vs3_4 0.3
Cvs3_3 vs3_3 0 0.3f
Rvs3_4 vs3_4 vs3_5 0.3
Cvs3_4 vs3_4 0 0.3f
Rvs3_5 vs3_5 vs3_6 0.3
Cvs3_5 vs3_5 0 0.3f
Rvs3_6 vs3_6 vs3_7 0.3
Cvs3_6 vs3_6 0 0.3f
Rvs3_7 vs3_7 vs3_8 0.3
Cvs3_7 vs3_7 0 0.3f
Rvs3_8 vs3_8 vs3_9 0.3
Cvs3_8 vs3_8 0 0.3f
Rvs3_9 vs3_9 vs3_10 0.3
Cvs3_9 vs3_9 0 0.3f
Rvs3_10 vs3_10 vs3_11 0.3
Cvs3_10 vs3_10 0 0.3f
Rvs3_11 vs3_11 vs3_12 0.3
Cvs3_11 vs3_11 0 0.3f
Rvs3_12 vs3_12 vs3_13 0.3
Cvs3_12 vs3_12 0 0.3f
Rvs3_13 vs3_13 vs3_14 0.3
Cvs3_13 vs3_13 0 0.3f
Rvs3_14 vs3_14 vs3_15 0.3
Cvs3_14 vs3_14 0 0.3f
Rvs3_15 vs3_15 vs3_16 0.3
Cvs3_15 vs3_15 0 0.3f
Rvs3_16 vs3_16 vs3_17 0.3
Cvs3_16 vs3_16 0 0.3f
Rvs3_17 vs3_17 vs3_18 0.3
Cvs3_17 vs3_17 0 0.3f
Rvs3_18 vs3_18 vs3_19 0.3
Cvs3_18 vs3_18 0 0.3f
Rvs3_19 vs3_19 vs3_20 0.3
Cvs3_19 vs3_19 0 0.3f
Rvs3_20 vs3_20 vs3_21 0.3
Cvs3_20 vs3_20 0 0.3f
Rvs3_21 vs3_21 vs3_22 0.3
Cvs3_21 vs3_21 0 0.3f
Rvs3_22 vs3_22 vs3_23 0.3
Cvs3_22 vs3_22 0 0.3f
Rvs3_23 vs3_23 vs3_24 0.3
Cvs3_23 vs3_23 0 0.3f
Rvs3_24 vs3_24 vs3_25 0.3
Cvs3_24 vs3_24 0 0.3f
Rvs3_25 vs3_25 vs3_26 0.3
Cvs3_25 vs3_25 0 0.3f
Rvs3_26 vs3_26 vs3_27 0.3
Cvs3_26 vs3_26 0 0.3f
Rvs3_27 vs3_27 vs3_28 0.3
Cvs3_27 vs3_27 0 0.3f
Rvs3_28 vs3_28 vs3_29 0.3
Cvs3_28 vs3_28 0 0.3f
Rvs3_29 vs3_29 vs3_30 0.3
Cvs3_29 vs3_29 0 0.3f
Rvs3_30 vs3_30 vs3_31 0.3
Cvs3_30 vs3_30 0 0.3f
Rvs3_31 vs3_31 vs3_32 0.3
Cvs3_31 vs3_31 0 0.3f
Rvss3_0 vs3_0 vs4_0 0.2
Rvss3_16 vs3_16 vs4_16 0.2
Rvss3_32 vs3_32 vs4_32 0.2
Rvs4_0 vs4_0 vs4_1 0.3
Cvs4_0 vs4_0 0 0.3f
Rvs4_1 vs4_1 vs4_2 0.3
Cvs4_1 vs4_1 0 0.3f
Rvs4_2 vs4_2 vs4_3 0.3
Cvs4_2 vs4_2 0 0.3f
Rvs4_3 vs4_3 vs4_4 0.3
Cvs4_3 vs4_3 0 0.3f
Rvs4_4 vs4_4 vs4_5 0.3
Cvs4_4 vs4_4 0 0.3f
Rvs4_5 vs4_5 vs4_6 0.3
Cvs4_5 vs4_5 0 0.3f
Rvs4_6 vs4_6 vs4_7 0.3
Cvs4_6 vs4_6 0 0.3f
Rvs4_7 vs4_7 vs4_8 0.3
Cvs4_7 vs4_7 0 0.3f
Rvs4_8 vs4_8 vs4_9 0.3
Cvs4_8 vs4_8 0 0.3f
Rvs4_9 vs4_9 vs4_10 0.3
Cvs4_9 vs4_9 0 0.3f
Rvs4_10 vs4_10 vs4_11 0.3
Cvs4_10 vs4_10 0 0.3f
Rvs4_11 vs4_11 vs4_12 0.3
Cvs4_11 vs4_11 0 0.3f
Rvs4_12 vs4_12 vs4_13 0.3
Cvs4_12 vs4_12 0 0.3f
Rvs4_13 vs4_13 vs4_14 0.3
Cvs4_13 vs4_13 0 0.3f
Rvs4_14 vs4_14 vs4_15 0.3
Cvs4_14 vs4_14 0 0.3f
Rvs4_15 vs4_15 vs4_16 0.3
Cvs4_15 vs4_15 0 0.3f
Rvs4_16 vs4_16 vs4_17 0.3
Cvs4_16 vs4_16 0 0.3f
Rvs4_17 vs4_17 vs4_18 0.3
Cvs4_17 vs4_17 0 0.3f
Rvs4_18 vs4_18 vs4_19 0.3
Cvs4_18 vs4_18 0 0.3f
Rvs4_19 vs4_19 vs4_20 0.3
Cvs4_19 vs4_19 0 0.3f
Rvs4_20 vs4_20 vs4_21 0.3
Cvs4_20 vs4_20 0 0.3f
Rvs4_21 vs4_21 vs4_22 0.3
Cvs4_21 vs4_21 0 0.3f
Rvs4_22 vs4_22 vs4_23 0.3
Cvs4_22 vs4_22 0 0.3f
Rvs4_23 vs4_23 vs4_24 0.3
Cvs4_23 vs4_23 0 0.3f
Rvs4_24 vs4_24 vs4_25 0.3
Cvs4_24 vs4_24 0 0.3f
Rvs4_25 vs4_25 vs4_26 0.3
Cvs4_25 vs4_25 0 0.3f
Rvs4_26 vs4_26 vs4_27 0.3
Cvs4_26 vs4_26 0 0.3f
Rvs4_27 vs4_27 vs4_28 0.3
Cvs4_27 vs4_27 0 0.3f
Rvs4_28 vs4_28 vs4_29 0.3
Cvs4_28 vs4_28 0 0.3f
Rvs4_29 vs4_29 vs4_30 0.3
Cvs4_29 vs4_29 0 0.3f
Rvs4_30 vs4_30 vs4_31 0.3
Cvs4_30 vs4_30 0 0.3f
Rvs4_31 vs4_31 vs4_32 0.3
Cvs4_31 vs4_31 0 0.3f
Rvss4_0 vs4_0 vs5_0 0.2
Rvss4_16 vs4_16 vs5_16 0.2
Rvss4_32 vs4_32 vs5_32 0.2
Rvs5_0 vs5_0 vs5_1 0.3
Cvs5_0 vs5_0 0 0.3f
Rvs5_1 vs5_1 vs5_2 0.3
Cvs5_1 vs5_1 0 0.3f
Rvs5_2 vs5_2 vs5_3 0.3
Cvs5_2 vs5_2 0 0.3f
Rvs5_3 vs5_3 vs5_4 0.3
Cvs5_3 vs5_3 0 0.3f
Rvs5_4 vs5_4 vs5_5 0.3
Cvs5_4 vs5_4 0 0.3f
Rvs5_5 vs5_5 vs5_6 0.3
Cvs5_5 vs5_5 0 0.3f
Rvs5_6 vs5_6 vs5_7 0.3
Cvs5_6 vs5_6 0 0.3f
Rvs5_7 vs5_7 vs5_8 0.3
Cvs5_7 vs5_7 0 0.3f
Rvs5_8 vs5_8 vs5_9 0.3
Cvs5_8 vs5_8 0 0.3f
Rvs5_9 vs5_9 vs5_10 0.3
Cvs5_9 vs5_9 0 0.3f
Rvs5_10 vs5_10 vs5_11 0.3
Cvs5_10 vs5_10 0 0.3f
Rvs5_11 vs5_11 vs5_12 0.3
Cvs5_11 vs5_11 0 0.3f
Rvs5_12 vs5_12 vs5_13 0.3
Cvs5_12 vs5_12 0 0.3f
Rvs5_13 vs5_13 vs5_14 0.3
Cvs5_13 vs5_13 0 0.3f
Rvs5_14 vs5_14 vs5_15 0.3
Cvs5_14 vs5_14 0 0.3f
Rvs5_15 vs5_15 vs5_16 0.3
Cvs5_15 vs5_15 0 0.3f
Rvs5_16 vs5_16 vs5_17 0.3
Cvs5_16 vs5_16 0 0.3f
Rvs5_17 vs5_17 vs5_18 0.3
Cvs5_17 vs5_17 0 0.3f
Rvs5_18 vs5_18 vs5_19 0.3
Cvs5_18 vs5_18 0 0.3f
Rvs5_19 vs5_19 vs5_20 0.3
Cvs5_19 vs5_19 0 0.3f
Rvs5_20 vs5_20 vs5_21 0.3
Cvs5_20 vs5_20 0 0.3f
Rvs5_21 vs5_21 vs5_22 0.3
Cvs5_21 vs5_21 0 0.3f
Rvs5_22 vs5_22 vs5_23 0.3
Cvs5_22 vs5_22 0 0.3f
Rvs5_23 vs5_23 vs5_24 0.3
Cvs5_23 vs5_23 0 0.3f
Rvs5_24 vs5_24 vs5_25 0.3
Cvs5_24 vs5_24 0 0.3f
Rvs5_25 vs5_25 vs5_26 0.3
Cvs5_25 vs5_25 0 0.3f
Rvs5_26 vs5_26 vs5_27 0.3
Cvs5_26 vs5_26 0 0.3f
Rvs5_27 vs5_27 vs5_28 0.3
Cvs5_27 vs5_27 0 0.3f
Rvs5_28 vs5_28 vs5_29 0.3
Cvs5_28 vs5_28 0 0.3f
Rvs5_29 vs5_29 vs5_30 0.3
Cvs5_29 vs5_29 0 0.3f
Rvs5_30 vs5_30 vs5_31 0.3
Cvs5_30 vs5_30 0 0.3f
Rvs5_31 vs5_31 vs5_32 0.3
Cvs5_31 vs5_31 0 0.3f
Rvss5_0 vs5_0 vs6_0 0.2
Rvss5_16 vs5_16 vs6_16 0.2
Rvss5_32 vs5_32 vs6_32 0.2
Rvs6_0 vs6_0 vs6_1 0.3
Cvs6_0 vs6_0 0 0.3f
Rvs6_1 vs6_1 vs6_2 0.3
Cvs6_1 vs6_1 0 0.3f
Rvs6_2 vs6_2 vs6_3 0.3
Cvs6_2 vs6_2 0 0.3f
Rvs6_3 vs6_3 vs6_4 0.3
Cvs6_3 vs6_3 0 0.3f
Rvs6_4 vs6_4 vs6_5 0.3
Cvs6_4 vs6_4 0 0.3f
Rvs6_5 vs6_5 vs6_6 0.3
Cvs6_5 vs6_5 0 0.3f
Rvs6_6 vs6_6 vs6_7 0.3
Cvs6_6 vs6_6 0 0.3f
Rvs6_7 vs6_7 vs6_8 0.3
Cvs6_7 vs6_7 0 0.3f
Rvs6_8 vs6_8 vs6_9 0.3
Cvs6_8 vs6_8 0 0.3f
Rvs6_9 vs6_9 vs6_10 0.3
Cvs6_9 vs6_9 0 0.3f
Rvs6_10 vs6_10 vs6_11 0.3
Cvs6_10 vs6_10 0 0.3f
Rvs6_11 vs6_11 vs6_12 0.3
Cvs6_11 vs6_11 0 0.3f
Rvs6_12 vs6_12 vs6_13 0.3
Cvs6_12 vs6_12 0 0.3f
Rvs6_13 vs6_13 vs6_14 0.3
Cvs6_13 vs6_13 0 0.3f
Rvs6_14 vs6_14 vs6_15 0.3
Cvs6_14 vs6_14 0 0.3f
Rvs6_15 vs6_15 vs6_16 0.3
Cvs6_15 vs6_15 0 0.3f
Rvs6_16 vs6_16 vs6_17 0.3
Cvs6_16 vs6_16 0 0.3f
Rvs6_17 vs6_17 vs6_18 0.3
Cvs6_17 vs6_17 0 0.3f
Rvs6_18 vs6_18 vs6_19 0.3
Cvs6_18 vs6_18 0 0.3f
Rvs6_19 vs6_19 vs6_20 0.3
Cvs6_19 vs6_19 0 0.3f
Rvs6_20 vs6_20 vs6_21 0.3
Cvs6_20 vs6_20 0 0.3f
Rvs6_21 vs6_21 vs6_22 0.3
Cvs6_21 vs6_21 0 0.3f
Rvs6_22 vs6_22 vs6_23 0.3
Cvs6_22 vs6_22 0 0.3f
Rvs6_23 vs6_23 vs6_24 0.3
Cvs6_23 vs6_23 0 0.3f
Rvs6_24 vs6_24 vs6_25 0.3
Cvs6_24 vs6_24 0 0.3f
Rvs6_25 vs6_25 vs6_26 0.3
Cvs6_25 vs6_25 0 0.3f
Rvs6_26 vs6_26 vs6_27 0.3
Cvs6_26 vs6_26 0 0.3f
Rvs6_27 vs6_27 vs6_28 0.3
Cvs6_27 vs6_27 0 0.3f
Rvs6_28 vs6_28 vs6_29 0.3
Cvs6_28 vs6_28 0 0.3f
Rvs6_29 vs6_29 vs6_30 0.3
Cvs6_29 vs6_29 0 0.3f
Rvs6_30 vs6_30 vs6_31 0.3
Cvs6_30 vs6_30 0 0.3f
Rvs6_31 vs6_31 vs6_32 0.3
Cvs6_31 vs6_31 0 0.3f
Rvss6_0 vs6_0 vs7_0 0.2
Rvss6_16 vs6_16 vs7_16 0.2
Rvss6_32 vs6_32 vs7_32 0.2
Rvs7_0 vs7_0 vs7_1 0.3
Cvs7_0 vs7_0 0 0.3f
Rvs7_1 vs7_1 vs7_2 0.3
Cvs7_1 vs7_1 0 0.3f
Rvs7_2 vs7_2 vs7_3 0.3
Cvs7_2 vs7_2 0 0.3f
Rvs7_3 vs7_3 vs7_4 0.3
Cvs7_3 vs7_3 0 0.3f
Rvs7_4 vs7_4 vs7_5 0.3
Cvs7_4 vs7_4 0 0.3f
Rvs7_5 vs7_5 vs7_6 0.3
Cvs7_5 vs7_5 0 0.3f
Rvs7_6 vs7_6 vs7_7 0.3
Cvs7_6 vs7_6 0 0.3f
Rvs7_7 vs7_7 vs7_8 0.3
Cvs7_7 vs7_7 0 0.3f
Rvs7_8 vs7_8 vs7_9 0.3
Cvs7_8 vs7_8 0 0.3f
Rvs7_9 vs7_9 vs7_10 0.3
Cvs7_9 vs7_9 0 0.3f
Rvs7_10 vs7_10 vs7_11 0.3
Cvs7_10 vs7_10 0 0.3f
Rvs7_11 vs7_11 vs7_12 0.3
Cvs7_11 vs7_11 0 0.3f
Rvs7_12 vs7_12 vs7_13 0.3
Cvs7_12 vs7_12 0 0.3f
Rvs7_13 vs7_13 vs7_14 0.3
Cvs7_13 vs7_13 0 0.3f
Rvs7_14 vs7_14 vs7_15 0.3
Cvs7_14 vs7_14 0 0.3f
Rvs7_15 vs7_15 vs7_16 0.3
Cvs7_15 vs7_15 0 0.3f
Rvs7_16 vs7_16 vs7_17 0.3
Cvs7_16 vs7_16 0 0.3f
Rvs7_17 vs7_17 vs7_18 0.3
Cvs7_17 vs7_17 0 0.3f
Rvs7_18 vs7_18 vs7_19 0.3
Cvs7_18 vs7_18 0 0.3f
Rvs7_19 vs7_19 vs7_20 0.3
Cvs7_19 vs7_19 0 0.3f
Rvs7_20 vs7_20 vs7_21 0.3
Cvs7_20 vs7_20 0 0.3f
Rvs7_21 vs7_21 vs7_22 0.3
Cvs7_21 vs7_21 0 0.3f
Rvs7_22 vs7_22 vs7_23 0.3
Cvs7_22 vs7_22 0 0.3f
Rvs7_23 vs7_23 vs7_24 0.3
Cvs7_23 vs7_23 0 0.3f
Rvs7_24 vs7_24 vs7_25 0.3
Cvs7_24 vs7_24 0 0.3f
Rvs7_25 vs7_25 vs7_26 0.3
Cvs7_25 vs7_25 0 0.3f
Rvs7_26 vs7_26 vs7_27 0.3
Cvs7_26 vs7_26 0 0.3f
Rvs7_27 vs7_27 vs7_28 0.3
Cvs7_27 vs7_27 0 0.3f
Rvs7_28 vs7_28 vs7_29 0.3
Cvs7_28 vs7_28 0 0.3f
Rvs7_29 vs7_29 vs7_30 0.3
Cvs7_29 vs7_29 0 0.3f
Rvs7_30 vs7_30 vs7_31 0.3
Cvs7_30 vs7_30 0 0.3f
Rvs7_31 vs7_31 vs7_32 0.3
Cvs7_31 vs7_31 0 0.3f
Rvss7_0 vs7_0 vs8_0 0.2
Rvss7_16 vs7_16 vs8_16 0.2
Rvss7_32 vs7_32 vs8_32 0.2
Rvs8_0 vs8_0 vs8_1 0.3
Cvs8_0 vs8_0 0 0.3f
Rvs8_1 vs8_1 vs8_2 0.3
Cvs8_1 vs8_1 0 0.3f
Rvs8_2 vs8_2 vs8_3 0.3
Cvs8_2 vs8_2 0 0.3f
Rvs8_3 vs8_3 vs8_4 0.3
Cvs8_3 vs8_3 0 0.3f
Rvs8_4 vs8_4 vs8_5 0.3
Cvs8_4 vs8_4 0 0.3f
Rvs8_5 vs8_5 vs8_6 0.3
Cvs8_5 vs8_5 0 0.3f
Rvs8_6 vs8_6 vs8_7 0.3
Cvs8_6 vs8_6 0 0.3f
Rvs8_7 vs8_7 vs8_8 0.3
Cvs8_7 vs8_7 0 0.3f
Rvs8_8 vs8_8 vs8_9 0.3
Cvs8_8 vs8_8 0 0.3f
Rvs8_9 vs8_9 vs8_10 0.3
Cvs8_9 vs8_9 0 0.3f
Rvs8_10 vs8_10 vs8_11 0.3
Cvs8_10 vs8_10 0 0.3f
Rvs8_11 vs8_11 vs8_12 0.3
Cvs8_11 vs8_11 0 0.3f
Rvs8_12 vs8_12 vs8_13 0.3
Cvs8_12 vs8_12 0 0.3f
Rvs8_13 vs8_13 vs8_14 0.3
Cvs8_13 vs8_13 0 0.3f
Rvs8_14 vs8_14 vs8_15 0.3
Cvs8_14 vs8_14 0 0.3f
Rvs8_15 vs8_15 vs8_16 0.3
Cvs8_15 vs8_15 0 0.3f
Rvs8_16 vs8_16 vs8_17 0.3
Cvs8_16 vs8_16 0 0.3f
Rvs8_17 vs8_17 vs8_18 0.3
Cvs8_17 vs8_17 0 0.3f
Rvs8_18 vs8_18 vs8_19 0.3
Cvs8_18 vs8_18 0 0.3f
Rvs8_19 vs8_19 vs8_20 0.3
Cvs8_19 vs8_19 0 0.3f
Rvs8_20 vs8_20 vs8_21 0.3
Cvs8_20 vs8_20 0 0.3f
Rvs8_21 vs8_21 vs8_22 0.3
Cvs8_21 vs8_21 0 0.3f
Rvs8_22 vs8_22 vs8_23 0.3
Cvs8_22 vs8_22 0 0.3f
Rvs8_23 vs8_23 vs8_24 0.3
Cvs8_23 vs8_23 0 0.3f
Rvs8_24 vs8_24 vs8_25 0.3
Cvs8_24 vs8_24 0 0.3f
Rvs8_25 vs8_25 vs8_26 0.3
Cvs8_25 vs8_25 0 0.3f
Rvs8_26 vs8_26 vs8_27 0.3
Cvs8_26 vs8_26 0 0.3f
Rvs8_27 vs8_27 vs8_28 0.3
Cvs8_27 vs8_27 0 0.3f
Rvs8_28 vs8_28 vs8_29 0.3
Cvs8_28 vs8_28 0 0.3f
Rvs8_29 vs8_29 vs8_30 0.3
Cvs8_29 vs8_29 0 0.3f
Rvs8_30 vs8_30 vs8_31 0.3
Cvs8_30 vs8_30 0 0.3f
Rvs8_31 vs8_31 vs8_32 0.3
Cvs8_31 vs8_31 0 0.3f
Rvss8_0 vs8_0 vs9_0 0.2
Rvss8_16 vs8_16 vs9_16 0.2
Rvss8_32 vs8_32 vs9_32 0.2
Rvs9_0 vs9_0 vs9_1 0.3
Cvs9_0 vs9_0 0 0.3f
Rvs9_1 vs9_1 vs9_2 0.3
Cvs9_1 vs9_1 0 0.3f
Rvs9_2 vs9_2 vs9_3 0.3
Cvs9_2 vs9_2 0 0.3f
Rvs9_3 vs9_3 vs9_4 0.3
Cvs9_3 vs9_3 0 0.3f
Rvs9_4 vs9_4 vs9_5 0.3
Cvs9_4 vs9_4 0 0.3f
Rvs9_5 vs9_5 vs9_6 0.3
Cvs9_5 vs9_5 0 0.3f
Rvs9_6 vs9_6 vs9_7 0.3
Cvs9_6 vs9_6 0 0.3f
Rvs9_7 vs9_7 vs9_8 0.3
Cvs9_7 vs9_7 0 0.3f
Rvs9_8 vs9_8 vs9_9 0.3
Cvs9_8 vs9_8 0 0.3f
Rvs9_9 vs9_9 vs9_10 0.3
Cvs9_9 vs9_9 0 0.3f
Rvs9_10 vs9_10 vs9_11 0.3
Cvs9_10 vs9_10 0 0.3f
Rvs9_11 vs9_11 vs9_12 0.3
Cvs9_11 vs9_11 0 0.3f
Rvs9_12 vs9_12 vs9_13 0.3
Cvs9_12 vs9_12 0 0.3f
Rvs9_13 vs9_13 vs9_14 0.3
Cvs9_13 vs9_13 0 0.3f
Rvs9_14 vs9_14 vs9_15 0.3
Cvs9_14 vs9_14 0 0.3f
Rvs9_15 vs9_15 vs9_16 0.3
Cvs9_15 vs9_15 0 0.3f
Rvs9_16 vs9_16 vs9_17 0.3
Cvs9_16 vs9_16 0 0.3f
Rvs9_17 vs9_17 vs9_18 0.3
Cvs9_17 vs9_17 0 0.3f
Rvs9_18 vs9_18 vs9_19 0.3
Cvs9_18 vs9_18 0 0.3f
Rvs9_19 vs9_19 vs9_20 0.3
Cvs9_19 vs9_19 0 0.3f
Rvs9_20 vs9_20 vs9_21 0.3
Cvs9_20 vs9_20 0 0.3f
Rvs9_21 vs9_21 vs9_22 0.3
Cvs9_21 vs9_21 0 0.3f
Rvs9_22 vs9_22 vs9_23 0.3
Cvs9_22 vs9_22 0 0.3f
Rvs9_23 vs9_23 vs9_24 0.3
Cvs9_23 vs9_23 0 0.3f
Rvs9_24 vs9_24 vs9_25 0.3
Cvs9_24 vs9_24 0 0.3f
Rvs9_25 vs9_25 vs9_26 0.3
Cvs9_25 vs9_25 0 0.3f
Rvs9_26 vs9_26 vs9_27 0.3
Cvs9_26 vs9_26 0 0.3f
Rvs9_27 vs9_27 vs9_28 0.3
Cvs9_27 vs9_27 0 0.3f
Rvs9_28 vs9_28 vs9_29 0.3
Cvs9_28 vs9_28 0 0.3f
Rvs9_29 vs9_29 vs9_30 0.3
Cvs9_29 vs9_29 0 0.3f
Rvs9_30 vs9_30 vs9_31 0.3
Cvs9_30 vs9_30 0 0.3f
Rvs9_31 vs9_31 vs9_32 0.3
Cvs9_31 vs9_31 0 0.3f
Rvss9_0 vs9_0 vs10_0 0.2
Rvss9_16 vs9_16 vs10_16 0.2
Rvss9_32 vs9_32 vs10_32 0.2
Rvs10_0 vs10_0 vs10_1 0.3
Cvs10_0 vs10_0 0 0.3f
Rvs10_1 vs10_1 vs10_2 0.3
Cvs10_1 vs10_1 0 0.3f
Rvs10_2 vs10_2 vs10_3 0.3
Cvs10_2 vs10_2 0 0.3f
Rvs10_3 vs10_3 vs10_4 0.3
Cvs10_3 vs10_3 0 0.3f
Rvs10_4 vs10_4 vs10_5 0.3
Cvs10_4 vs10_4 0 0.3f
Rvs10_5 vs10_5 vs10_6 0.3
Cvs10_5 vs10_5 0 0.3f
Rvs10_6 vs10_6 vs10_7 0.3
Cvs10_6 vs10_6 0 0.3f
Rvs10_7 vs10_7 vs10_8 0.3
Cvs10_7 vs10_7 0 0.3f
Rvs10_8 vs10_8 vs10_9 0.3
Cvs10_8 vs10_8 0 0.3f
Rvs10_9 vs10_9 vs10_10 0.3
Cvs10_9 vs10_9 0 0.3f
Rvs10_10 vs10_10 vs10_11 0.3
Cvs10_10 vs10_10 0 0.3f
Rvs10_11 vs10_11 vs10_12 0.3
Cvs10_11 vs10_11 0 0.3f
Rvs10_12 vs10_12 vs10_13 0.3
Cvs10_12 vs10_12 0 0.3f
Rvs10_13 vs10_13 vs10_14 0.3
Cvs10_13 vs10_13 0 0.3f
Rvs10_14 vs10_14 vs10_15 0.3
Cvs10_14 vs10_14 0 0.3f
Rvs10_15 vs10_15 vs10_16 0.3
Cvs10_15 vs10_15 0 0.3f
Rvs10_16 vs10_16 vs10_17 0.3
Cvs10_16 vs10_16 0 0.3f
Rvs10_17 vs10_17 vs10_18 0.3
Cvs10_17 vs10_17 0 0.3f
Rvs10_18 vs10_18 vs10_19 0.3
Cvs10_18 vs10_18 0 0.3f
Rvs10_19 vs10_19 vs10_20 0.3
Cvs10_19 vs10_19 0 0.3f
Rvs10_20 vs10_20 vs10_21 0.3
Cvs10_20 vs10_20 0 0.3f
Rvs10_21 vs10_21 vs10_22 0.3
Cvs10_21 vs10_21 0 0.3f
Rvs10_22 vs10_22 vs10_23 0.3
Cvs10_22 vs10_22 0 0.3f
Rvs10_23 vs10_23 vs10_24 0.3
Cvs10_23 vs10_23 0 0.3f
Rvs10_24 vs10_24 vs10_25 0.3
Cvs10_24 vs10_24 0 0.3f
Rvs10_25 vs10_25 vs10_26 0.3
Cvs10_25 vs10_25 0 0.3f
Rvs10_26 vs10_26 vs10_27 0.3
Cvs10_26 vs10_26 0 0.3f
Rvs10_27 vs10_27 vs10_28 0.3
Cvs10_27 vs10_27 0 0.3f
Rvs10_28 vs10_28 vs10_29 0.3
Cvs10_28 vs10_28 0 0.3f
Rvs10_29 vs10_29 vs10_30 0.3
Cvs10_29 vs10_29 0 0.3f
Rvs10_30 vs10_30 vs10_31 0.3
Cvs10_30 vs10_30 0 0.3f
Rvs10_31 vs10_31 vs10_32 0.3
Cvs10_31 vs10_31 0 0.3f
Rvss10_0 vs10_0 vs11_0 0.2
Rvss10_16 vs10_16 vs11_16 0.2
Rvss10_32 vs10_32 vs11_32 0.2
Rvs11_0 vs11_0 vs11_1 0.3
Cvs11_0 vs11_0 0 0.3f
Rvs11_1 vs11_1 vs11_2 0.3
Cvs11_1 vs11_1 0 0.3f
Rvs11_2 vs11_2 vs11_3 0.3
Cvs11_2 vs11_2 0 0.3f
Rvs11_3 vs11_3 vs11_4 0.3
Cvs11_3 vs11_3 0 0.3f
Rvs11_4 vs11_4 vs11_5 0.3
Cvs11_4 vs11_4 0 0.3f
Rvs11_5 vs11_5 vs11_6 0.3
Cvs11_5 vs11_5 0 0.3f
Rvs11_6 vs11_6 vs11_7 0.3
Cvs11_6 vs11_6 0 0.3f
Rvs11_7 vs11_7 vs11_8 0.3
Cvs11_7 vs11_7 0 0.3f
Rvs11_8 vs11_8 vs11_9 0.3
Cvs11_8 vs11_8 0 0.3f
Rvs11_9 vs11_9 vs11_10 0.3
Cvs11_9 vs11_9 0 0.3f
Rvs11_10 vs11_10 vs11_11 0.3
Cvs11_10 vs11_10 0 0.3f
Rvs11_11 vs11_11 vs11_12 0.3
Cvs11_11 vs11_11 0 0.3f
Rvs11_12 vs11_12 vs11_13 0.3
Cvs11_12 vs11_12 0 0.3f
Rvs11_13 vs11_13 vs11_14 0.3
Cvs11_13 vs11_13 0 0.3f
Rvs11_14 vs11_14 vs11_15 0.3
Cvs11_14 vs11_14 0 0.3f
Rvs11_15 vs11_15 vs11_16 0.3
Cvs11_15 vs11_15 0 0.3f
Rvs11_16 vs11_16 vs11_17 0.3
Cvs11_16 vs11_16 0 0.3f
Rvs11_17 vs11_17 vs11_18 0.3
Cvs11_17 vs11_17 0 0.3f
Rvs11_18 vs11_18 vs11_19 0.3
Cvs11_18 vs11_18 0 0.3f
Rvs11_19 vs11_19 vs11_20 0.3
Cvs11_19 vs11_19 0 0.3f
Rvs11_20 vs11_20 vs11_21 0.3
Cvs11_20 vs11_20 0 0.3f
Rvs11_21 vs11_21 vs11_22 0.3
Cvs11_21 vs11_21 0 0.3f
Rvs11_22 vs11_22 vs11_23 0.3
Cvs11_22 vs11_22 0 0.3f
Rvs11_23 vs11_23 vs11_24 0.3
Cvs11_23 vs11_23 0 0.3f
Rvs11_24 vs11_24 vs11_25 0.3
Cvs11_24 vs11_24 0 0.3f
Rvs11_25 vs11_25 vs11_26 0.3
Cvs11_25 vs11_25 0 0.3f
Rvs11_26 vs11_26 vs11_27 0.3
Cvs11_26 vs11_26 0 0.3f
Rvs11_27 vs11_27 vs11_28 0.3
Cvs11_27 vs11_27 0 0.3f
Rvs11_28 vs11_28 vs11_29 0.3
Cvs11_28 vs11_28 0 0.3f
Rvs11_29 vs11_29 vs11_30 0.3
Cvs11_29 vs11_29 0 0.3f
Rvs11_30 vs11_30 vs11_31 0.3
Cvs11_30 vs11_30 0 0.3f
Rvs11_31 vs11_31 vs11_32 0.3
Cvs11_31 vs11_31 0 0.3f
Rvss11_0 vs11_0 vs12_0 0.2
Rvss11_16 vs11_16 vs12_16 0.2
Rvss11_32 vs11_32 vs12_32 0.2
Rvs12_0 vs12_0 vs12_1 0.3
Cvs12_0 vs12_0 0 0.3f
Rvs12_1 vs12_1 vs12_2 0.3
Cvs12_1 vs12_1 0 0.3f
Rvs12_2 vs12_2 vs12_3 0.3
Cvs12_2 vs12_2 0 0.3f
Rvs12_3 vs12_3 vs12_4 0.3
Cvs12_3 vs12_3 0 0.3f
Rvs12_4 vs12_4 vs12_5 0.3
Cvs12_4 vs12_4 0 0.3f
Rvs12_5 vs12_5 vs12_6 0.3
Cvs12_5 vs12_5 0 0.3f
Rvs12_6 vs12_6 vs12_7 0.3
Cvs12_6 vs12_6 0 0.3f
Rvs12_7 vs12_7 vs12_8 0.3
Cvs12_7 vs12_7 0 0.3f
Rvs12_8 vs12_8 vs12_9 0.3
Cvs12_8 vs12_8 0 0.3f
Rvs12_9 vs12_9 vs12_10 0.3
Cvs12_9 vs12_9 0 0.3f
Rvs12_10 vs12_10 vs12_11 0.3
Cvs12_10 vs12_10 0 0.3f
Rvs12_11 vs12_11 vs12_12 0.3
Cvs12_11 vs12_11 0 0.3f
Rvs12_12 vs12_12 vs12_13 0.3
Cvs12_12 vs12_12 0 0.3f
Rvs12_13 vs12_13 vs12_14 0.3
Cvs12_13 vs12_13 0 0.3f
Rvs12_14 vs12_14 vs12_15 0.3
Cvs12_14 vs12_14 0 0.3f
Rvs12_15 vs12_15 vs12_16 0.3
Cvs12_15 vs12_15 0 0.3f
Rvs12_16 vs12_16 vs12_17 0.3
Cvs12_16 vs12_16 0 0.3f
Rvs12_17 vs12_17 vs12_18 0.3
Cvs12_17 vs12_17 0 0.3f
Rvs12_18 vs12_18 vs12_19 0.3
Cvs12_18 vs12_18 0 0.3f
Rvs12_19 vs12_19 vs12_20 0.3
Cvs12_19 vs12_19 0 0.3f
Rvs12_20 vs12_20 vs12_21 0.3
Cvs12_20 vs12_20 0 0.3f
Rvs12_21 vs12_21 vs12_22 0.3
Cvs12_21 vs12_21 0 0.3f
Rvs12_22 vs12_22 vs12_23 0.3
Cvs12_22 vs12_22 0 0.3f
Rvs12_23 vs12_23 vs12_24 0.3
Cvs12_23 vs12_23 0 0.3f
Rvs12_24 vs12_24 vs12_25 0.3
Cvs12_24 vs12_24 0 0.3f
Rvs12_25 vs12_25 vs12_26 0.3
Cvs12_25 vs12_25 0 0.3f
Rvs12_26 vs12_26 vs12_27 0.3
Cvs12_26 vs12_26 0 0.3f
Rvs12_27 vs12_27 vs12_28 0.3
Cvs12_27 vs12_27 0 0.3f
Rvs12_28 vs12_28 vs12_29 0.3
Cvs12_28 vs12_28 0 0.3f
Rvs12_29 vs12_29 vs12_30 0.3
Cvs12_29 vs12_29 0 0.3f
Rvs12_30 vs12_30 vs12_31 0.3
Cvs12_30 vs12_30 0 0.3f
Rvs12_31 vs12_31 vs12_32 0.3
Cvs12_31 vs12_31 0 0.3f
Rvss12_0 vs12_0 vs13_0 0.2
Rvss12_16 vs12_16 vs13_16 0.2
Rvss12_32 vs12_32 vs13_32 0.2
Rvs13_0 vs13_0 vs13_1 0.3
Cvs13_0 vs13_0 0 0.3f
Rvs13_1 vs13_1 vs13_2 0.3
Cvs13_1 vs13_1 0 0.3f
Rvs13_2 vs13_2 vs13_3 0.3
Cvs13_2 vs13_2 0 0.3f
Rvs13_3 vs13_3 vs13_4 0.3
Cvs13_3 vs13_3 0 0.3f
Rvs13_4 vs13_4 vs13_5 0.3
Cvs13_4 vs13_4 0 0.3f
Rvs13_5 vs13_5 vs13_6 0.3
Cvs13_5 vs13_5 0 0.3f
Rvs13_6 vs13_6 vs13_7 0.3
Cvs13_6 vs13_6 0 0.3f
Rvs13_7 vs13_7 vs13_8 0.3
Cvs13_7 vs13_7 0 0.3f
Rvs13_8 vs13_8 vs13_9 0.3
Cvs13_8 vs13_8 0 0.3f
Rvs13_9 vs13_9 vs13_10 0.3
Cvs13_9 vs13_9 0 0.3f
Rvs13_10 vs13_10 vs13_11 0.3
Cvs13_10 vs13_10 0 0.3f
Rvs13_11 vs13_11 vs13_12 0.3
Cvs13_11 vs13_11 0 0.3f
Rvs13_12 vs13_12 vs13_13 0.3
Cvs13_12 vs13_12 0 0.3f
Rvs13_13 vs13_13 vs13_14 0.3
Cvs13_13 vs13_13 0 0.3f
Rvs13_14 vs13_14 vs13_15 0.3
Cvs13_14 vs13_14 0 0.3f
Rvs13_15 vs13_15 vs13_16 0.3
Cvs13_15 vs13_15 0 0.3f
Rvs13_16 vs13_16 vs13_17 0.3
Cvs13_16 vs13_16 0 0.3f
Rvs13_17 vs13_17 vs13_18 0.3
Cvs13_17 vs13_17 0 0.3f
Rvs13_18 vs13_18 vs13_19 0.3
Cvs13_18 vs13_18 0 0.3f
Rvs13_19 vs13_19 vs13_20 0.3
Cvs13_19 vs13_19 0 0.3f
Rvs13_20 vs13_20 vs13_21 0.3
Cvs13_20 vs13_20 0 0.3f
Rvs13_21 vs13_21 vs13_22 0.3
Cvs13_21 vs13_21 0 0.3f
Rvs13_22 vs13_22 vs13_23 0.3
Cvs13_22 vs13_22 0 0.3f
Rvs13_23 vs13_23 vs13_24 0.3
Cvs13_23 vs13_23 0 0.3f
Rvs13_24 vs13_24 vs13_25 0.3
Cvs13_24 vs13_24 0 0.3f
Rvs13_25 vs13_25 vs13_26 0.3
Cvs13_25 vs13_25 0 0.3f
Rvs13_26 vs13_26 vs13_27 0.3
Cvs13_26 vs13_26 0 0.3f
Rvs13_27 vs13_27 vs13_28 0.3
Cvs13_27 vs13_27 0 0.3f
Rvs13_28 vs13_28 vs13_29 0.3
Cvs13_28 vs13_28 0 0.3f
Rvs13_29 vs13_29 vs13_30 0.3
Cvs13_29 vs13_29 0 0.3f
Rvs13_30 vs13_30 vs13_31 0.3
Cvs13_30 vs13_30 0 0.3f
Rvs13_31 vs13_31 vs13_32 0.3
Cvs13_31 vs13_31 0 0.3f
Rvss13_0 vs13_0 vs14_0 0.2
Rvss13_16 vs13_16 vs14_16 0.2
Rvss13_32 vs13_32 vs14_32 0.2
Rvs14_0 vs14_0 vs14_1 0.3
Cvs14_0 vs14_0 0 0.3f
Rvs14_1 vs14_1 vs14_2 0.3
Cvs14_1 vs14_1 0 0.3f
Rvs14_2 vs14_2 vs14_3 0.3
Cvs14_2 vs14_2 0 0.3f
Rvs14_3 vs14_3 vs14_4 0.3
Cvs14_3 vs14_3 0 0.3f
Rvs14_4 vs14_4 vs14_5 0.3
Cvs14_4 vs14_4 0 0.3f
Rvs14_5 vs14_5 vs14_6 0.3
Cvs14_5 vs14_5 0 0.3f
Rvs14_6 vs14_6 vs14_7 0.3
Cvs14_6 vs14_6 0 0.3f
Rvs14_7 vs14_7 vs14_8 0.3
Cvs14_7 vs14_7 0 0.3f
Rvs14_8 vs14_8 vs14_9 0.3
Cvs14_8 vs14_8 0 0.3f
Rvs14_9 vs14_9 vs14_10 0.3
Cvs14_9 vs14_9 0 0.3f
Rvs14_10 vs14_10 vs14_11 0.3
Cvs14_10 vs14_10 0 0.3f
Rvs14_11 vs14_11 vs14_12 0.3
Cvs14_11 vs14_11 0 0.3f
Rvs14_12 vs14_12 vs14_13 0.3
Cvs14_12 vs14_12 0 0.3f
Rvs14_13 vs14_13 vs14_14 0.3
Cvs14_13 vs14_13 0 0.3f
Rvs14_14 vs14_14 vs14_15 0.3
Cvs14_14 vs14_14 0 0.3f
Rvs14_15 vs14_15 vs14_16 0.3
Cvs14_15 vs14_15 0 0.3f
Rvs14_16 vs14_16 vs14_17 0.3
Cvs14_16 vs14_16 0 0.3f
Rvs14_17 vs14_17 vs14_18 0.3
Cvs14_17 vs14_17 0 0.3f
Rvs14_18 vs14_18 vs14_19 0.3
Cvs14_18 vs14_18 0 0.3f
Rvs14_19 vs14_19 vs14_20 0.3
Cvs14_19 vs14_19 0 0.3f
Rvs14_20 vs14_20 vs14_21 0.3
Cvs14_20 vs14_20 0 0.3f
Rvs14_21 vs14_21 vs14_22 0.3
Cvs14_21 vs14_21 0 0.3f
Rvs14_22 vs14_22 vs14_23 0.3
Cvs14_22 vs14_22 0 0.3f
Rvs14_23 vs14_23 vs14_24 0.3
Cvs14_23 vs14_23 0 0.3f
Rvs14_24 vs14_24 vs14_25 0.3
Cvs14_24 vs14_24 0 0.3f
Rvs14_25 vs14_25 vs14_26 0.3
Cvs14_25 vs14_25 0 0.3f
Rvs14_26 vs14_26 vs14_27 0.3
Cvs14_26 vs14_26 0 0.3f
Rvs14_27 vs14_27 vs14_28 0.3
Cvs14_27 vs14_27 0 0.3f
Rvs14_28 vs14_28 vs14_29 0.3
Cvs14_28 vs14_28 0 0.3f
Rvs14_29 vs14_29 vs14_30 0.3
Cvs14_29 vs14_29 0 0.3f
Rvs14_30 vs14_30 vs14_31 0.3
Cvs14_30 vs14_30 0 0.3f
Rvs14_31 vs14_31 vs14_32 0.3
Cvs14_31 vs14_31 0 0.3f
Rvss14_0 vs14_0 vs15_0 0.2
Rvss14_16 vs14_16 vs15_16 0.2
Rvss14_32 vs14_32 vs15_32 0.2
Rvs15_0 vs15_0 vs15_1 0.3
Cvs15_0 vs15_0 0 0.3f
Rvs15_1 vs15_1 vs15_2 0.3
Cvs15_1 vs15_1 0 0.3f
Rvs15_2 vs15_2 vs15_3 0.3
Cvs15_2 vs15_2 0 0.3f
Rvs15_3 vs15_3 vs15_4 0.3
Cvs15_3 vs15_3 0 0.3f
Rvs15_4 vs15_4 vs15_5 0.3
Cvs15_4 vs15_4 0 0.3f
Rvs15_5 vs15_5 vs15_6 0.3
Cvs15_5 vs15_5 0 0.3f
Rvs15_6 vs15_6 vs15_7 0.3
Cvs15_6 vs15_6 0 0.3f
Rvs15_7 vs15_7 vs15_8 0.3
Cvs15_7 vs15_7 0 0.3f
Rvs15_8 vs15_8 vs15_9 0.3
Cvs15_8 vs15_8 0 0.3f
Rvs15_9 vs15_9 vs15_10 0.3
Cvs15_9 vs15_9 0 0.3f
Rvs15_10 vs15_10 vs15_11 0.3
Cvs15_10 vs15_10 0 0.3f
Rvs15_11 vs15_11 vs15_12 0.3
Cvs15_11 vs15_11 0 0.3f
Rvs15_12 vs15_12 vs15_13 0.3
Cvs15_12 vs15_12 0 0.3f
Rvs15_13 vs15_13 vs15_14 0.3
Cvs15_13 vs15_13 0 0.3f
Rvs15_14 vs15_14 vs15_15 0.3
Cvs15_14 vs15_14 0 0.3f
Rvs15_15 vs15_15 vs15_16 0.3
Cvs15_15 vs15_15 0 0.3f
Rvs15_16 vs15_16 vs15_17 0.3
Cvs15_16 vs15_16 0 0.3f
Rvs15_17 vs15_17 vs15_18 0.3
Cvs15_17 vs15_17 0 0.3f
Rvs15_18 vs15_18 vs15_19 0.3
Cvs15_18 vs15_18 0 0.3f
Rvs15_19 vs15_19 vs15_20 0.3
Cvs15_19 vs15_19 0 0.3f
Rvs15_20 vs15_20 vs15_21 0.3
Cvs15_20 vs15_20 0 0.3f
Rvs15_21 vs15_21 vs15_22 0.3
Cvs15_21 vs15_21 0 0.3f
Rvs15_22 vs15_22 vs15_23 0.3
Cvs15_22 vs15_22 0 0.3f
Rvs15_23 vs15_23 vs15_24 0.3
Cvs15_23 vs15_23 0 0.3f
Rvs15_24 vs15_24 vs15_25 0.3
Cvs15_24 vs15_24 0 0.3f
Rvs15_25 vs15_25 vs15_26 0.3
Cvs15_25 vs15_25 0 0.3f
Rvs15_26 vs15_26 vs15_27 0.3
Cvs15_26 vs15_26 0 0.3f
Rvs15_27 vs15_27 vs15_28 0.3
Cvs15_27 vs15_27 0 0.3f
Rvs15_28 vs15_28 vs15_29 0.3
Cvs15_28 vs15_28 0 0.3f
Rvs15_29 vs15_29 vs15_30 0.3
Cvs15_29 vs15_29 0 0.3f
Rvs15_30 vs15_30 vs15_31 0.3
Cvs15_30 vs15_30 0 0.3f
Rvs15_31 vs15_31 vs15_32 0.3
Cvs15_31 vs15_31 0 0.3f
Rvsp0 0 vs0_0 0.5
Rvsp32 0 vs0_32 0.5
Xc0s0 clk_2 c0s0_0 vd0_0 vs0_0 inv
Xc0s1 c0s0_6 c0s1_0 vd0_1 vs0_1 inv
Xc0s2 c0s1_6 c0s2_0 vd0_2 vs0_2 inv
Xc0s3 c0s2_6 c0s3_0 vd0_3 vs0_3 inv
Xc0s4 c0s3_6 c0s4_0 vd0_4 vs0_4 inv
Xc0s5 c0s4_6 c0s5_0 vd0_5 vs0_5 inv
Xc0s6 c0s5_6 c0s6_0 vd0_6 vs0_6 inv
Xc0s7 c0s6_6 c0s7_0 vd0_7 vs0_7 inv
Xc0s8 c0s7_6 c0s8_0 vd0_8 vs0_8 inv
Xc0s9 c0s8_6 c0s9_0 vd0_9 vs0_9 inv
Xc0s10 c0s9_6 c0s10_0 vd0_10 vs0_10 inv
Xc0s11 c0s10_6 c0s11_0 vd0_11 vs0_11 inv
Xc0s12 c0s11_6 c0s12_0 vd0_12 vs0_12 inv
Xc0s13 c0s12_6 c0s13_0 vd0_13 vs0_13 inv
Xc0s14 c0s13_6 c0s14_0 vd0_14 vs0_14 inv
Xc0s15 c0s14_6 c0s15_0 vd0_15 vs0_15 inv
Xc0s16 c0s15_6 c0s16_0 vd0_16 vs0_16 inv
Xc0s17 c0s16_6 c0s17_0 vd0_17 vs0_17 inv
Xc0s18 c0s17_6 c0s18_0 vd0_18 vs0_18 inv
Xc0s19 c0s18_6 c0s19_0 vd0_19 vs0_19 inv
Xc0s20 c0s19_6 c0s20_0 vd0_20 vs0_20 inv
Xc0s21 c0s20_6 c0s21_0 vd0_21 vs0_21 inv
Xc0s22 c0s21_6 c0s22_0 vd0_22 vs0_22 inv
Xc0s23 c0s22_6 c0s23_0 vd0_23 vs0_23 inv
Xc0s24 c0s23_6 c0s24_0 vd0_24 vs0_24 inv
Xc0s25 c0s24_6 c0s25_0 vd0_25 vs0_25 inv
Xc0s26 c0s25_6 c0s26_0 vd0_26 vs0_26 inv
Xc0s27 c0s26_6 c0s27_0 vd0_27 vs0_27 inv
Xc0s28 c0s27_6 c0s28_0 vd0_28 vs0_28 inv
Xc0s29 c0s28_6 c0s29_0 vd0_29 vs0_29 inv
Xc0s30 c0s29_6 c0s30_0 vd0_30 vs0_30 inv
Xc0s31 c0s30_6 c0s31_0 vd0_31 vs0_31 inv
Xc0s32 c0s31_6 c0s32_0 vd1_0 vs1_0 inv
Xc0s33 c0s32_6 c0s33_0 vd1_1 vs1_1 inv
Xc0s34 c0s33_6 c0s34_0 vd1_2 vs1_2 inv
Xc0s35 c0s34_6 c0s35_0 vd1_3 vs1_3 inv
Xc0s36 c0s35_6 c0s36_0 vd1_4 vs1_4 inv
Xc0s37 c0s36_6 c0s37_0 vd1_5 vs1_5 inv
Xc0s38 c0s37_6 c0s38_0 vd1_6 vs1_6 inv
Xc0s39 c0s38_6 c0s39_0 vd1_7 vs1_7 inv
Xc0s40 c0s39_6 c0s40_0 vd1_8 vs1_8 inv
Xc0s41 c0s40_6 c0s41_0 vd1_9 vs1_9 inv
Xc0s42 c0s41_6 c0s42_0 vd1_10 vs1_10 inv
Xc0s43 c0s42_6 c0s43_0 vd1_11 vs1_11 inv
Xc0s44 c0s43_6 c0s44_0 vd1_12 vs1_12 inv
Xc0s45 c0s44_6 c0s45_0 vd1_13 vs1_13 inv
Xc0s46 c0s45_6 c0s46_0 vd1_14 vs1_14 inv
Xc0s47 c0s46_6 c0s47_0 vd1_15 vs1_15 inv
Xc0s48 c0s47_6 c0s48_0 vd1_16 vs1_16 inv
Xc0s49 c0s48_6 c0s49_0 vd1_17 vs1_17 inv
Xc1s0 clk_4 c1s0_0 vd1_18 vs1_18 inv
Xc1s1 c1s0_6 c1s1_0 vd1_19 vs1_19 inv
Xc1s2 c1s1_6 c1s2_0 vd1_20 vs1_20 inv
Xc1s3 c1s2_6 c1s3_0 vd1_21 vs1_21 inv
Xc1s4 c1s3_6 c1s4_0 vd1_22 vs1_22 inv
Xc1s5 c1s4_6 c1s5_0 vd1_23 vs1_23 inv
Xc1s6 c1s5_6 c1s6_0 vd1_24 vs1_24 inv
Xc1s7 c1s6_6 c1s7_0 vd1_25 vs1_25 inv
Xc1s8 c1s7_6 c1s8_0 vd1_26 vs1_26 inv
Xc1s9 c1s8_6 c1s9_0 vd1_27 vs1_27 inv
Xc1s10 c1s9_6 c1s10_0 vd1_28 vs1_28 inv
Xc1s11 c1s10_6 c1s11_0 vd1_29 vs1_29 inv
Xc1s12 c1s11_6 c1s12_0 vd1_30 vs1_30 inv
Xc1s13 c1s12_6 c1s13_0 vd1_31 vs1_31 inv
Xc1s14 c1s13_6 c1s14_0 vd2_0 vs2_0 inv
Xc1s15 c1s14_6 c1s15_0 vd2_1 vs2_1 inv
Xc1s16 c1s15_6 c1s16_0 vd2_2 vs2_2 inv
Xc1s17 c1s16_6 c1s17_0 vd2_3 vs2_3 inv
Xc1s18 c1s17_6 c1s18_0 vd2_4 vs2_4 inv
Xc1s19 c1s18_6 c1s19_0 vd2_5 vs2_5 inv
Xc1s20 c1s19_6 c1s20_0 vd2_6 vs2_6 inv
Xc1s21 c1s20_6 c1s21_0 vd2_7 vs2_7 inv
Xc1s22 c1s21_6 c1s22_0 vd2_8 vs2_8 inv
Xc1s23 c1s22_6 c1s23_0 vd2_9 vs2_9 inv
Xc1s24 c1s23_6 c1s24_0 vd2_10 vs2_10 inv
Xc1s25 c1s24_6 c1s25_0 vd2_11 vs2_11 inv
Xc1s26 c1s25_6 c1s26_0 vd2_12 vs2_12 inv
Xc1s27 c1s26_6 c1s27_0 vd2_13 vs2_13 inv
Xc1s28 c1s27_6 c1s28_0 vd2_14 vs2_14 inv
Xc1s29 c1s28_6 c1s29_0 vd2_15 vs2_15 inv
Xc1s30 c1s29_6 c1s30_0 vd2_16 vs2_16 inv
Xc1s31 c1s30_6 c1s31_0 vd2_17 vs2_17 inv
Xc1s32 c1s31_6 c1s32_0 vd2_18 vs2_18 inv
Xc1s33 c1s32_6 c1s33_0 vd2_19 vs2_19 inv
Xc1s34 c1s33_6 c1s34_0 vd2_20 vs2_20 inv
Xc1s35 c1s34_6 c1s35_0 vd2_21 vs2_21 inv
Xc1s36 c1s35_6 c1s36_0 vd2_22 vs2_22 inv
Xc1s37 c1s36_6 c1s37_0 vd2_23 vs2_23 inv
Xc1s38 c1s37_6 c1s38_0 vd2_24 vs2_24 inv
Xc1s39 c1s38_6 c1s39_0 vd2_25 vs2_25 inv
Xc1s40 c1s39_6 c1s40_0 vd2_26 vs2_26 inv
Xc1s41 c1s40_6 c1s41_0 vd2_27 vs2_27 inv
Xc1s42 c1s41_6 c1s42_0 vd2_28 vs2_28 inv
Xc1s43 c1s42_6 c1s43_0 vd2_29 vs2_29 inv
Xc1s44 c1s43_6 c1s44_0 vd2_30 vs2_30 inv
Xc1s45 c1s44_6 c1s45_0 vd2_31 vs2_31 inv
Xc1s46 c1s45_6 c1s46_0 vd3_0 vs3_0 inv
Xc1s47 c1s46_6 c1s47_0 vd3_1 vs3_1 inv
Xc1s48 c1s47_6 c1s48_0 vd3_2 vs3_2 inv
Xc1s49 c1s48_6 c1s49_0 vd3_3 vs3_3 inv
Xc2s0 clk_6 c2s0_0 vd3_4 vs3_4 inv
Xc2s1 c2s0_6 c2s1_0 vd3_5 vs3_5 inv
Xc2s2 c2s1_6 c2s2_0 vd3_6 vs3_6 inv
Xc2s3 c2s2_6 c2s3_0 vd3_7 vs3_7 inv
Xc2s4 c2s3_6 c2s4_0 vd3_8 vs3_8 inv
Xc2s5 c2s4_6 c2s5_0 vd3_9 vs3_9 inv
Xc2s6 c2s5_6 c2s6_0 vd3_10 vs3_10 inv
Xc2s7 c2s6_6 c2s7_0 vd3_11 vs3_11 inv
Xc2s8 c2s7_6 c2s8_0 vd3_12 vs3_12 inv
Xc2s9 c2s8_6 c2s9_0 vd3_13 vs3_13 inv
Xc2s10 c2s9_6 c2s10_0 vd3_14 vs3_14 inv
Xc2s11 c2s10_6 c2s11_0 vd3_15 vs3_15 inv
Xc2s12 c2s11_6 c2s12_0 vd3_16 vs3_16 inv
Xc2s13 c2s12_6 c2s13_0 vd3_17 vs3_17 inv
Xc2s14 c2s13_6 c2s14_0 vd3_18 vs3_18 inv
Xc2s15 c2s14_6 c2s15_0 vd3_19 vs3_19 inv
Xc2s16 c2s15_6 c2s16_0 vd3_20 vs3_20 inv
Xc2s17 c2s16_6 c2s17_0 vd3_21 vs3_21 inv
Xc2s18 c2s17_6 c2s18_0 vd3_22 vs3_22 inv
Xc2s19 c2s18_6 c2s19_0 vd3_23 vs3_23 inv
Xc2s20 c2s19_6 c2s20_0 vd3_24 vs3_24 inv
Xc2s21 c2s20_6 c2s21_0 vd3_25 vs3_25 inv
Xc2s22 c2s21_6 c2s22_0 vd3_26 vs3_26 inv
Xc2s23 c2s22_6 c2s23_0 vd3_27 vs3_27 inv
Xc2s24 c2s23_6 c2s24_0 vd3_28 vs3_28 inv
Xc2s25 c2s24_6 c2s25_0 vd3_29 vs3_29 inv
Xc2s26 c2s25_6 c2s26_0 vd3_30 vs3_30 inv
Xc2s27 c2s26_6 c2s27_0 vd3_31 vs3_31 inv
Xc2s28 c2s27_6 c2s28_0 vd4_0 vs4_0 inv
Xc2s29 c2s28_6 c2s29_0 vd4_1 vs4_1 inv
Xc2s30 c2s29_6 c2s30_0 vd4_2 vs4_2 inv
Xc2s31 c2s30_6 c2s31_0 vd4_3 vs4_3 inv
Xc2s32 c2s31_6 c2s32_0 vd4_4 vs4_4 inv
Xc2s33 c2s32_6 c2s33_0 vd4_5 vs4_5 inv
Xc2s34 c2s33_6 c2s34_0 vd4_6 vs4_6 inv
Xc2s35 c2s34_6 c2s35_0 vd4_7 vs4_7 inv
Xc2s36 c2s35_6 c2s36_0 vd4_8 vs4_8 inv
Xc2s37 c2s36_6 c2s37_0 vd4_9 vs4_9 inv
Xc2s38 c2s37_6 c2s38_0 vd4_10 vs4_10 inv
Xc2s39 c2s38_6 c2s39_0 vd4_11 vs4_11 inv
Xc2s40 c2s39_6 c2s40_0 vd4_12 vs4_12 inv
Xc2s41 c2s40_6 c2s41_0 vd4_13 vs4_13 inv
Xc2s42 c2s41_6 c2s42_0 vd4_14 vs4_14 inv
Xc2s43 c2s42_6 c2s43_0 vd4_15 vs4_15 inv
Xc2s44 c2s43_6 c2s44_0 vd4_16 vs4_16 inv
Xc2s45 c2s44_6 c2s45_0 vd4_17 vs4_17 inv
Xc2s46 c2s45_6 c2s46_0 vd4_18 vs4_18 inv
Xc2s47 c2s46_6 c2s47_0 vd4_19 vs4_19 inv
Xc2s48 c2s47_6 c2s48_0 vd4_20 vs4_20 inv
Xc2s49 c2s48_6 c2s49_0 vd4_21 vs4_21 inv
Xc3s0 clk_8 c3s0_0 vd4_22 vs4_22 inv
Xc3s1 c3s0_6 c3s1_0 vd4_23 vs4_23 inv
Xc3s2 c3s1_6 c3s2_0 vd4_24 vs4_24 inv
Xc3s3 c3s2_6 c3s3_0 vd4_25 vs4_25 inv
Xc3s4 c3s3_6 c3s4_0 vd4_26 vs4_26 inv
Xc3s5 c3s4_6 c3s5_0 vd4_27 vs4_27 inv
Xc3s6 c3s5_6 c3s6_0 vd4_28 vs4_28 inv
Xc3s7 c3s6_6 c3s7_0 vd4_29 vs4_29 inv
Xc3s8 c3s7_6 c3s8_0 vd4_30 vs4_30 inv
Xc3s9 c3s8_6 c3s9_0 vd4_31 vs4_31 inv
Xc3s10 c3s9_6 c3s10_0 vd5_0 vs5_0 inv
Xc3s11 c3s10_6 c3s11_0 vd5_1 vs5_1 inv
Xc3s12 c3s11_6 c3s12_0 vd5_2 vs5_2 inv
Xc3s13 c3s12_6 c3s13_0 vd5_3 vs5_3 inv
Xc3s14 c3s13_6 c3s14_0 vd5_4 vs5_4 inv
Xc3s15 c3s14_6 c3s15_0 vd5_5 vs5_5 inv
Xc3s16 c3s15_6 c3s16_0 vd5_6 vs5_6 inv
Xc3s17 c3s16_6 c3s17_0 vd5_7 vs5_7 inv
Xc3s18 c3s17_6 c3s18_0 vd5_8 vs5_8 inv
Xc3s19 c3s18_6 c3s19_0 vd5_9 vs5_9 inv
Xc3s20 c3s19_6 c3s20_0 vd5_10 vs5_10 inv
Xc3s21 c3s20_6 c3s21_0 vd5_11 vs5_11 inv
Xc3s22 c3s21_6 c3s22_0 vd5_12 vs5_12 inv
Xc3s23 c3s22_6 c3s23_0 vd5_13 vs5_13 inv
Xc3s24 c3s23_6 c3s24_0 vd5_14 vs5_14 inv
Xc3s25 c3s24_6 c3s25_0 vd5_15 vs5_15 inv
Xc3s26 c3s25_6 c3s26_0 vd5_16 vs5_16 inv
Xc3s27 c3s26_6 c3s27_0 vd5_17 vs5_17 inv
Xc3s28 c3s27_6 c3s28_0 vd5_18 vs5_18 inv
Xc3s29 c3s28_6 c3s29_0 vd5_19 vs5_19 inv
Xc3s30 c3s29_6 c3s30_0 vd5_20 vs5_20 inv
Xc3s31 c3s30_6 c3s31_0 vd5_21 vs5_21 inv
Xc3s32 c3s31_6 c3s32_0 vd5_22 vs5_22 inv
Xc3s33 c3s32_6 c3s33_0 vd5_23 vs5_23 inv
Xc3s34 c3s33_6 c3s34_0 vd5_24 vs5_24 inv
Xc3s35 c3s34_6 c3s35_0 vd5_25 vs5_25 inv
Xc3s36 c3s35_6 c3s36_0 vd5_26 vs5_26 inv
Xc3s37 c3s36_6 c3s37_0 vd5_27 vs5_27 inv
Xc3s38 c3s37_6 c3s38_0 vd5_28 vs5_28 inv
Xc3s39 c3s38_6 c3s39_0 vd5_29 vs5_29 inv
Xc3s40 c3s39_6 c3s40_0 vd5_30 vs5_30 inv
Xc3s41 c3s40_6 c3s41_0 vd5_31 vs5_31 inv
Xc3s42 c3s41_6 c3s42_0 vd6_0 vs6_0 inv
Xc3s43 c3s42_6 c3s43_0 vd6_1 vs6_1 inv
Xc3s44 c3s43_6 c3s44_0 vd6_2 vs6_2 inv
Xc3s45 c3s44_6 c3s45_0 vd6_3 vs6_3 inv
Xc3s46 c3s45_6 c3s46_0 vd6_4 vs6_4 inv
Xc3s47 c3s46_6 c3s47_0 vd6_5 vs6_5 inv
Xc3s48 c3s47_6 c3s48_0 vd6_6 vs6_6 inv
Xc3s49 c3s48_6 c3s49_0 vd6_7 vs6_7 inv
Xc4s0 clk_10 c4s0_0 vd6_8 vs6_8 inv
Xc4s1 c4s0_6 c4s1_0 vd6_9 vs6_9 inv
Xc4s2 c4s1_6 c4s2_0 vd6_10 vs6_10 inv
Xc4s3 c4s2_6 c4s3_0 vd6_11 vs6_11 inv
Xc4s4 c4s3_6 c4s4_0 vd6_12 vs6_12 inv
Xc4s5 c4s4_6 c4s5_0 vd6_13 vs6_13 inv
Xc4s6 c4s5_6 c4s6_0 vd6_14 vs6_14 inv
Xc4s7 c4s6_6 c4s7_0 vd6_15 vs6_15 inv
Xc4s8 c4s7_6 c4s8_0 vd6_16 vs6_16 inv
Xc4s9 c4s8_6 c4s9_0 vd6_17 vs6_17 inv
Xc4s10 c4s9_6 c4s10_0 vd6_18 vs6_18 inv
Xc4s11 c4s10_6 c4s11_0 vd6_19 vs6_19 inv
Xc4s12 c4s11_6 c4s12_0 vd6_20 vs6_20 inv
Xc4s13 c4s12_6 c4s13_0 vd6_21 vs6_21 inv
Xc4s14 c4s13_6 c4s14_0 vd6_22 vs6_22 inv
Xc4s15 c4s14_6 c4s15_0 vd6_23 vs6_23 inv
Xc4s16 c4s15_6 c4s16_0 vd6_24 vs6_24 inv
Xc4s17 c4s16_6 c4s17_0 vd6_25 vs6_25 inv
Xc4s18 c4s17_6 c4s18_0 vd6_26 vs6_26 inv
Xc4s19 c4s18_6 c4s19_0 vd6_27 vs6_27 inv
Xc4s20 c4s19_6 c4s20_0 vd6_28 vs6_28 inv
Xc4s21 c4s20_6 c4s21_0 vd6_29 vs6_29 inv
Xc4s22 c4s21_6 c4s22_0 vd6_30 vs6_30 inv
Xc4s23 c4s22_6 c4s23_0 vd6_31 vs6_31 inv
Xc4s24 c4s23_6 c4s24_0 vd7_0 vs7_0 inv
Xc4s25 c4s24_6 c4s25_0 vd7_1 vs7_1 inv
Xc4s26 c4s25_6 c4s26_0 vd7_2 vs7_2 inv
Xc4s27 c4s26_6 c4s27_0 vd7_3 vs7_3 inv
Xc4s28 c4s27_6 c4s28_0 vd7_4 vs7_4 inv
Xc4s29 c4s28_6 c4s29_0 vd7_5 vs7_5 inv
Xc4s30 c4s29_6 c4s30_0 vd7_6 vs7_6 inv
Xc4s31 c4s30_6 c4s31_0 vd7_7 vs7_7 inv
Xc4s32 c4s31_6 c4s32_0 vd7_8 vs7_8 inv
Xc4s33 c4s32_6 c4s33_0 vd7_9 vs7_9 inv
Xc4s34 c4s33_6 c4s34_0 vd7_10 vs7_10 inv
Xc4s35 c4s34_6 c4s35_0 vd7_11 vs7_11 inv
Xc4s36 c4s35_6 c4s36_0 vd7_12 vs7_12 inv
Xc4s37 c4s36_6 c4s37_0 vd7_13 vs7_13 inv
Xc4s38 c4s37_6 c4s38_0 vd7_14 vs7_14 inv
Xc4s39 c4s38_6 c4s39_0 vd7_15 vs7_15 inv
Xc4s40 c4s39_6 c4s40_0 vd7_16 vs7_16 inv
Xc4s41 c4s40_6 c4s41_0 vd7_17 vs7_17 inv
Xc4s42 c4s41_6 c4s42_0 vd7_18 vs7_18 inv
Xc4s43 c4s42_6 c4s43_0 vd7_19 vs7_19 inv
Xc4s44 c4s43_6 c4s44_0 vd7_20 vs7_20 inv
Xc4s45 c4s44_6 c4s45_0 vd7_21 vs7_21 inv
Xc4s46 c4s45_6 c4s46_0 vd7_22 vs7_22 inv
Xc4s47 c4s46_6 c4s47_0 vd7_23 vs7_23 inv
Xc4s48 c4s47_6 c4s48_0 vd7_24 vs7_24 inv
Xc4s49 c4s48_6 c4s49_0 vd7_25 vs7_25 inv
Xc5s0 clk_12 c5s0_0 vd7_26 vs7_26 inv
Xc5s1 c5s0_6 c5s1_0 vd7_27 vs7_27 inv
Xc5s2 c5s1_6 c5s2_0 vd7_28 vs7_28 inv
Xc5s3 c5s2_6 c5s3_0 vd7_29 vs7_29 inv
Xc5s4 c5s3_6 c5s4_0 vd7_30 vs7_30 inv
Xc5s5 c5s4_6 c5s5_0 vd7_31 vs7_31 inv
Xc5s6 c5s5_6 c5s6_0 vd8_0 vs8_0 inv
Xc5s7 c5s6_6 c5s7_0 vd8_1 vs8_1 inv
Xc5s8 c5s7_6 c5s8_0 vd8_2 vs8_2 inv
Xc5s9 c5s8_6 c5s9_0 vd8_3 vs8_3 inv
Xc5s10 c5s9_6 c5s10_0 vd8_4 vs8_4 inv
Xc5s11 c5s10_6 c5s11_0 vd8_5 vs8_5 inv
Xc5s12 c5s11_6 c5s12_0 vd8_6 vs8_6 inv
Xc5s13 c5s12_6 c5s13_0 vd8_7 vs8_7 inv
Xc5s14 c5s13_6 c5s14_0 vd8_8 vs8_8 inv
Xc5s15 c5s14_6 c5s15_0 vd8_9 vs8_9 inv
Xc5s16 c5s15_6 c5s16_0 vd8_10 vs8_10 inv
Xc5s17 c5s16_6 c5s17_0 vd8_11 vs8_11 inv
Xc5s18 c5s17_6 c5s18_0 vd8_12 vs8_12 inv
Xc5s19 c5s18_6 c5s19_0 vd8_13 vs8_13 inv
Xc5s20 c5s19_6 c5s20_0 vd8_14 vs8_14 inv
Xc5s21 c5s20_6 c5s21_0 vd8_15 vs8_15 inv
Xc5s22 c5s21_6 c5s22_0 vd8_16 vs8_16 inv
Xc5s23 c5s22_6 c5s23_0 vd8_17 vs8_17 inv
Xc5s24 c5s23_6 c5s24_0 vd8_18 vs8_18 inv
Xc5s25 c5s24_6 c5s25_0 vd8_19 vs8_19 inv
Xc5s26 c5s25_6 c5s26_0 vd8_20 vs8_20 inv
Xc5s27 c5s26_6 c5s27_0 vd8_21 vs8_21 inv
Xc5s28 c5s27_6 c5s28_0 vd8_22 vs8_22 inv
Xc5s29 c5s28_6 c5s29_0 vd8_23 vs8_23 inv
Xc5s30 c5s29_6 c5s30_0 vd8_24 vs8_24 inv
Xc5s31 c5s30_6 c5s31_0 vd8_25 vs8_25 inv
Xc5s32 c5s31_6 c5s32_0 vd8_26 vs8_26 inv
Xc5s33 c5s32_6 c5s33_0 vd8_27 vs8_27 inv
Xc5s34 c5s33_6 c5s34_0 vd8_28 vs8_28 inv
Xc5s35 c5s34_6 c5s35_0 vd8_29 vs8_29 inv
Xc5s36 c5s35_6 c5s36_0 vd8_30 vs8_30 inv
Xc5s37 c5s36_6 c5s37_0 vd8_31 vs8_31 inv
Xc5s38 c5s37_6 c5s38_0 vd9_0 vs9_0 inv
Xc5s39 c5s38_6 c5s39_0 vd9_1 vs9_1 inv
Xc5s40 c5s39_6 c5s40_0 vd9_2 vs9_2 inv
Xc5s41 c5s40_6 c5s41_0 vd9_3 vs9_3 inv
Xc5s42 c5s41_6 c5s42_0 vd9_4 vs9_4 inv
Xc5s43 c5s42_6 c5s43_0 vd9_5 vs9_5 inv
Xc5s44 c5s43_6 c5s44_0 vd9_6 vs9_6 inv
Xc5s45 c5s44_6 c5s45_0 vd9_7 vs9_7 inv
Xc5s46 c5s45_6 c5s46_0 vd9_8 vs9_8 inv
Xc5s47 c5s46_6 c5s47_0 vd9_9 vs9_9 inv
Xc5s48 c5s47_6 c5s48_0 vd9_10 vs9_10 inv
Xc5s49 c5s48_6 c5s49_0 vd9_11 vs9_11 inv
Xc6s0 clk_14 c6s0_0 vd9_12 vs9_12 inv
Xc6s1 c6s0_6 c6s1_0 vd9_13 vs9_13 inv
Xc6s2 c6s1_6 c6s2_0 vd9_14 vs9_14 inv
Xc6s3 c6s2_6 c6s3_0 vd9_15 vs9_15 inv
Xc6s4 c6s3_6 c6s4_0 vd9_16 vs9_16 inv
Xc6s5 c6s4_6 c6s5_0 vd9_17 vs9_17 inv
Xc6s6 c6s5_6 c6s6_0 vd9_18 vs9_18 inv
Xc6s7 c6s6_6 c6s7_0 vd9_19 vs9_19 inv
Xc6s8 c6s7_6 c6s8_0 vd9_20 vs9_20 inv
Xc6s9 c6s8_6 c6s9_0 vd9_21 vs9_21 inv
Xc6s10 c6s9_6 c6s10_0 vd9_22 vs9_22 inv
Xc6s11 c6s10_6 c6s11_0 vd9_23 vs9_23 inv
Xc6s12 c6s11_6 c6s12_0 vd9_24 vs9_24 inv
Xc6s13 c6s12_6 c6s13_0 vd9_25 vs9_25 inv
Xc6s14 c6s13_6 c6s14_0 vd9_26 vs9_26 inv
Xc6s15 c6s14_6 c6s15_0 vd9_27 vs9_27 inv
Xc6s16 c6s15_6 c6s16_0 vd9_28 vs9_28 inv
Xc6s17 c6s16_6 c6s17_0 vd9_29 vs9_29 inv
Xc6s18 c6s17_6 c6s18_0 vd9_30 vs9_30 inv
Xc6s19 c6s18_6 c6s19_0 vd9_31 vs9_31 inv
Xc6s20 c6s19_6 c6s20_0 vd10_0 vs10_0 inv
Xc6s21 c6s20_6 c6s21_0 vd10_1 vs10_1 inv
Xc6s22 c6s21_6 c6s22_0 vd10_2 vs10_2 inv
Xc6s23 c6s22_6 c6s23_0 vd10_3 vs10_3 inv
Xc6s24 c6s23_6 c6s24_0 vd10_4 vs10_4 inv
Xc6s25 c6s24_6 c6s25_0 vd10_5 vs10_5 inv
Xc6s26 c6s25_6 c6s26_0 vd10_6 vs10_6 inv
Xc6s27 c6s26_6 c6s27_0 vd10_7 vs10_7 inv
Xc6s28 c6s27_6 c6s28_0 vd10_8 vs10_8 inv
Xc6s29 c6s28_6 c6s29_0 vd10_9 vs10_9 inv
Xc6s30 c6s29_6 c6s30_0 vd10_10 vs10_10 inv
Xc6s31 c6s30_6 c6s31_0 vd10_11 vs10_11 inv
Xc6s32 c6s31_6 c6s32_0 vd10_12 vs10_12 inv
Xc6s33 c6s32_6 c6s33_0 vd10_13 vs10_13 inv
Xc6s34 c6s33_6 c6s34_0 vd10_14 vs10_14 inv
Xc6s35 c6s34_6 c6s35_0 vd10_15 vs10_15 inv
Xc6s36 c6s35_6 c6s36_0 vd10_16 vs10_16 inv
Xc6s37 c6s36_6 c6s37_0 vd10_17 vs10_17 inv
Xc6s38 c6s37_6 c6s38_0 vd10_18 vs10_18 inv
Xc6s39 c6s38_6 c6s39_0 vd10_19 vs10_19 inv
Xc6s40 c6s39_6 c6s40_0 vd10_20 vs10_20 inv
Xc6s41 c6s40_6 c6s41_0 vd10_21 vs10_21 inv
Xc6s42 c6s41_6 c6s42_0 vd10_22 vs10_22 inv
Xc6s43 c6s42_6 c6s43_0 vd10_23 vs10_23 inv
Xc6s44 c6s43_6 c6s44_0 vd10_24 vs10_24 inv
Xc6s45 c6s44_6 c6s45_0 vd10_25 vs10_25 inv
Xc6s46 c6s45_6 c6s46_0 vd10_26 vs10_26 inv
Xc6s47 c6s46_6 c6s47_0 vd10_27 vs10_27 inv
Xc6s48 c6s47_6 c6s48_0 vd10_28 vs10_28 inv
Xc6s49 c6s48_6 c6s49_0 vd10_29 vs10_29 inv
Xc7s0 clk_16 c7s0_0 vd10_30 vs10_30 inv
Xc7s1 c7s0_6 c7s1_0 vd10_31 vs10_31 inv
Xc7s2 c7s1_6 c7s2_0 vd11_0 vs11_0 inv
Xc7s3 c7s2_6 c7s3_0 vd11_1 vs11_1 inv
Xc7s4 c7s3_6 c7s4_0 vd11_2 vs11_2 inv
Xc7s5 c7s4_6 c7s5_0 vd11_3 vs11_3 inv
Xc7s6 c7s5_6 c7s6_0 vd11_4 vs11_4 inv
Xc7s7 c7s6_6 c7s7_0 vd11_5 vs11_5 inv
Xc7s8 c7s7_6 c7s8_0 vd11_6 vs11_6 inv
Xc7s9 c7s8_6 c7s9_0 vd11_7 vs11_7 inv
Xc7s10 c7s9_6 c7s10_0 vd11_8 vs11_8 inv
Xc7s11 c7s10_6 c7s11_0 vd11_9 vs11_9 inv
Xc7s12 c7s11_6 c7s12_0 vd11_10 vs11_10 inv
Xc7s13 c7s12_6 c7s13_0 vd11_11 vs11_11 inv
Xc7s14 c7s13_6 c7s14_0 vd11_12 vs11_12 inv
Xc7s15 c7s14_6 c7s15_0 vd11_13 vs11_13 inv
Xc7s16 c7s15_6 c7s16_0 vd11_14 vs11_14 inv
Xc7s17 c7s16_6 c7s17_0 vd11_15 vs11_15 inv
Xc7s18 c7s17_6 c7s18_0 vd11_16 vs11_16 inv
Xc7s19 c7s18_6 c7s19_0 vd11_17 vs11_17 inv
Xc7s20 c7s19_6 c7s20_0 vd11_18 vs11_18 inv
Xc7s21 c7s20_6 c7s21_0 vd11_19 vs11_19 inv
Xc7s22 c7s21_6 c7s22_0 vd11_20 vs11_20 inv
Xc7s23 c7s22_6 c7s23_0 vd11_21 vs11_21 inv
Xc7s24 c7s23_6 c7s24_0 vd11_22 vs11_22 inv
Xc7s25 c7s24_6 c7s25_0 vd11_23 vs11_23 inv
Xc7s26 c7s25_6 c7s26_0 vd11_24 vs11_24 inv
Xc7s27 c7s26_6 c7s27_0 vd11_25 vs11_25 inv
Xc7s28 c7s27_6 c7s28_0 vd11_26 vs11_26 inv
Xc7s29 c7s28_6 c7s29_0 vd11_27 vs11_27 inv
Xc7s30 c7s29_6 c7s30_0 vd11_28 vs11_28 inv
Xc7s31 c7s30_6 c7s31_0 vd11_29 vs11_29 inv
Xc7s32 c7s31_6 c7s32_0 vd11_30 vs11_30 inv
Xc7s33 c7s32_6 c7s33_0 vd11_31 vs11_31 inv
Xc7s34 c7s33_6 c7s34_0 vd12_0 vs12_0 inv
Xc7s35 c7s34_6 c7s35_0 vd12_1 vs12_1 inv
Xc7s36 c7s35_6 c7s36_0 vd12_2 vs12_2 inv
Xc7s37 c7s36_6 c7s37_0 vd12_3 vs12_3 inv
Xc7s38 c7s37_6 c7s38_0 vd12_4 vs12_4 inv
Xc7s39 c7s38_6 c7s39_0 vd12_5 vs12_5 inv
Xc7s40 c7s39_6 c7s40_0 vd12_6 vs12_6 inv
Xc7s41 c7s40_6 c7s41_0 vd12_7 vs12_7 inv
Xc7s42 c7s41_6 c7s42_0 vd12_8 vs12_8 inv
Xc7s43 c7s42_6 c7s43_0 vd12_9 vs12_9 inv
Xc7s44 c7s43_6 c7s44_0 vd12_10 vs12_10 inv
Xc7s45 c7s44_6 c7s45_0 vd12_11 vs12_11 inv
Xc7s46 c7s45_6 c7s46_0 vd12_12 vs12_12 inv
Xc7s47 c7s46_6 c7s47_0 vd12_13 vs12_13 inv
Xc7s48 c7s47_6 c7s48_0 vd12_14 vs12_14 inv
Xc7s49 c7s48_6 c7s49_0 vd12_15 vs12_15 inv
Xc8s0 clk_18 c8s0_0 vd12_16 vs12_16 inv
Xc8s1 c8s0_6 c8s1_0 vd12_17 vs12_17 inv
Xc8s2 c8s1_6 c8s2_0 vd12_18 vs12_18 inv
Xc8s3 c8s2_6 c8s3_0 vd12_19 vs12_19 inv
Xc8s4 c8s3_6 c8s4_0 vd12_20 vs12_20 inv
Xc8s5 c8s4_6 c8s5_0 vd12_21 vs12_21 inv
Xc8s6 c8s5_6 c8s6_0 vd12_22 vs12_22 inv
Xc8s7 c8s6_6 c8s7_0 vd12_23 vs12_23 inv
Xc8s8 c8s7_6 c8s8_0 vd12_24 vs12_24 inv
Xc8s9 c8s8_6 c8s9_0 vd12_25 vs12_25 inv
Xc8s10 c8s9_6 c8s10_0 vd12_26 vs12_26 inv
Xc8s11 c8s10_6 c8s11_0 vd12_27 vs12_27 inv
Xc8s12 c8s11_6 c8s12_0 vd12_28 vs12_28 inv
Xc8s13 c8s12_6 c8s13_0 vd12_29 vs12_29 inv
Xc8s14 c8s13_6 c8s14_0 vd12_30 vs12_30 inv
Xc8s15 c8s14_6 c8s15_0 vd12_31 vs12_31 inv
Xc8s16 c8s15_6 c8s16_0 vd13_0 vs13_0 inv
Xc8s17 c8s16_6 c8s17_0 vd13_1 vs13_1 inv
Xc8s18 c8s17_6 c8s18_0 vd13_2 vs13_2 inv
Xc8s19 c8s18_6 c8s19_0 vd13_3 vs13_3 inv
Xc8s20 c8s19_6 c8s20_0 vd13_4 vs13_4 inv
Xc8s21 c8s20_6 c8s21_0 vd13_5 vs13_5 inv
Xc8s22 c8s21_6 c8s22_0 vd13_6 vs13_6 inv
Xc8s23 c8s22_6 c8s23_0 vd13_7 vs13_7 inv
Xc8s24 c8s23_6 c8s24_0 vd13_8 vs13_8 inv
Xc8s25 c8s24_6 c8s25_0 vd13_9 vs13_9 inv
Xc8s26 c8s25_6 c8s26_0 vd13_10 vs13_10 inv
Xc8s27 c8s26_6 c8s27_0 vd13_11 vs13_11 inv
Xc8s28 c8s27_6 c8s28_0 vd13_12 vs13_12 inv
Xc8s29 c8s28_6 c8s29_0 vd13_13 vs13_13 inv
Xc8s30 c8s29_6 c8s30_0 vd13_14 vs13_14 inv
Xc8s31 c8s30_6 c8s31_0 vd13_15 vs13_15 inv
Xc8s32 c8s31_6 c8s32_0 vd13_16 vs13_16 inv
Xc8s33 c8s32_6 c8s33_0 vd13_17 vs13_17 inv
Xc8s34 c8s33_6 c8s34_0 vd13_18 vs13_18 inv
Xc8s35 c8s34_6 c8s35_0 vd13_19 vs13_19 inv
Xc8s36 c8s35_6 c8s36_0 vd13_20 vs13_20 inv
Xc8s37 c8s36_6 c8s37_0 vd13_21 vs13_21 inv
Xc8s38 c8s37_6 c8s38_0 vd13_22 vs13_22 inv
Xc8s39 c8s38_6 c8s39_0 vd13_23 vs13_23 inv
Xc8s40 c8s39_6 c8s40_0 vd13_24 vs13_24 inv
Xc8s41 c8s40_6 c8s41_0 vd13_25 vs13_25 inv
Xc8s42 c8s41_6 c8s42_0 vd13_26 vs13_26 inv
Xc8s43 c8s42_6 c8s43_0 vd13_27 vs13_27 inv
Xc8s44 c8s43_6 c8s44_0 vd13_28 vs13_28 inv
Xc8s45 c8s44_6 c8s45_0 vd13_29 vs13_29 inv
Xc8s46 c8s45_6 c8s46_0 vd13_30 vs13_30 inv
Xc8s47 c8s46_6 c8s47_0 vd13_31 vs13_31 inv
Xc8s48 c8s47_6 c8s48_0 vd14_0 vs14_0 inv
Xc8s49 c8s48_6 c8s49_0 vd14_1 vs14_1 inv
Xc9s0 clk_20 c9s0_0 vd14_2 vs14_2 inv
Xc9s1 c9s0_6 c9s1_0 vd14_3 vs14_3 inv
Xc9s2 c9s1_6 c9s2_0 vd14_4 vs14_4 inv
Xc9s3 c9s2_6 c9s3_0 vd14_5 vs14_5 inv
Xc9s4 c9s3_6 c9s4_0 vd14_6 vs14_6 inv
Xc9s5 c9s4_6 c9s5_0 vd14_7 vs14_7 inv
Xc9s6 c9s5_6 c9s6_0 vd14_8 vs14_8 inv
Xc9s7 c9s6_6 c9s7_0 vd14_9 vs14_9 inv
Xc9s8 c9s7_6 c9s8_0 vd14_10 vs14_10 inv
Xc9s9 c9s8_6 c9s9_0 vd14_11 vs14_11 inv
Xc9s10 c9s9_6 c9s10_0 vd14_12 vs14_12 inv
Xc9s11 c9s10_6 c9s11_0 vd14_13 vs14_13 inv
Xc9s12 c9s11_6 c9s12_0 vd14_14 vs14_14 inv
Xc9s13 c9s12_6 c9s13_0 vd14_15 vs14_15 inv
Xc9s14 c9s13_6 c9s14_0 vd14_16 vs14_16 inv
Xc9s15 c9s14_6 c9s15_0 vd14_17 vs14_17 inv
Xc9s16 c9s15_6 c9s16_0 vd14_18 vs14_18 inv
Xc9s17 c9s16_6 c9s17_0 vd14_19 vs14_19 inv
Xc9s18 c9s17_6 c9s18_0 vd14_20 vs14_20 inv
Xc9s19 c9s18_6 c9s19_0 vd14_21 vs14_21 inv
Xc9s20 c9s19_6 c9s20_0 vd14_22 vs14_22 inv
Xc9s21 c9s20_6 c9s21_0 vd14_23 vs14_23 inv
Xc9s22 c9s21_6 c9s22_0 vd14_24 vs14_24 inv
Xc9s23 c9s22_6 c9s23_0 vd14_25 vs14_25 inv
Xc9s24 c9s23_6 c9s24_0 vd14_26 vs14_26 inv
Xc9s25 c9s24_6 c9s25_0 vd14_27 vs14_27 inv
Xc9s26 c9s25_6 c9s26_0 vd14_28 vs14_28 inv
Xc9s27 c9s26_6 c9s27_0 vd14_29 vs14_29 inv
Xc9s28 c9s27_6 c9s28_0 vd14_30 vs14_30 inv
Xc9s29 c9s28_6 c9s29_0 vd14_31 vs14_31 inv
Xc9s30 c9s29_6 c9s30_0 vd15_0 vs15_0 inv
Xc9s31 c9s30_6 c9s31_0 vd15_1 vs15_1 inv
Xc9s32 c9s31_6 c9s32_0 vd15_2 vs15_2 inv
Xc9s33 c9s32_6 c9s33_0 vd15_3 vs15_3 inv
Xc9s34 c9s33_6 c9s34_0 vd15_4 vs15_4 inv
Xc9s35 c9s34_6 c9s35_0 vd15_5 vs15_5 inv
Xc9s36 c9s35_6 c9s36_0 vd15_6 vs15_6 inv
Xc9s37 c9s36_6 c9s37_0 vd15_7 vs15_7 inv
Xc9s38 c9s37_6 c9s38_0 vd15_8 vs15_8 inv
Xc9s39 c9s38_6 c9s39_0 vd15_9 vs15_9 inv
Xc9s40 c9s39_6 c9s40_0 vd15_10 vs15_10 inv
Xc9s41 c9s40_6 c9s41_0 vd15_11 vs15_11 inv
Xc9s42 c9s41_6 c9s42_0 vd15_12 vs15_12 inv
Xc9s43 c9s42_6 c9s43_0 vd15_13 vs15_13 inv
Xc9s44 c9s43_6 c9s44_0 vd15_14 vs15_14 inv
Xc9s45 c9s44_6 c9s45_0 vd15_15 vs15_15 inv
Xc9s46 c9s45_6 c9s46_0 vd15_16 vs15_16 inv
Xc9s47 c9s46_6 c9s47_0 vd15_17 vs15_17 inv
Xc9s48 c9s47_6 c9s48_0 vd15_18 vs15_18 inv
Xc9s49 c9s48_6 c9s49_0 vd15_19 vs15_19 inv
Rclk_0 clk_0 clk_1 2.873
Rclk_1 clk_1 clk_2 3.119
Rclk_2 clk_2 clk_3 2.856
Rclk_3 clk_3 clk_4 1.253
Rclk_4 clk_4 clk_5 2.011
Rclk_5 clk_5 clk_6 1.866
Rclk_6 clk_6 clk_7 2.503
Rclk_7 clk_7 clk_8 2.934
Rclk_8 clk_8 clk_9 0.7457
Rclk_9 clk_9 clk_10 0.5393
Rclk_10 clk_10 clk_11 3.083
Rclk_11 clk_11 clk_12 1.813
Rclk_12 clk_12 clk_13 2.851
Rclk_13 clk_13 clk_14 0.4566
Rclk_14 clk_14 clk_15 1.853
Rclk_15 clk_15 clk_16 2.723
Rclk_16 clk_16 clk_17 1.171
Rclk_17 clk_17 clk_18 3.428
Rclk_18 clk_18 clk_19 3.289
Rclk_19 clk_19 clk_20 0.5464
Cclk_0 clk_0 0 0.05822f
Cclk_1 clk_1 0 0.2662f
Cclk_2 clk_2 0 0.3984f
Cclk_3 clk_3 0 0.274f
Cclk_4 clk_4 0 0.2176f
Cclk_5 clk_5 0 0.2584f
Cclk_6 clk_6 0 0.2912f
Cclk_7 clk_7 0 0.3625f
Cclk_8 clk_8 0 0.2453f
Cclk_9 clk_9 0 0.08566f
Cclk_10 clk_10 0 0.2415f
Cclk_11 clk_11 0 0.3264f
Cclk_12 clk_12 0 0.311f
Cclk_13 clk_13 0 0.2205f
Cclk_14 clk_14 0 0.154f
Cclk_15 clk_15 0 0.3051f
Cclk_16 clk_16 0 0.2596f
Cclk_17 clk_17 0 0.3065f
Cclk_18 clk_18 0 0.4478f
Cclk_19 clk_19 0 0.2557f
Cclk_20 clk_20 0 0.03642f
CCclk_0 clk_0 c0s0_0 0.02356f
CCclk_2 clk_2 c0s0_2 0.0958f
CCclk_4 clk_4 c0s0_4 0.1515f
CCclk_6 clk_6 c0s0_6 0.07337f
Rc0s0_0 c0s0_0 c0s0_1 3.132
Rc0s0_1 c0s0_1 c0s0_2 1.78
Rc0s0_2 c0s0_2 c0s0_3 0.5415
Rc0s0_3 c0s0_3 c0s0_4 1.148
Rc0s0_4 c0s0_4 c0s0_5 1.829
Rc0s0_5 c0s0_5 c0s0_6 2.012
Cc0s0_0 c0s0_0 0 0.07549f
Cc0s0_1 c0s0_1 0 0.1941f
Cc0s0_2 c0s0_2 0 0.1547f
Cc0s0_3 c0s0_3 0 0.1127f
Cc0s0_4 c0s0_4 0 0.1985f
Cc0s0_5 c0s0_5 0 0.2561f
Cc0s0_6 c0s0_6 0 0.1341f
CCc0s0_0 c0s0_0 c0s1_0 0.05263f
CCc0s0_2 c0s0_2 c0s1_2 0.05232f
CCc0s0_4 c0s0_4 c0s1_4 0.05063f
CCc0s0_6 c0s0_6 c0s1_6 0.08434f
Rc0s1_0 c0s1_0 c0s1_1 3.363
Rc0s1_1 c0s1_1 c0s1_2 0.5177
Rc0s1_2 c0s1_2 c0s1_3 3.088
Rc0s1_3 c0s1_3 c0s1_4 2.203
Rc0s1_4 c0s1_4 c0s1_5 2.473
Rc0s1_5 c0s1_5 c0s1_6 1.036
Cc0s1_0 c0s1_0 0 0.09085f
Cc0s1_1 c0s1_1 0 0.1254f
Cc0s1_2 c0s1_2 0 0.2404f
Cc0s1_3 c0s1_3 0 0.3527f
Cc0s1_4 c0s1_4 0 0.3117f
Cc0s1_5 c0s1_5 0 0.2339f
Cc0s1_6 c0s1_6 0 0.06904f
CCc0s1_0 c0s1_0 c0s2_0 0.159f
CCc0s1_2 c0s1_2 c0s2_2 0.1404f
CCc0s1_4 c0s1_4 c0s2_4 0.03692f
CCc0s1_6 c0s1_6 c0s2_6 0.06658f
Rc0s2_0 c0s2_0 c0s2_1 4.723
Rc0s2_1 c0s2_1 c0s2_2 2.69
Rc0s2_2 c0s2_2 c0s2_3 3.4
Rc0s2_3 c0s2_3 c0s2_4 1.78
Rc0s2_4 c0s2_4 c0s2_5 3.065
Rc0s2_5 c0s2_5 c0s2_6 2.561
Cc0s2_0 c0s2_0 0 0.1815f
Cc0s2_1 c0s2_1 0 0.3609f
Cc0s2_2 c0s2_2 0 0.406f
Cc0s2_3 c0s2_3 0 0.3453f
Cc0s2_4 c0s2_4 0 0.3229f
Cc0s2_5 c0s2_5 0 0.3751f
Cc0s2_6 c0s2_6 0 0.1708f
CCc0s2_0 c0s2_0 c0s3_0 0.06247f
CCc0s2_2 c0s2_2 c0s3_2 0.1023f
CCc0s2_4 c0s2_4 c0s3_4 0.1435f
CCc0s2_6 c0s2_6 c0s3_6 0.1385f
Rc0s3_0 c0s3_0 c0s3_1 4.042
Rc0s3_1 c0s3_1 c0s3_2 2.305
Rc0s3_2 c0s3_2 c0s3_3 0.5588
Rc0s3_3 c0s3_3 c0s3_4 1.215
Rc0s3_4 c0s3_4 c0s3_5 2.962
Rc0s3_5 c0s3_5 c0s3_6 1.755
Cc0s3_0 c0s3_0 0 0.1361f
Cc0s3_1 c0s3_1 0 0.2898f
Cc0s3_2 c0s3_2 0 0.1909f
Cc0s3_3 c0s3_3 0 0.1182f
Cc0s3_4 c0s3_4 0 0.2784f
Cc0s3_5 c0s3_5 0 0.3145f
Cc0s3_6 c0s3_6 0 0.117f
CCc0s3_0 c0s3_0 c0s4_0 0.04422f
CCc0s3_2 c0s3_2 c0s4_2 0.09683f
CCc0s3_4 c0s3_4 c0s4_4 0.1184f
CCc0s3_6 c0s3_6 c0s4_6 0.1144f
Rc0s4_0 c0s4_0 c0s4_1 3.63
Rc0s4_1 c0s4_1 c0s4_2 1.833
Rc0s4_2 c0s4_2 c0s4_3 2.052
Rc0s4_3 c0s4_3 c0s4_4 2.902
Rc0s4_4 c0s4_4 c0s4_5 2.091
Rc0s4_5 c0s4_5 c0s4_6 1.689
Cc0s4_0 c0s4_0 0 0.1087f
Cc0s4_1 c0s4_1 0 0.2309f
Cc0s4_2 c0s4_2 0 0.259f
Cc0s4_3 c0s4_3 0 0.3302f
Cc0s4_4 c0s4_4 0 0.3329f
Cc0s4_5 c0s4_5 0 0.252f
Cc0s4_6 c0s4_6 0 0.1126f
CCc0s4_0 c0s4_0 c0s5_0 0.08856f
CCc0s4_2 c0s4_2 c0s5_2 0.02414f
CCc0s4_4 c0s4_4 c0s5_4 0.02609f
CCc0s4_6 c0s4_6 c0s5_6 0.1185f
Rc0s5_0 c0s5_0 c0s5_1 5.547
Rc0s5_1 c0s5_1 c0s5_2 2.319
Rc0s5_2 c0s5_2 c0s5_3 1.69
Rc0s5_3 c0s5_3 c0s5_4 0.9866
Rc0s5_4 c0s5_4 c0s5_5 2.032
Rc0s5_5 c0s5_5 c0s5_6 3.544
Cc0s5_0 c0s5_0 0 0.2365f
Cc0s5_1 c0s5_1 0 0.391f
Cc0s5_2 c0s5_2 0 0.2672f
Cc0s5_3 c0s5_3 0 0.1784f
Cc0s5_4 c0s5_4 0 0.2012f
Cc0s5_5 c0s5_5 0 0.3717f
Cc0s5_6 c0s5_6 0 0.2362f
CCc0s5_0 c0s5_0 c0s6_0 0.1279f
CCc0s5_2 c0s5_2 c0s6_2 0.09555f
CCc0s5_4 c0s5_4 c0s6_4 0.1404f
CCc0s5_6 c0s5_6 c0s6_6 0.0525f
Rc0s6_0 c0s6_0 c0s6_1 4.068
Rc0s6_1 c0s6_1 c0s6_2 3.45
Rc0s6_2 c0s6_2 c0s6_3 2.27
Rc0s6_3 c0s6_3 c0s6_4 1.896
Rc0s6_4 c0s6_4 c0s6_5 1.298
Rc0s6_5 c0s6_5 c0s6_6 2.176
Cc0s6_0 c0s6_0 0 0.1379f
Cc0s6_1 c0s6_1 0 0.3679f
Cc0s6_2 c0s6_2 0 0.3814f
Cc0s6_3 c0s6_3 0 0.2778f
Cc0s6_4 c0s6_4 0 0.213f
Cc0s6_5 c0s6_5 0 0.2316f
Cc0s6_6 c0s6_6 0 0.1451f
CCc0s6_0 c0s6_0 c0s7_0 0.154f
CCc0s6_2 c0s6_2 c0s7_2 0.0208f
CCc0s6_4 c0s6_4 c0s7_4 0.1297f
CCc0s6_6 c0s6_6 c0s7_6 0.1349f
Rc0s7_0 c0s7_0 c0s7_1 5.241
Rc0s7_1 c0s7_1 c0s7_2 2.783
Rc0s7_2 c0s7_2 c0s7_3 2.999
Rc0s7_3 c0s7_3 c0s7_4 2.084
Rc0s7_4 c0s7_4 c0s7_5 2.218
Rc0s7_5 c0s7_5 c0s7_6 1.792
Cc0s7_0 c0s7_0 0 0.2161f
Cc0s7_1 c0s7_1 0 0.4016f
Cc0s7_2 c0s7_2 0 0.3854f
Cc0s7_3 c0s7_3 0 0.3388f
Cc0s7_4 c0s7_4 0 0.2868f
Cc0s7_5 c0s7_5 0 0.2674f
Cc0s7_6 c0s7_6 0 0.1195f
CCc0s7_0 c0s7_0 c0s8_0 0.02786f
CCc0s7_2 c0s7_2 c0s8_2 0.1418f
CCc0s7_4 c0s7_4 c0s8_4 0.0998f
CCc0s7_6 c0s7_6 c0s8_6 0.04798f
Rc0s8_0 c0s8_0 c0s8_1 4.04
Rc0s8_1 c0s8_1 c0s8_2 1.978
Rc0s8_2 c0s8_2 c0s8_3 1.574
Rc0s8_3 c0s8_3 c0s8_4 1.54
Rc0s8_4 c0s8_4 c0s8_5 2.146
Rc0s8_5 c0s8_5 c0s8_6 2.414
Cc0s8_0 c0s8_0 0 0.136f
Cc0s8_1 c0s8_1 0 0.2678f
Cc0s8_2 c0s8_2 0 0.2368f
Cc0s8_3 c0s8_3 0 0.2076f
Cc0s8_4 c0s8_4 0 0.2458f
Cc0s8_5 c0s8_5 0 0.304f
Cc0s8_6 c0s8_6 0 0.1609f
CCc0s8_0 c0s8_0 c0s9_0 0.1057f
CCc0s8_2 c0s8_2 c0s9_2 0.08414f
CCc0s8_4 c0s8_4 c0s9_4 0.02392f
CCc0s8_6 c0s8_6 c0s9_6 0.05214f
Rc0s9_0 c0s9_0 c0s9_1 3.008
Rc0s9_1 c0s9_1 c0s9_2 2.291
Rc0s9_2 c0s9_2 c0s9_3 3.162
Rc0s9_3 c0s9_3 c0s9_4 2.965
Rc0s9_4 c0s9_4 c0s9_5 2.961
Rc0s9_5 c0s9_5 c0s9_6 3.022
Cc0s9_0 c0s9_0 0 0.06721f
Cc0s9_1 c0s9_1 0 0.22f
Cc0s9_2 c0s9_2 0 0.3635f
Cc0s9_3 c0s9_3 0 0.4085f
Cc0s9_4 c0s9_4 0 0.3951f
Cc0s9_5 c0s9_5 0 0.3988f
Cc0s9_6 c0s9_6 0 0.2015f
CCc0s9_0 c0s9_0 c0s10_0 0.05574f
CCc0s9_2 c0s9_2 c0s10_2 0.1378f
CCc0s9_4 c0s9_4 c0s10_4 0.1142f
CCc0s9_6 c0s9_6 c0s10_6 0.03165f
Rc0s10_0 c0s10_0 c0s10_1 2.503
Rc0s10_1 c0s10_1 c0s10_2 0.4959
Rc0s10_2 c0s10_2 c0s10_3 2.83
Rc0s10_3 c0s10_3 c0s10_4 1.236
Rc0s10_4 c0s10_4 c0s10_5 0.7949
Rc0s10_5 c0s10_5 c0s10_6 2.418
Cc0s10_0 c0s10_0 0 0.03351f
Cc0s10_1 c0s10_1 0 0.06656f
Cc0s10_2 c0s10_2 0 0.2217f
Cc0s10_3 c0s10_3 0 0.2711f
Cc0s10_4 c0s10_4 0 0.1354f
Cc0s10_5 c0s10_5 0 0.2142f
Cc0s10_6 c0s10_6 0 0.1612f
CCc0s10_0 c0s10_0 c0s11_0 0.06822f
CCc0s10_2 c0s10_2 c0s11_2 0.02973f
CCc0s10_4 c0s10_4 c0s11_4 0.04235f
CCc0s10_6 c0s10_6 c0s11_6 0.09383f
Rc0s11_0 c0s11_0 c0s11_1 2.98
Rc0s11_1 c0s11_1 c0s11_2 1.31
Rc0s11_2 c0s11_2 c0s11_3 2.692
Rc0s11_3 c0s11_3 c0s11_4 1.882
Rc0s11_4 c0s11_4 c0s11_5 1.464
Rc0s11_5 c0s11_5 c0s11_6 1.942
Cc0s11_0 c0s11_0 0 0.06531f
Cc0s11_1 c0s11_1 0 0.1526f
Cc0s11_2 c0s11_2 0 0.2667f
Cc0s11_3 c0s11_3 0 0.3049f
Cc0s11_4 c0s11_4 0 0.2231f
Cc0s11_5 c0s11_5 0 0.2271f
Cc0s11_6 c0s11_6 0 0.1295f
CCc0s11_0 c0s11_0 c0s12_0 0.02331f
CCc0s11_2 c0s11_2 c0s12_2 0.07412f
CCc0s11_4 c0s11_4 c0s12_4 0.07893f
CCc0s11_6 c0s11_6 c0s12_6 0.04633f
Rc0s12_0 c0s12_0 c0s12_1 2.793
Rc0s12_1 c0s12_1 c0s12_2 3.284
Rc0s12_2 c0s12_2 c0s12_3 2.057
Rc0s12_3 c0s12_3 c0s12_4 1.109
Rc0s12_4 c0s12_4 c0s12_5 2.358
Rc0s12_5 c0s12_5 c0s12_6 3.024
Cc0s12_0 c0s12_0 0 0.05284f
Cc0s12_1 c0s12_1 0 0.2718f
Cc0s12_2 c0s12_2 0 0.3561f
Cc0s12_3 c0s12_3 0 0.211f
Cc0s12_4 c0s12_4 0 0.2311f
Cc0s12_5 c0s12_5 0 0.3588f
Cc0s12_6 c0s12_6 0 0.2016f
CCc0s12_0 c0s12_0 c0s13_0 0.02291f
CCc0s12_2 c0s12_2 c0s13_2 0.0225f
CCc0s12_4 c0s12_4 c0s13_4 0.0405f
CCc0s12_6 c0s12_6 c0s13_6 0.1206f
Rc0s13_0 c0s13_0 c0s13_1 2.955
Rc0s13_1 c0s13_1 c0s13_2 2.67
Rc0s13_2 c0s13_2 c0s13_3 2.586
Rc0s13_3 c0s13_3 c0s13_4 2.166
Rc0s13_4 c0s13_4 c0s13_5 1.145
Rc0s13_5 c0s13_5 c0s13_6 3.523
Cc0s13_0 c0s13_0 0 0.06365f
Cc0s13_1 c0s13_1 0 0.2416f
Cc0s13_2 c0s13_2 0 0.3504f
Cc0s13_3 c0s13_3 0 0.3168f
Cc0s13_4 c0s13_4 0 0.2207f
Cc0s13_5 c0s13_5 0 0.3112f
Cc0s13_6 c0s13_6 0 0.2349f
CCc0s13_0 c0s13_0 c0s14_0 0.1317f
CCc0s13_2 c0s13_2 c0s14_2 0.09232f
CCc0s13_4 c0s13_4 c0s14_4 0.05125f
CCc0s13_6 c0s13_6 c0s14_6 0.1108f
Rc0s14_0 c0s14_0 c0s14_1 3.694
Rc0s14_1 c0s14_1 c0s14_2 2.264
Rc0s14_2 c0s14_2 c0s14_3 1.462
Rc0s14_3 c0s14_3 c0s14_4 2.437
Rc0s14_4 c0s14_4 c0s14_5 0.6352
Rc0s14_5 c0s14_5 c0s14_6 1.391
Cc0s14_0 c0s14_0 0 0.1129f
Cc0s14_1 c0s14_1 0 0.2639f
Cc0s14_2 c0s14_2 0 0.2484f
Cc0s14_3 c0s14_3 0 0.26f
Cc0s14_4 c0s14_4 0 0.2048f
Cc0s14_5 c0s14_5 0 0.1351f
Cc0s14_6 c0s14_6 0 0.09271f
CCc0s14_0 c0s14_0 c0s15_0 0.1555f
CCc0s14_2 c0s14_2 c0s15_2 0.1426f
CCc0s14_4 c0s14_4 c0s15_4 0.06289f
CCc0s14_6 c0s14_6 c0s15_6 0.1402f
Rc0s15_0 c0s15_0 c0s15_1 3.428
Rc0s15_1 c0s15_1 c0s15_2 3.409
Rc0s15_2 c0s15_2 c0s15_3 2.793
Rc0s15_3 c0s15_3 c0s15_4 1.761
Rc0s15_4 c0s15_4 c0s15_5 1.245
Rc0s15_5 c0s15_5 c0s15_6 0.4767
Cc0s15_0 c0s15_0 0 0.09518f
Cc0s15_1 c0s15_1 0 0.3224f
Cc0s15_2 c0s15_2 0 0.4135f
Cc0s15_3 c0s15_3 0 0.3036f
Cc0s15_4 c0s15_4 0 0.2004f
Cc0s15_5 c0s15_5 0 0.1148f
Cc0s15_6 c0s15_6 0 0.03178f
CCc0s15_0 c0s15_0 c0s16_0 0.143f
CCc0s15_2 c0s15_2 c0s16_2 0.02531f
CCc0s15_4 c0s15_4 c0s16_4 0.1347f
CCc0s15_6 c0s15_6 c0s16_6 0.1547f
Rc0s16_0 c0s16_0 c0s16_1 4.246
Rc0s16_1 c0s16_1 c0s16_2 0.9903
Rc0s16_2 c0s16_2 c0s16_3 3.184
Rc0s16_3 c0s16_3 c0s16_4 3.517
Rc0s16_4 c0s16_4 c0s16_5 2.668
Rc0s16_5 c0s16_5 c0s16_6 2.053
Cc0s16_0 c0s16_0 0 0.1498f
Cc0s16_1 c0s16_1 0 0.2158f
Cc0s16_2 c0s16_2 0 0.2783f
Cc0s16_3 c0s16_3 0 0.4467f
Cc0s16_4 c0s16_4 0 0.4123f
Cc0s16_5 c0s16_5 0 0.3147f
Cc0s16_6 c0s16_6 0 0.1369f
CCc0s16_0 c0s16_0 c0s17_0 0.07292f
CCc0s16_2 c0s16_2 c0s17_2 0.06857f
CCc0s16_4 c0s16_4 c0s17_4 0.04881f
CCc0s16_6 c0s16_6 c0s17_6 0.1144f
Rc0s17_0 c0s17_0 c0s17_1 3.814
Rc0s17_1 c0s17_1 c0s17_2 1.061
Rc0s17_2 c0s17_2 c0s17_3 0.7789
Rc0s17_3 c0s17_3 c0s17_4 2.548
Rc0s17_4 c0s17_4 c0s17_5 1.383
Rc0s17_5 c0s17_5 c0s17_6 2.024
Cc0s17_0 c0s17_0 0 0.1209f
Cc0s17_1 c0s17_1 0 0.1917f
Cc0s17_2 c0s17_2 0 0.1227f
Cc0s17_3 c0s17_3 0 0.2218f
Cc0s17_4 c0s17_4 0 0.262f
Cc0s17_5 c0s17_5 0 0.2271f
Cc0s17_6 c0s17_6 0 0.135f
CCc0s17_0 c0s17_0 c0s18_0 0.06555f
CCc0s17_2 c0s17_2 c0s18_2 0.142f
CCc0s17_4 c0s17_4 c0s18_4 0.146f
CCc0s17_6 c0s17_6 c0s18_6 0.02253f
Rc0s18_0 c0s18_0 c0s18_1 3.083
Rc0s18_1 c0s18_1 c0s18_2 1.482
Rc0s18_2 c0s18_2 c0s18_3 3.559
Rc0s18_3 c0s18_3 c0s18_4 2.916
Rc0s18_4 c0s18_4 c0s18_5 1.518
Rc0s18_5 c0s18_5 c0s18_6 1.121
Cc0s18_0 c0s18_0 0 0.07218f
Cc0s18_1 c0s18_1 0 0.171f
Cc0s18_2 c0s18_2 0 0.3361f
Cc0s18_3 c0s18_3 0 0.4316f
Cc0s18_4 c0s18_4 0 0.2956f
Cc0s18_5 c0s18_5 0 0.1759f
Cc0s18_6 c0s18_6 0 0.07474f
CCc0s18_0 c0s18_0 c0s19_0 0.1144f
CCc0s18_2 c0s18_2 c0s19_2 0.1373f
CCc0s18_4 c0s18_4 c0s19_4 0.1505f
CCc0s18_6 c0s18_6 c0s19_6 0.06814f
Rc0s19_0 c0s19_0 c0s19_1 5.23
Rc0s19_1 c0s19_1 c0s19_2 2.614
Rc0s19_2 c0s19_2 c0s19_3 1.976
Rc0s19_3 c0s19_3 c0s19_4 3.554
Rc0s19_4 c0s19_4 c0s19_5 1.189
Rc0s19_5 c0s19_5 c0s19_6 2.735
Cc0s19_0 c0s19_0 0 0.2153f
Cc0s19_1 c0s19_1 0 0.3896f
Cc0s19_2 c0s19_2 0 0.306f
Cc0s19_3 c0s19_3 0 0.3687f
Cc0s19_4 c0s19_4 0 0.3162f
Cc0s19_5 c0s19_5 0 0.2616f
Cc0s19_6 c0s19_6 0 0.1823f
CCc0s19_0 c0s19_0 c0s20_0 0.03186f
CCc0s19_2 c0s19_2 c0s20_2 0.04376f
CCc0s19_4 c0s19_4 c0s20_4 0.1475f
CCc0s19_6 c0s19_6 c0s20_6 0.04982f
Rc0s20_0 c0s20_0 c0s20_1 4.841
Rc0s20_1 c0s20_1 c0s20_2 2.341
Rc0s20_2 c0s20_2 c0s20_3 3.1
Rc0s20_3 c0s20_3 c0s20_4 1.61
Rc0s20_4 c0s20_4 c0s20_5 1.522
Rc0s20_5 c0s20_5 c0s20_6 1.367
Cc0s20_0 c0s20_0 0 0.1894f
Cc0s20_1 c0s20_1 0 0.3455f
Cc0s20_2 c0s20_2 0 0.3627f
Cc0s20_3 c0s20_3 0 0.3139f
Cc0s20_4 c0s20_4 0 0.2088f
Cc0s20_5 c0s20_5 0 0.1926f
Cc0s20_6 c0s20_6 0 0.09116f
CCc0s20_0 c0s20_0 c0s21_0 0.1414f
CCc0s20_2 c0s20_2 c0s21_2 0.1046f
CCc0s20_4 c0s20_4 c0s21_4 0.1536f
CCc0s20_6 c0s20_6 c0s21_6 0.1442f
Rc0s21_0 c0s21_0 c0s21_1 2.876
Rc0s21_1 c0s21_1 c0s21_2 2.186
Rc0s21_2 c0s21_2 c0s21_3 0.7785
Rc0s21_3 c0s21_3 c0s21_4 0.5733
Rc0s21_4 c0s21_4 c0s21_5 0.6806
Rc0s21_5 c0s21_5 c0s21_6 3.178
Cc0s21_0 c0s21_0 0 0.05842f
Cc0s21_1 c0s21_1 0 0.2042f
Cc0s21_2 c0s21_2 0 0.1976f
Cc0s21_3 c0s21_3 0 0.09012f
Cc0s21_4 c0s21_4 0 0.08359f
Cc0s21_5 c0s21_5 0 0.2573f
Cc0s21_6 c0s21_6 0 0.2119f
CCc0s21_0 c0s21_0 c0s22_0 0.1303f
CCc0s21_2 c0s21_2 c0s22_2 0.136f
CCc0s21_4 c0s21_4 c0s22_4 0.06773f
CCc0s21_6 c0s21_6 c0s22_6 0.1061f
Rc0s22_0 c0s22_0 c0s22_1 4.913
Rc0s22_1 c0s22_1 c0s22_2 1.641
Rc0s22_2 c0s22_2 c0s22_3 2.248
Rc0s22_3 c0s22_3 c0s22_4 1.155
Rc0s22_4 c0s22_4 c0s22_5 0.7075
Rc0s22_5 c0s22_5 c0s22_6 1.29
Cc0s22_0 c0s22_0 0 0.1942f
Cc0s22_1 c0s22_1 0 0.3036f
Cc0s22_2 c0s22_2 0 0.2593f
Cc0s22_3 c0s22_3 0 0.2268f
Cc0s22_4 c0s22_4 0 0.1241f
Cc0s22_5 c0s22_5 0 0.1332f
Cc0s22_6 c0s22_6 0 0.08601f
CCc0s22_0 c0s22_0 c0s23_0 0.1447f
CCc0s22_2 c0s22_2 c0s23_2 0.09902f
CCc0s22_4 c0s22_4 c0s23_4 0.1495f
CCc0s22_6 c0s22_6 c0s23_6 0.08409f
Rc0s23_0 c0s23_0 c0s23_1 3.323
Rc0s23_1 c0s23_1 c0s23_2 2.929
Rc0s23_2 c0s23_2 c0s23_3 3.057
Rc0s23_3 c0s23_3 c0s23_4 0.489
Rc0s23_4 c0s23_4 c0s23_5 2.562
Rc0s23_5 c0s23_5 c0s23_6 0.7388
Cc0s23_0 c0s23_0 0 0.08821f
Cc0s23_1 c0s23_1 0 0.2835f
Cc0s23_2 c0s23_2 0 0.3991f
Cc0s23_3 c0s23_3 0 0.2364f
Cc0s23_4 c0s23_4 0 0.2034f
Cc0s23_5 c0s23_5 0 0.22f
Cc0s23_6 c0s23_6 0 0.04925f
CCc0s23_0 c0s23_0 c0s24_0 0.03611f
CCc0s23_2 c0s23_2 c0s24_2 0.1439f
CCc0s23_4 c0s23_4 c0s24_4 0.0256f
CCc0s23_6 c0s23_6 c0s24_6 0.05355f
Rc0s24_0 c0s24_0 c0s24_1 5.563
Rc0s24_1 c0s24_1 c0s24_2 1.776
Rc0s24_2 c0s24_2 c0s24_3 0.814
Rc0s24_3 c0s24_3 c0s24_4 0.9773
Rc0s24_4 c0s24_4 c0s24_5 1.21
Rc0s24_5 c0s24_5 c0s24_6 2.794
Cc0s24_0 c0s24_0 0 0.2375f
Cc0s24_1 c0s24_1 0 0.3559f
Cc0s24_2 c0s24_2 0 0.1727f
Cc0s24_3 c0s24_3 0 0.1194f
Cc0s24_4 c0s24_4 0 0.1458f
Cc0s24_5 c0s24_5 0 0.2669f
Cc0s24_6 c0s24_6 0 0.1862f
CCc0s24_0 c0s24_0 c0s25_0 0.0344f
CCc0s24_2 c0s24_2 c0s25_2 0.1475f
CCc0s24_4 c0s24_4 c0s25_4 0.07296f
CCc0s24_6 c0s24_6 c0s25_6 0.1558f
Rc0s25_0 c0s25_0 c0s25_1 5.314
Rc0s25_1 c0s25_1 c0s25_2 1.376
Rc0s25_2 c0s25_2 c0s25_3 1.248
Rc0s25_3 c0s25_3 c0s25_4 1.953
Rc0s25_4 c0s25_4 c0s25_5 0.7654
Rc0s25_5 c0s25_5 c0s25_6 2.504
Cc0s25_0 c0s25_0 0 0.2209f
Cc0s25_1 c0s25_1 0 0.3127f
Cc0s25_2 c0s25_2 0 0.175f
Cc0s25_3 c0s25_3 0 0.2134f
Cc0s25_4 c0s25_4 0 0.1812f
Cc0s25_5 c0s25_5 0 0.218f
Cc0s25_6 c0s25_6 0 0.1669f
CCc0s25_0 c0s25_0 c0s26_0 0.02555f
CCc0s25_2 c0s25_2 c0s26_2 0.02147f
CCc0s25_4 c0s25_4 c0s26_4 0.1576f
CCc0s25_6 c0s25_6 c0s26_6 0.06138f
Rc0s26_0 c0s26_0 c0s26_1 4.329
Rc0s26_1 c0s26_1 c0s26_2 1.867
Rc0s26_2 c0s26_2 c0s26_3 1.437
Rc0s26_3 c0s26_3 c0s26_4 0.6483
Rc0s26_4 c0s26_4 c0s26_5 3.327
Rc0s26_5 c0s26_5 c0s26_6 3.505
Cc0s26_0 c0s26_0 0 0.1553f
Cc0s26_1 c0s26_1 0 0.2797f
Cc0s26_2 c0s26_2 0 0.2203f
Cc0s26_3 c0s26_3 0 0.139f
Cc0s26_4 c0s26_4 0 0.265f
Cc0s26_5 c0s26_5 0 0.4555f
Cc0s26_6 c0s26_6 0 0.2337f
CCc0s26_0 c0s26_0 c0s27_0 0.1558f
CCc0s26_2 c0s26_2 c0s27_2 0.03559f
CCc0s26_4 c0s26_4 c0s27_4 0.05013f
CCc0s26_6 c0s26_6 c0s27_6 0.1065f
Rc0s27_0 c0s27_0 c0s27_1 5.537
Rc0s27_1 c0s27_1 c0s27_2 2.16
Rc0s27_2 c0s27_2 c0s27_3 2.618
Rc0s27_3 c0s27_3 c0s27_4 2.535
Rc0s27_4 c0s27_4 c0s27_5 1.266
Rc0s27_5 c0s27_5 c0s27_6 2.156
Cc0s27_0 c0s27_0 0 0.2358f
Cc0s27_1 c0s27_1 0 0.3798f
Cc0s27_2 c0s27_2 0 0.3185f
Cc0s27_3 c0s27_3 0 0.3435f
Cc0s27_4 c0s27_4 0 0.2534f
Cc0s27_5 c0s27_5 0 0.2281f
Cc0s27_6 c0s27_6 0 0.1437f
CCc0s27_0 c0s27_0 c0s28_0 0.06302f
CCc0s27_2 c0s27_2 c0s28_2 0.05449f
CCc0s27_4 c0s27_4 c0s28_4 0.03139f
CCc0s27_6 c0s27_6 c0s28_6 0.05931f
Rc0s28_0 c0s28_0 c0s28_1 5.548
Rc0s28_1 c0s28_1 c0s28_2 1.861
Rc0s28_2 c0s28_2 c0s28_3 2.504
Rc0s28_3 c0s28_3 c0s28_4 2.477
Rc0s28_4 c0s28_4 c0s28_5 3.413
Rc0s28_5 c0s28_5 c0s28_6 1.68
Cc0s28_0 c0s28_0 0 0.2365f
Cc0s28_1 c0s28_1 0 0.3606f
Cc0s28_2 c0s28_2 0 0.291f
Cc0s28_3 c0s28_3 0 0.3321f
Cc0s28_4 c0s28_4 0 0.3927f
Cc0s28_5 c0s28_5 0 0.3396f
Cc0s28_6 c0s28_6 0 0.112f
CCc0s28_0 c0s28_0 c0s29_0 0.06295f
CCc0s28_2 c0s28_2 c0s29_2 0.06581f
CCc0s28_4 c0s28_4 c0s29_4 0.06434f
CCc0s28_6 c0s28_6 c0s29_6 0.1386f
Rc0s29_0 c0s29_0 c0s29_1 5.265
Rc0s29_1 c0s29_1 c0s29_2 1.404
Rc0s29_2 c0s29_2 c0s29_3 1.503
Rc0s29_3 c0s29_3 c0s29_4 2.164
Rc0s29_4 c0s29_4 c0s29_5 2.274
Rc0s29_5 c0s29_5 c0s29_6 2.327
Cc0s29_0 c0s29_0 0 0.2176f
Cc0s29_1 c0s29_1 0 0.3112f
Cc0s29_2 c0s29_2 0 0.1938f
Cc0s29_3 c0s29_3 0 0.2445f
Cc0s29_4 c0s29_4 0 0.2959f
Cc0s29_5 c0s29_5 0 0.3067f
Cc0s29_6 c0s29_6 0 0.1552f
CCc0s29_0 c0s29_0 c0s30_0 0.05431f
CCc0s29_2 c0s29_2 c0s30_2 0.02285f
CCc0s29_4 c0s29_4 c0s30_4 0.05413f
CCc0s29_6 c0s29_6 c0s30_6 0.03013f
Rc0s30_0 c0s30_0 c0s30_1 4.186
Rc0s30_1 c0s30_1 c0s30_2 0.6734
Rc0s30_2 c0s30_2 c0s30_3 0.6867
Rc0s30_3 c0s30_3 c0s30_4 2.451
Rc0s30_4 c0s30_4 c0s30_5 1.366
Rc0s30_5 c0s30_5 c0s30_6 2.945
Cc0s30_0 c0s30_0 0 0.1458f
Cc0s30_1 c0s30_1 0 0.1906f
Cc0s30_2 c0s30_2 0 0.09067f
Cc0s30_3 c0s30_3 0 0.2092f
Cc0s30_4 c0s30_4 0 0.2545f
Cc0s30_5 c0s30_5 0 0.2874f
Cc0s30_6 c0s30_6 0 0.1964f
CCc0s30_0 c0s30_0 c0s31_0 0.08906f
CCc0s30_2 c0s30_2 c0s31_2 0.1408f
CCc0s30_4 c0s30_4 c0s31_4 0.04159f
CCc0s30_6 c0s30_6 c0s31_6 0.0902f
Rc0s31_0 c0s31_0 c0s31_1 4.954
Rc0s31_1 c0s31_1 c0s31_2 0.6929
Rc0s31_2 c0s31_2 c0s31_3 3.44
Rc0s31_3 c0s31_3 c0s31_4 0.9957
Rc0s31_4 c0s31_4 c0s31_5 2.895
Rc0s31_5 c0s31_5 c0s31_6 3.552
Cc0s31_0 c0s31_0 0 0.1969f
Cc0s31_1 c0s31_1 0 0.2431f
Cc0s31_2 c0s31_2 0 0.2755f
Cc0s31_3 c0s31_3 0 0.2957f
Cc0s31_4 c0s31_4 0 0.2594f
Cc0s31_5 c0s31_5 0 0.4298f
Cc0s31_6 c0s31_6 0 0.2368f
CCc0s31_0 c0s31_0 c0s32_0 0.135f
CCc0s31_2 c0s31_2 c0s32_2 0.06477f
CCc0s31_4 c0s31_4 c0s32_4 0.03496f
CCc0s31_6 c0s31_6 c0s32_6 0.09201f
Rc0s32_0 c0s32_0 c0s32_1 5.346
Rc0s32_1 c0s32_1 c0s32_2 1.374
Rc0s32_2 c0s32_2 c0s32_3 3.265
Rc0s32_3 c0s32_3 c0s32_4 0.8963
Rc0s32_4 c0s32_4 c0s32_5 3.318
Rc0s32_5 c0s32_5 c0s32_6 0.55
Cc0s32_0 c0s32_0 0 0.2231f
Cc0s32_1 c0s32_1 0 0.3147f
Cc0s32_2 c0s32_2 0 0.3093f
Cc0s32_3 c0s32_3 0 0.2774f
Cc0s32_4 c0s32_4 0 0.281f
Cc0s32_5 c0s32_5 0 0.2579f
Cc0s32_6 c0s32_6 0 0.03667f
CCc0s32_0 c0s32_0 c0s33_0 0.06425f
CCc0s32_2 c0s32_2 c0s33_2 0.1464f
CCc0s32_4 c0s32_4 c0s33_4 0.1325f
CCc0s32_6 c0s32_6 c0s33_6 0.147f
Rc0s33_0 c0s33_0 c0s33_1 5.098
Rc0s33_1 c0s33_1 c0s33_2 2.8
Rc0s33_2 c0s33_2 c0s33_3 2.622
Rc0s33_3 c0s33_3 c0s33_4 1.011
Rc0s33_4 c0s33_4 c0s33_5 1.813
Rc0s33_5 c0s33_5 c0s33_6 0.9474
Cc0s33_0 c0s33_0 0 0.2066f
Cc0s33_1 c0s33_1 0 0.3932f
Cc0s33_2 c0s33_2 0 0.3615f
Cc0s33_3 c0s33_3 0 0.2422f
Cc0s33_4 c0s33_4 0 0.1883f
Cc0s33_5 c0s33_5 0 0.184f
Cc0s33_6 c0s33_6 0 0.06316f
CCc0s33_0 c0s33_0 c0s34_0 0.1201f
CCc0s33_2 c0s33_2 c0s34_2 0.1135f
CCc0s33_4 c0s33_4 c0s34_4 0.05536f
CCc0s33_6 c0s33_6 c0s34_6 0.02902f
Rc0s34_0 c0s34_0 c0s34_1 5.485
Rc0s34_1 c0s34_1 c0s34_2 2.996
Rc0s34_2 c0s34_2 c0s34_3 2.18
Rc0s34_3 c0s34_3 c0s34_4 2.155
Rc0s34_4 c0s34_4 c0s34_5 3.132
Rc0s34_5 c0s34_5 c0s34_6 1.878
Cc0s34_0 c0s34_0 0 0.2323f
Cc0s34_1 c0s34_1 0 0.432f
Cc0s34_2 c0s34_2 0 0.3451f
Cc0s34_3 c0s34_3 0 0.289f
Cc0s34_4 c0s34_4 0 0.3525f
Cc0s34_5 c0s34_5 0 0.334f
Cc0s34_6 c0s34_6 0 0.1252f
CCc0s34_0 c0s34_0 c0s35_0 0.0754f
CCc0s34_2 c0s34_2 c0s35_2 0.06741f
CCc0s34_4 c0s34_4 c0s35_4 0.05612f
CCc0s34_6 c0s34_6 c0s35_6 0.02342f
Rc0s35_0 c0s35_0 c0s35_1 4.486
Rc0s35_1 c0s35_1 c0s35_2 1.763
Rc0s35_2 c0s35_2 c0s35_3 2.247
Rc0s35_3 c0s35_3 c0s35_4 0.6463
Rc0s35_4 c0s35_4 c0s35_5 1.568
Rc0s35_5 c0s35_5 c0s35_6 0.8856
Cc0s35_0 c0s35_0 0 0.1658f
Cc0s35_1 c0s35_1 0 0.2833f
Cc0s35_2 c0s35_2 0 0.2673f
Cc0s35_3 c0s35_3 0 0.1929f
Cc0s35_4 c0s35_4 0 0.1476f
Cc0s35_5 c0s35_5 0 0.1636f
Cc0s35_6 c0s35_6 0 0.05904f
CCc0s35_0 c0s35_0 c0s36_0 0.03752f
CCc0s35_2 c0s35_2 c0s36_2 0.05628f
CCc0s35_4 c0s35_4 c0s36_4 0.1361f
CCc0s35_6 c0s35_6 c0s36_6 0.07569f
Rc0s36_0 c0s36_0 c0s36_1 3.713
Rc0s36_1 c0s36_1 c0s36_2 2.379
Rc0s36_2 c0s36_2 c0s36_3 1.186
Rc0s36_3 c0s36_3 c0s36_4 0.4736
Rc0s36_4 c0s36_4 c0s36_5 2.115
Rc0s36_5 c0s36_5 c0s36_6 2.028
Cc0s36_0 c0s36_0 0 0.1142f
Cc0s36_1 c0s36_1 0 0.2728f
Cc0s36_2 c0s36_2 0 0.2377f
Cc0s36_3 c0s36_3 0 0.1106f
Cc0s36_4 c0s36_4 0 0.1726f
Cc0s36_5 c0s36_5 0 0.2762f
Cc0s36_6 c0s36_6 0 0.1352f
CCc0s36_0 c0s36_0 c0s37_0 0.1108f
CCc0s36_2 c0s36_2 c0s37_2 0.08136f
CCc0s36_4 c0s36_4 c0s37_4 0.1161f
CCc0s36_6 c0s36_6 c0s37_6 0.1224f
Rc0s37_0 c0s37_0 c0s37_1 3.201
Rc0s37_1 c0s37_1 c0s37_2 2.009
Rc0s37_2 c0s37_2 c0s37_3 1.958
Rc0s37_3 c0s37_3 c0s37_4 1.159
Rc0s37_4 c0s37_4 c0s37_5 1.749
Rc0s37_5 c0s37_5 c0s37_6 2.215
Cc0s37_0 c0s37_0 0 0.08006f
Cc0s37_1 c0s37_1 0 0.214f
Cc0s37_2 c0s37_2 0 0.2645f
Cc0s37_3 c0s37_3 0 0.2078f
Cc0s37_4 c0s37_4 0 0.1938f
Cc0s37_5 c0s37_5 0 0.2643f
Cc0s37_6 c0s37_6 0 0.1477f
CCc0s37_0 c0s37_0 c0s38_0 0.147f
CCc0s37_2 c0s37_2 c0s38_2 0.1485f
CCc0s37_4 c0s37_4 c0s38_4 0.05853f
CCc0s37_6 c0s37_6 c0s38_6 0.1105f
Rc0s38_0 c0s38_0 c0s38_1 2.602
Rc0s38_1 c0s38_1 c0s38_2 0.6754
Rc0s38_2 c0s38_2 c0s38_3 2.062
Rc0s38_3 c0s38_3 c0s38_4 3.214
Rc0s38_4 c0s38_4 c0s38_5 0.9523
Rc0s38_5 c0s38_5 c0s38_6 2.863
Cc0s38_0 c0s38_0 0 0.04012f
Cc0s38_1 c0s38_1 0 0.08515f
Cc0s38_2 c0s38_2 0 0.1825f
Cc0s38_3 c0s38_3 0 0.3517f
Cc0s38_4 c0s38_4 0 0.2777f
Cc0s38_5 c0s38_5 0 0.2544f
Cc0s38_6 c0s38_6 0 0.1909f
CCc0s38_0 c0s38_0 c0s39_0 0.1436f
CCc0s38_2 c0s38_2 c0s39_2 0.06365f
CCc0s38_4 c0s38_4 c0s39_4 0.117f
CCc0s38_6 c0s38_6 c0s39_6 0.1389f
Rc0s39_0 c0s39_0 c0s39_1 3.621
Rc0s39_1 c0s39_1 c0s39_2 2.659
Rc0s39_2 c0s39_2 c0s39_3 2.77
Rc0s39_3 c0s39_3 c0s39_4 2.323
Rc0s39_4 c0s39_4 c0s39_5 3.147
Rc0s39_5 c0s39_5 c0s39_6 3.274
Cc0s39_0 c0s39_0 0 0.108f
Cc0s39_1 c0s39_1 0 0.2853f
Cc0s39_2 c0s39_2 0 0.3619f
Cc0s39_3 c0s39_3 0 0.3395f
Cc0s39_4 c0s39_4 0 0.3647f
Cc0s39_5 c0s39_5 0 0.4281f
Cc0s39_6 c0s39_6 0 0.2183f
CCc0s39_0 c0s39_0 c0s40_0 0.1544f
CCc0s39_2 c0s39_2 c0s40_2 0.09997f
CCc0s39_4 c0s39_4 c0s40_4 0.04468f
CCc0s39_6 c0s39_6 c0s40_6 0.05508f
Rc0s40_0 c0s40_0 c0s40_1 3.135
Rc0s40_1 c0s40_1 c0s40_2 2.244
Rc0s40_2 c0s40_2 c0s40_3 2.837
Rc0s40_3 c0s40_3 c0s40_4 0.6142
Rc0s40_4 c0s40_4 c0s40_5 2.597
Rc0s40_5 c0s40_5 c0s40_6 2.709
Cc0s40_0 c0s40_0 0 0.0757f
Cc0s40_1 c0s40_1 0 0.2253f
Cc0s40_2 c0s40_2 0 0.3387f
Cc0s40_3 c0s40_3 0 0.2301f
Cc0s40_4 c0s40_4 0 0.2141f
Cc0s40_5 c0s40_5 0 0.3537f
Cc0s40_6 c0s40_6 0 0.1806f
CCc0s40_0 c0s40_0 c0s41_0 0.06872f
CCc0s40_2 c0s40_2 c0s41_2 0.09211f
CCc0s40_4 c0s40_4 c0s41_4 0.04307f
CCc0s40_6 c0s40_6 c0s41_6 0.1222f
Rc0s41_0 c0s41_0 c0s41_1 2.578
Rc0s41_1 c0s41_1 c0s41_2 3.541
Rc0s41_2 c0s41_2 c0s41_3 2.995
Rc0s41_3 c0s41_3 c0s41_4 2.43
Rc0s41_4 c0s41_4 c0s41_5 1.293
Rc0s41_5 c0s41_5 c0s41_6 3.326
Cc0s41_0 c0s41_0 0 0.03855f
Cc0s41_1 c0s41_1 0 0.2746f
Cc0s41_2 c0s41_2 0 0.4357f
Cc0s41_3 c0s41_3 0 0.3616f
Cc0s41_4 c0s41_4 0 0.2482f
Cc0s41_5 c0s41_5 0 0.3079f
Cc0s41_6 c0s41_6 0 0.2217f
CCc0s41_0 c0s41_0 c0s42_0 0.1543f
CCc0s41_2 c0s41_2 c0s42_2 0.03948f
CCc0s41_4 c0s41_4 c0s42_4 0.1286f
CCc0s41_6 c0s41_6 c0s42_6 0.1379f
Rc0s42_0 c0s42_0 c0s42_1 4.528
Rc0s42_1 c0s42_1 c0s42_2 2.656
Rc0s42_2 c0s42_2 c0s42_3 1.852
Rc0s42_3 c0s42_3 c0s42_4 3.362
Rc0s42_4 c0s42_4 c0s42_5 3.509
Rc0s42_5 c0s42_5 c0s42_6 1.654
Cc0s42_0 c0s42_0 0 0.1685f
Cc0s42_1 c0s42_1 0 0.3456f
Cc0s42_2 c0s42_2 0 0.3005f
Cc0s42_3 c0s42_3 0 0.3476f
Cc0s42_4 c0s42_4 0 0.4581f
Cc0s42_5 c0s42_5 0 0.3442f
Cc0s42_6 c0s42_6 0 0.1103f
CCc0s42_0 c0s42_0 c0s43_0 0.1324f
CCc0s42_2 c0s42_2 c0s43_2 0.08061f
CCc0s42_4 c0s42_4 c0s43_4 0.04307f
CCc0s42_6 c0s42_6 c0s43_6 0.06557f
Rc0s43_0 c0s43_0 c0s43_1 2.848
Rc0s43_1 c0s43_1 c0s43_2 3.313
Rc0s43_2 c0s43_2 c0s43_3 3.472
Rc0s43_3 c0s43_3 c0s43_4 0.8254
Rc0s43_4 c0s43_4 c0s43_5 2.342
Rc0s43_5 c0s43_5 c0s43_6 1.736
Cc0s43_0 c0s43_0 0 0.05653f
Cc0s43_1 c0s43_1 0 0.2774f
Cc0s43_2 c0s43_2 0 0.4523f
Cc0s43_3 c0s43_3 0 0.2865f
Cc0s43_4 c0s43_4 0 0.2112f
Cc0s43_5 c0s43_5 0 0.2719f
Cc0s43_6 c0s43_6 0 0.1157f
CCc0s43_0 c0s43_0 c0s44_0 0.03653f
CCc0s43_2 c0s43_2 c0s44_2 0.06137f
CCc0s43_4 c0s43_4 c0s44_4 0.05475f
CCc0s43_6 c0s43_6 c0s44_6 0.1249f
Rc0s44_0 c0s44_0 c0s44_1 2.463
Rc0s44_1 c0s44_1 c0s44_2 1.048
Rc0s44_2 c0s44_2 c0s44_3 1.832
Rc0s44_3 c0s44_3 c0s44_4 0.5163
Rc0s44_4 c0s44_4 c0s44_5 2.427
Rc0s44_5 c0s44_5 c0s44_6 2.358
Cc0s44_0 c0s44_0 0 0.03084f
Cc0s44_1 c0s44_1 0 0.1007f
Cc0s44_2 c0s44_2 0 0.192f
Cc0s44_3 c0s44_3 0 0.1566f
Cc0s44_4 c0s44_4 0 0.1962f
Cc0s44_5 c0s44_5 0 0.319f
Cc0s44_6 c0s44_6 0 0.1572f
CCc0s44_0 c0s44_0 c0s45_0 0.1369f
CCc0s44_2 c0s44_2 c0s45_2 0.04892f
CCc0s44_4 c0s44_4 c0s45_4 0.05987f
CCc0s44_6 c0s44_6 c0s45_6 0.09593f
Rc0s45_0 c0s45_0 c0s45_1 3.311
Rc0s45_1 c0s45_1 c0s45_2 2.295
Rc0s45_2 c0s45_2 c0s45_3 1.24
Rc0s45_3 c0s45_3 c0s45_4 2.603
Rc0s45_4 c0s45_4 c0s45_5 2.942
Rc0s45_5 c0s45_5 c0s45_6 2.997
Cc0s45_0 c0s45_0 0 0.08738f
Cc0s45_1 c0s45_1 0 0.2404f
Cc0s45_2 c0s45_2 0 0.2357f
Cc0s45_3 c0s45_3 0 0.2562f
Cc0s45_4 c0s45_4 0 0.3697f
Cc0s45_5 c0s45_5 0 0.3959f
Cc0s45_6 c0s45_6 0 0.1998f
CCc0s45_0 c0s45_0 c0s46_0 0.1563f
CCc0s45_2 c0s45_2 c0s46_2 0.09635f
CCc0s45_4 c0s45_4 c0s46_4 0.08871f
CCc0s45_6 c0s45_6 c0s46_6 0.1398f
Rc0s46_0 c0s46_0 c0s46_1 4.873
Rc0s46_1 c0s46_1 c0s46_2 2.247
Rc0s46_2 c0s46_2 c0s46_3 1.657
Rc0s46_3 c0s46_3 c0s46_4 1.345
Rc0s46_4 c0s46_4 c0s46_5 0.7906
Rc0s46_5 c0s46_5 c0s46_6 2.994
Cc0s46_0 c0s46_0 0 0.1915f
Cc0s46_1 c0s46_1 0 0.3413f
Cc0s46_2 c0s46_2 0 0.2603f
Cc0s46_3 c0s46_3 0 0.2001f
Cc0s46_4 c0s46_4 0 0.1424f
Cc0s46_5 c0s46_5 0 0.2523f
Cc0s46_6 c0s46_6 0 0.1996f
CCc0s46_0 c0s46_0 c0s47_0 0.03653f
CCc0s46_2 c0s46_2 c0s47_2 0.1246f
CCc0s46_4 c0s46_4 c0s47_4 0.09634f
CCc0s46_6 c0s46_6 c0s47_6 0.1551f
Rc0s47_0 c0s47_0 c0s47_1 4.847
Rc0s47_1 c0s47_1 c0s47_2 3.517
Rc0s47_2 c0s47_2 c0s47_3 0.8803
Rc0s47_3 c0s47_3 c0s47_4 2.026
Rc0s47_4 c0s47_4 c0s47_5 2.254
Rc0s47_5 c0s47_5 c0s47_6 1.43
Cc0s47_0 c0s47_0 0 0.1898f
Cc0s47_1 c0s47_1 0 0.4243f
Cc0s47_2 c0s47_2 0 0.2931f
Cc0s47_3 c0s47_3 0 0.1938f
Cc0s47_4 c0s47_4 0 0.2853f
Cc0s47_5 c0s47_5 0 0.2456f
Cc0s47_6 c0s47_6 0 0.09536f
CCc0s47_0 c0s47_0 c0s48_0 0.09042f
CCc0s47_2 c0s47_2 c0s48_2 0.06995f
CCc0s47_4 c0s47_4 c0s48_4 0.09398f
CCc0s47_6 c0s47_6 c0s48_6 0.02012f
Rc0s48_0 c0s48_0 c0s48_1 3.843
Rc0s48_1 c0s48_1 c0s48_2 1.866
Rc0s48_2 c0s48_2 c0s48_3 1.41
Rc0s48_3 c0s48_3 c0s48_4 1.708
Rc0s48_4 c0s48_4 c0s48_5 2.917
Rc0s48_5 c0s48_5 c0s48_6 2.603
Cc0s48_0 c0s48_0 0 0.1229f
Cc0s48_1 c0s48_1 0 0.2473f
Cc0s48_2 c0s48_2 0 0.2184f
Cc0s48_3 c0s48_3 0 0.2079f
Cc0s48_4 c0s48_4 0 0.3083f
Cc0s48_5 c0s48_5 0 0.368f
Cc0s48_6 c0s48_6 0 0.1735f
CCc0s48_0 c0s48_0 c0s49_0 0.08892f
Cc0s49_0 c0s49_0 0 0f
CCc0s49_0 c0s49_0 c1s0_0 0.1107f
Rc1s0_0 c1s0_0 c1s0_1 3.639
Rc1s0_1 c1s0_1 c1s0_2 1.092
Rc1s0_2 c1s0_2 c1s0_3 0.4622
Rc1s0_3 c1s0_3 c1s0_4 1.325
Rc1s0_4 c1s0_4 c1s0_5 2.334
Rc1s0_5 c1s0_5 c1s0_6 3.227
Cc1s0_0 c1s0_0 0 0.1093f
Cc1s0_1 c1s0_1 0 0.1821f
Cc1s0_2 c1s0_2 0 0.1036f
Cc1s0_3 c1s0_3 0 0.1191f
Cc1s0_4 c1s0_4 0 0.2439f
Cc1s0_5 c1s0_5 0 0.3708f
Cc1s0_6 c1s0_6 0 0.2151f
CCc1s0_0 c1s0_0 c1s1_0 0.1361f
CCc1s0_2 c1s0_2 c1s1_2 0.09153f
CCc1s0_4 c1s0_4 c1s1_4 0.1582f
CCc1s0_6 c1s0_6 c1s1_6 0.08462f
Rc1s1_0 c1s1_0 c1s1_1 5.079
Rc1s1_1 c1s1_1 c1s1_2 1.738
Rc1s1_2 c1s1_2 c1s1_3 2.796
Rc1s1_3 c1s1_3 c1s1_4 3.561
Rc1s1_4 c1s1_4 c1s1_5 1.412
Rc1s1_5 c1s1_5 c1s1_6 0.9865
Cc1s1_0 c1s1_0 0 0.2053f
Cc1s1_1 c1s1_1 0 0.3211f
Cc1s1_2 c1s1_2 0 0.3023f
Cc1s1_3 c1s1_3 0 0.4238f
Cc1s1_4 c1s1_4 0 0.3315f
Cc1s1_5 c1s1_5 0 0.1599f
Cc1s1_6 c1s1_6 0 0.06577f
CCc1s1_0 c1s1_0 c1s2_0 0.1068f
CCc1s1_2 c1s1_2 c1s2_2 0.09433f
CCc1s1_4 c1s1_4 c1s2_4 0.07032f
CCc1s1_6 c1s1_6 c1s2_6 0.02049f
Rc1s2_0 c1s2_0 c1s2_1 3.676
Rc1s2_1 c1s2_1 c1s2_2 1.791
Rc1s2_2 c1s2_2 c1s2_3 1.727
Rc1s2_3 c1s2_3 c1s2_4 3.163
Rc1s2_4 c1s2_4 c1s2_5 2.291
Rc1s2_5 c1s2_5 c1s2_6 2.762
Cc1s2_0 c1s2_0 0 0.1117f
Cc1s2_1 c1s2_1 0 0.2312f
Cc1s2_2 c1s2_2 0 0.2345f
Cc1s2_3 c1s2_3 0 0.326f
Cc1s2_4 c1s2_4 0 0.3636f
Cc1s2_5 c1s2_5 0 0.3368f
Cc1s2_6 c1s2_6 0 0.1841f
CCc1s2_0 c1s2_0 c1s3_0 0.1457f
CCc1s2_2 c1s2_2 c1s3_2 0.1248f
CCc1s2_4 c1s2_4 c1s3_4 0.08898f
CCc1s2_6 c1s2_6 c1s3_6 0.1244f
Rc1s3_0 c1s3_0 c1s3_1 4.467
Rc1s3_1 c1s3_1 c1s3_2 2.494
Rc1s3_2 c1s3_2 c1s3_3 2.433
Rc1s3_3 c1s3_3 c1s3_4 1.732
Rc1s3_4 c1s3_4 c1s3_5 2.432
Rc1s3_5 c1s3_5 c1s3_6 2.446
Cc1s3_0 c1s3_0 0 0.1645f
Cc1s3_1 c1s3_1 0 0.3307f
Cc1s3_2 c1s3_2 0 0.3285f
Cc1s3_3 c1s3_3 0 0.2777f
Cc1s3_4 c1s3_4 0 0.2776f
Cc1s3_5 c1s3_5 0 0.3252f
Cc1s3_6 c1s3_6 0 0.1631f
CCc1s3_0 c1s3_0 c1s4_0 0.1512f
CCc1s3_2 c1s3_2 c1s4_2 0.1295f
CCc1s3_4 c1s3_4 c1s4_4 0.1385f
CCc1s3_6 c1s3_6 c1s4_6 0.1274f
Rc1s4_0 c1s4_0 c1s4_1 5.018
Rc1s4_1 c1s4_1 c1s4_2 2.357
Rc1s4_2 c1s4_2 c1s4_3 1.551
Rc1s4_3 c1s4_3 c1s4_4 1.283
Rc1s4_4 c1s4_4 c1s4_5 2.68
Rc1s4_5 c1s4_5 c1s4_6 3.203
Cc1s4_0 c1s4_0 0 0.2012f
Cc1s4_1 c1s4_1 0 0.3584f
Cc1s4_2 c1s4_2 0 0.2605f
Cc1s4_3 c1s4_3 0 0.1889f
Cc1s4_4 c1s4_4 0 0.2642f
Cc1s4_5 c1s4_5 0 0.3922f
Cc1s4_6 c1s4_6 0 0.2135f
CCc1s4_0 c1s4_0 c1s5_0 0.09619f
CCc1s4_2 c1s4_2 c1s5_2 0.04129f
CCc1s4_4 c1s4_4 c1s5_4 0.1366f
CCc1s4_6 c1s4_6 c1s5_6 0.08784f
Rc1s5_0 c1s5_0 c1s5_1 3.921
Rc1s5_1 c1s5_1 c1s5_2 0.593
Rc1s5_2 c1s5_2 c1s5_3 2.057
Rc1s5_3 c1s5_3 c1s5_4 2.796
Rc1s5_4 c1s5_4 c1s5_5 1.781
Rc1s5_5 c1s5_5 c1s5_6 1.569
Cc1s5_0 c1s5_0 0 0.1281f
Cc1s5_1 c1s5_1 0 0.1676f
Cc1s5_2 c1s5_2 0 0.1767f
Cc1s5_3 c1s5_3 0 0.3236f
Cc1s5_4 c1s5_4 0 0.3051f
Cc1s5_5 c1s5_5 0 0.2233f
Cc1s5_6 c1s5_6 0 0.1046f
CCc1s5_0 c1s5_0 c1s6_0 0.112f
CCc1s5_2 c1s5_2 c1s6_2 0.02276f
CCc1s5_4 c1s5_4 c1s6_4 0.091f
CCc1s5_6 c1s5_6 c1s6_6 0.1525f
Rc1s6_0 c1s6_0 c1s6_1 4.625
Rc1s6_1 c1s6_1 c1s6_2 1.716
Rc1s6_2 c1s6_2 c1s6_3 2.62
Rc1s6_3 c1s6_3 c1s6_4 2.356
Rc1s6_4 c1s6_4 c1s6_5 1.108
Rc1s6_5 c1s6_5 c1s6_6 1.104
Cc1s6_0 c1s6_0 0 0.175f
Cc1s6_1 c1s6_1 0 0.2894f
Cc1s6_2 c1s6_2 0 0.2891f
Cc1s6_3 c1s6_3 0 0.3317f
Cc1s6_4 c1s6_4 0 0.2309f
Cc1s6_5 c1s6_5 0 0.1475f
Cc1s6_6 c1s6_6 0 0.07362f
CCc1s6_0 c1s6_0 c1s7_0 0.144f
CCc1s6_2 c1s6_2 c1s7_2 0.05767f
CCc1s6_4 c1s6_4 c1s7_4 0.03048f
CCc1s6_6 c1s6_6 c1s7_6 0.1363f
Rc1s7_0 c1s7_0 c1s7_1 4.098
Rc1s7_1 c1s7_1 c1s7_2 1.61
Rc1s7_2 c1s7_2 c1s7_3 2.061
Rc1s7_3 c1s7_3 c1s7_4 2.771
Rc1s7_4 c1s7_4 c1s7_5 0.9809
Rc1s7_5 c1s7_5 c1s7_6 2.507
Cc1s7_0 c1s7_0 0 0.1399f
Cc1s7_1 c1s7_1 0 0.2472f
Cc1s7_2 c1s7_2 0 0.2447f
Cc1s7_3 c1s7_3 0 0.3221f
Cc1s7_4 c1s7_4 0 0.2501f
Cc1s7_5 c1s7_5 0 0.2325f
Cc1s7_6 c1s7_6 0 0.1671f
CCc1s7_0 c1s7_0 c1s8_0 0.1199f
CCc1s7_2 c1s7_2 c1s8_2 0.1341f
CCc1s7_4 c1s7_4 c1s8_4 0.05777f
CCc1s7_6 c1s7_6 c1s8_6 0.1054f
Rc1s8_0 c1s8_0 c1s8_1 3.181
Rc1s8_1 c1s8_1 c1s8_2 2.217
Rc1s8_2 c1s8_2 c1s8_3 0.9929
Rc1s8_3 c1s8_3 c1s8_4 2.938
Rc1s8_4 c1s8_4 c1s8_5 3.18
Rc1s8_5 c1s8_5 c1s8_6 1.488
Cc1s8_0 c1s8_0 0 0.07874f
Cc1s8_1 c1s8_1 0 0.2266f
Cc1s8_2 c1s8_2 0 0.214f
Cc1s8_3 c1s8_3 0 0.262f
Cc1s8_4 c1s8_4 0 0.4079f
Cc1s8_5 c1s8_5 0 0.3112f
Cc1s8_6 c1s8_6 0 0.09923f
CCc1s8_0 c1s8_0 c1s9_0 0.05112f
CCc1s8_2 c1s8_2 c1s9_2 0.1549f
CCc1s8_4 c1s8_4 c1s9_4 0.1189f
CCc1s8_6 c1s8_6 c1s9_6 0.1381f
Rc1s9_0 c1s9_0 c1s9_1 2.546
Rc1s9_1 c1s9_1 c1s9_2 3.283
Rc1s9_2 c1s9_2 c1s9_3 2.411
Rc1s9_3 c1s9_3 c1s9_4 1.447
Rc1s9_4 c1s9_4 c1s9_5 1.81
Rc1s9_5 c1s9_5 c1s9_6 2.849
Cc1s9_0 c1s9_0 0 0.03641f
Cc1s9_1 c1s9_1 0 0.2553f
Cc1s9_2 c1s9_2 0 0.3796f
Cc1s9_3 c1s9_3 0 0.2572f
Cc1s9_4 c1s9_4 0 0.2171f
Cc1s9_5 c1s9_5 0 0.3106f
Cc1s9_6 c1s9_6 0 0.1899f
CCc1s9_0 c1s9_0 c1s10_0 0.13f
CCc1s9_2 c1s9_2 c1s10_2 0.04659f
CCc1s9_4 c1s9_4 c1s10_4 0.1076f
CCc1s9_6 c1s9_6 c1s10_6 0.04319f
Rc1s10_0 c1s10_0 c1s10_1 5.515
Rc1s10_1 c1s10_1 c1s10_2 1.847
Rc1s10_2 c1s10_2 c1s10_3 3.326
Rc1s10_3 c1s10_3 c1s10_4 2.744
Rc1s10_4 c1s10_4 c1s10_5 2.36
Rc1s10_5 c1s10_5 c1s10_6 1.275
Cc1s10_0 c1s10_0 0 0.2343f
Cc1s10_1 c1s10_1 0 0.3575f
Cc1s10_2 c1s10_2 0 0.3449f
Cc1s10_3 c1s10_3 0 0.4047f
Cc1s10_4 c1s10_4 0 0.3402f
Cc1s10_5 c1s10_5 0 0.2423f
Cc1s10_6 c1s10_6 0 0.08502f
CCc1s10_0 c1s10_0 c1s11_0 0.09372f
CCc1s10_2 c1s10_2 c1s11_2 0.03941f
CCc1s10_4 c1s10_4 c1s11_4 0.03933f
CCc1s10_6 c1s10_6 c1s11_6 0.1202f
Rc1s11_0 c1s11_0 c1s11_1 3.587
Rc1s11_1 c1s11_1 c1s11_2 2.817
Rc1s11_2 c1s11_2 c1s11_3 1.208
Rc1s11_3 c1s11_3 c1s11_4 2.712
Rc1s11_4 c1s11_4 c1s11_5 2.713
Rc1s11_5 c1s11_5 c1s11_6 1.412
Cc1s11_0 c1s11_0 0 0.1058f
Cc1s11_1 c1s11_1 0 0.2936f
Cc1s11_2 c1s11_2 0 0.2683f
Cc1s11_3 c1s11_3 0 0.2613f
Cc1s11_4 c1s11_4 0 0.3617f
Cc1s11_5 c1s11_5 0 0.275f
Cc1s11_6 c1s11_6 0 0.09415f
CCc1s11_0 c1s11_0 c1s12_0 0.03489f
CCc1s11_2 c1s11_2 c1s12_2 0.07558f
CCc1s11_4 c1s11_4 c1s12_4 0.08893f
CCc1s11_6 c1s11_6 c1s12_6 0.034f
Rc1s12_0 c1s12_0 c1s12_1 3.038
Rc1s12_1 c1s12_1 c1s12_2 0.6243
Rc1s12_2 c1s12_2 c1s12_3 2.332
Rc1s12_3 c1s12_3 c1s12_4 3.25
Rc1s12_4 c1s12_4 c1s12_5 1.132
Rc1s12_5 c1s12_5 c1s12_6 0.5593
Cc1s12_0 c1s12_0 0 0.06922f
Cc1s12_1 c1s12_1 0 0.1108f
Cc1s12_2 c1s12_2 0 0.1971f
Cc1s12_3 c1s12_3 0 0.3721f
Cc1s12_4 c1s12_4 0 0.2921f
Cc1s12_5 c1s12_5 0 0.1128f
Cc1s12_6 c1s12_6 0 0.03729f
CCc1s12_0 c1s12_0 c1s13_0 0.1185f
CCc1s12_2 c1s12_2 c1s13_2 0.1341f
CCc1s12_4 c1s12_4 c1s13_4 0.155f
CCc1s12_6 c1s12_6 c1s13_6 0.1058f
Rc1s13_0 c1s13_0 c1s13_1 3.529
Rc1s13_1 c1s13_1 c1s13_2 3.089
Rc1s13_2 c1s13_2 c1s13_3 0.8219
Rc1s13_3 c1s13_3 c1s13_4 2.632
Rc1s13_4 c1s13_4 c1s13_5 0.75
Rc1s13_5 c1s13_5 c1s13_6 1.709
Cc1s13_0 c1s13_0 0 0.1019f
Cc1s13_1 c1s13_1 0 0.3079f
Cc1s13_2 c1s13_2 0 0.2607f
Cc1s13_3 c1s13_3 0 0.2302f
Cc1s13_4 c1s13_4 0 0.2255f
Cc1s13_5 c1s13_5 0 0.1639f
Cc1s13_6 c1s13_6 0 0.1139f
CCc1s13_0 c1s13_0 c1s14_0 0.0893f
CCc1s13_2 c1s13_2 c1s14_2 0.07291f
CCc1s13_4 c1s13_4 c1s14_4 0.0436f
CCc1s13_6 c1s13_6 c1s14_6 0.05244f
Rc1s14_0 c1s14_0 c1s14_1 5.033
Rc1s14_1 c1s14_1 c1s14_2 1.907
Rc1s14_2 c1s14_2 c1s14_3 2.277
Rc1s14_3 c1s14_3 c1s14_4 1.118
Rc1s14_4 c1s14_4 c1s14_5 2.702
Rc1s14_5 c1s14_5 c1s14_6 1.49
Cc1s14_0 c1s14_0 0 0.2022f
Cc1s14_1 c1s14_1 0 0.3294f
Cc1s14_2 c1s14_2 0 0.2789f
Cc1s14_3 c1s14_3 0 0.2263f
Cc1s14_4 c1s14_4 0 0.2546f
Cc1s14_5 c1s14_5 0 0.2795f
Cc1s14_6 c1s14_6 0 0.09932f
CCc1s14_0 c1s14_0 c1s15_0 0.1031f
CCc1s14_2 c1s14_2 c1s15_2 0.1473f
CCc1s14_4 c1s14_4 c1s15_4 0.1592f
CCc1s14_6 c1s14_6 c1s15_6 0.02647f
Rc1s15_0 c1s15_0 c1s15_1 4.962
Rc1s15_1 c1s15_1 c1s15_2 3.151
Rc1s15_2 c1s15_2 c1s15_3 1.457
Rc1s15_3 c1s15_3 c1s15_4 1.657
Rc1s15_4 c1s15_4 c1s15_5 2.278
Rc1s15_5 c1s15_5 c1s15_6 3.344
Cc1s15_0 c1s15_0 0 0.1975f
Cc1s15_1 c1s15_1 0 0.4076f
Cc1s15_2 c1s15_2 0 0.3072f
Cc1s15_3 c1s15_3 0 0.2076f
Cc1s15_4 c1s15_4 0 0.2623f
Cc1s15_5 c1s15_5 0 0.3748f
Cc1s15_6 c1s15_6 0 0.223f
CCc1s15_0 c1s15_0 c1s16_0 0.07599f
CCc1s15_2 c1s15_2 c1s16_2 0.1432f
CCc1s15_4 c1s15_4 c1s16_4 0.1262f
CCc1s15_6 c1s15_6 c1s16_6 0.04132f
Rc1s16_0 c1s16_0 c1s16_1 5.328
Rc1s16_1 c1s16_1 c1s16_2 0.4978
Rc1s16_2 c1s16_2 c1s16_3 0.9073
Rc1s16_3 c1s16_3 c1s16_4 2.544
Rc1s16_4 c1s16_4 c1s16_5 0.6299
Rc1s16_5 c1s16_5 c1s16_6 1.645
Cc1s16_0 c1s16_0 0 0.2219f
Cc1s16_1 c1s16_1 0 0.2551f
Cc1s16_2 c1s16_2 0 0.09368f
Cc1s16_3 c1s16_3 0 0.2301f
Cc1s16_4 c1s16_4 0 0.2116f
Cc1s16_5 c1s16_5 0 0.1517f
Cc1s16_6 c1s16_6 0 0.1097f
CCc1s16_0 c1s16_0 c1s17_0 0.0382f
CCc1s16_2 c1s16_2 c1s17_2 0.0848f
CCc1s16_4 c1s16_4 c1s17_4 0.1376f
CCc1s16_6 c1s16_6 c1s17_6 0.1469f
Rc1s17_0 c1s17_0 c1s17_1 2.562
Rc1s17_1 c1s17_1 c1s17_2 0.6417
Rc1s17_2 c1s17_2 c1s17_3 3.098
Rc1s17_3 c1s17_3 c1s17_4 0.5849
Rc1s17_4 c1s17_4 c1s17_5 1.312
Rc1s17_5 c1s17_5 c1s17_6 0.8199
Cc1s17_0 c1s17_0 0 0.03745f
Cc1s17_1 c1s17_1 0 0.08023f
Cc1s17_2 c1s17_2 0 0.2493f
Cc1s17_3 c1s17_3 0 0.2455f
Cc1s17_4 c1s17_4 0 0.1264f
Cc1s17_5 c1s17_5 0 0.1421f
Cc1s17_6 c1s17_6 0 0.05466f
CCc1s17_0 c1s17_0 c1s18_0 0.03275f
CCc1s17_2 c1s17_2 c1s18_2 0.02387f
CCc1s17_4 c1s17_4 c1s18_4 0.1093f
CCc1s17_6 c1s17_6 c1s18_6 0.1242f
Rc1s18_0 c1s18_0 c1s18_1 4.613
Rc1s18_1 c1s18_1 c1s18_2 3.114
Rc1s18_2 c1s18_2 c1s18_3 2.539
Rc1s18_3 c1s18_3 c1s18_4 1.678
Rc1s18_4 c1s18_4 c1s18_5 2.438
Rc1s18_5 c1s18_5 c1s18_6 3.504
Cc1s18_0 c1s18_0 0 0.1742f
Cc1s18_1 c1s18_1 0 0.3818f
Cc1s18_2 c1s18_2 0 0.3768f
Cc1s18_3 c1s18_3 0 0.2811f
Cc1s18_4 c1s18_4 0 0.2744f
Cc1s18_5 c1s18_5 0 0.3961f
Cc1s18_6 c1s18_6 0 0.2336f
CCc1s18_0 c1s18_0 c1s19_0 0.1098f
CCc1s18_2 c1s18_2 c1s19_2 0.05403f
CCc1s18_4 c1s18_4 c1s19_4 0.02843f
CCc1s18_6 c1s18_6 c1s19_6 0.1509f
Rc1s19_0 c1s19_0 c1s19_1 4.31
Rc1s19_1 c1s19_1 c1s19_2 1.551
Rc1s19_2 c1s19_2 c1s19_3 2.357
Rc1s19_3 c1s19_3 c1s19_4 2.215
Rc1s19_4 c1s19_4 c1s19_5 2.095
Rc1s19_5 c1s19_5 c1s19_6 0.6415
Cc1s19_0 c1s19_0 0 0.154f
Cc1s19_1 c1s19_1 0 0.2574f
Cc1s19_2 c1s19_2 0 0.2605f
Cc1s19_3 c1s19_3 0 0.3048f
Cc1s19_4 c1s19_4 0 0.2873f
Cc1s19_5 c1s19_5 0 0.1824f
Cc1s19_6 c1s19_6 0 0.04277f
CCc1s19_0 c1s19_0 c1s20_0 0.06945f
CCc1s19_2 c1s19_2 c1s20_2 0.07777f
CCc1s19_4 c1s19_4 c1s20_4 0.04791f
CCc1s19_6 c1s19_6 c1s20_6 0.1432f
Rc1s20_0 c1s20_0 c1s20_1 3.786
Rc1s20_1 c1s20_1 c1s20_2 2.537
Rc1s20_2 c1s20_2 c1s20_3 2.698
Rc1s20_3 c1s20_3 c1s20_4 2.791
Rc1s20_4 c1s20_4 c1s20_5 2.722
Rc1s20_5 c1s20_5 c1s20_6 2.819
Cc1s20_0 c1s20_0 0 0.1191f
Cc1s20_1 c1s20_1 0 0.2882f
Cc1s20_2 c1s20_2 0 0.3489f
Cc1s20_3 c1s20_3 0 0.3659f
Cc1s20_4 c1s20_4 0 0.3675f
Cc1s20_5 c1s20_5 0 0.3694f
Cc1s20_6 c1s20_6 0 0.188f
CCc1s20_0 c1s20_0 c1s21_0 0.05522f
CCc1s20_2 c1s20_2 c1s21_2 0.1567f
CCc1s20_4 c1s20_4 c1s21_4 0.04114f
CCc1s20_6 c1s20_6 c1s21_6 0.1486f
Rc1s21_0 c1s21_0 c1s21_1 5.142
Rc1s21_1 c1s21_1 c1s21_2 3.134
Rc1s21_2 c1s21_2 c1s21_3 0.6164
Rc1s21_3 c1s21_3 c1s21_4 0.7373
Rc1s21_4 c1s21_4 c1s21_5 3.011
Rc1s21_5 c1s21_5 c1s21_6 1.928
Cc1s21_0 c1s21_0 0 0.2095f
Cc1s21_1 c1s21_1 0 0.4184f
Cc1s21_2 c1s21_2 0 0.25f
Cc1s21_3 c1s21_3 0 0.09025f
Cc1s21_4 c1s21_4 0 0.2499f
Cc1s21_5 c1s21_5 0 0.3293f
Cc1s21_6 c1s21_6 0 0.1285f
CCc1s21_0 c1s21_0 c1s22_0 0.07184f
CCc1s21_2 c1s21_2 c1s22_2 0.1579f
CCc1s21_4 c1s21_4 c1s22_4 0.02562f
CCc1s21_6 c1s21_6 c1s22_6 0.09441f
Rc1s22_0 c1s22_0 c1s22_1 3.847
Rc1s22_1 c1s22_1 c1s22_2 0.8538
Rc1s22_2 c1s22_2 c1s22_3 1.695
Rc1s22_3 c1s22_3 c1s22_4 2.679
Rc1s22_4 c1s22_4 c1s22_5 3.229
Rc1s22_5 c1s22_5 c1s22_6 0.5276
Cc1s22_0 c1s22_0 0 0.1231f
Cc1s22_1 c1s22_1 0 0.18f
Cc1s22_2 c1s22_2 0 0.1699f
Cc1s22_3 c1s22_3 0 0.2916f
Cc1s22_4 c1s22_4 0 0.3939f
Cc1s22_5 c1s22_5 0 0.2505f
Cc1s22_6 c1s22_6 0 0.03517f
CCc1s22_0 c1s22_0 c1s23_0 0.09343f
CCc1s22_2 c1s22_2 c1s23_2 0.03265f
CCc1s22_4 c1s22_4 c1s23_4 0.1321f
CCc1s22_6 c1s22_6 c1s23_6 0.03201f
Rc1s23_0 c1s23_0 c1s23_1 2.558
Rc1s23_1 c1s23_1 c1s23_2 1.66
Rc1s23_2 c1s23_2 c1s23_3 2.758
Rc1s23_3 c1s23_3 c1s23_4 1.437
Rc1s23_4 c1s23_4 c1s23_5 0.8595
Rc1s23_5 c1s23_5 c1s23_6 2.953
Cc1s23_0 c1s23_0 0 0.03718f
Cc1s23_1 c1s23_1 0 0.1479f
Cc1s23_2 c1s23_2 0 0.2945f
Cc1s23_3 c1s23_3 0 0.2796f
Cc1s23_4 c1s23_4 0 0.1531f
Cc1s23_5 c1s23_5 0 0.2542f
Cc1s23_6 c1s23_6 0 0.1969f
CCc1s23_0 c1s23_0 c1s24_0 0.133f
CCc1s23_2 c1s23_2 c1s24_2 0.1398f
CCc1s23_4 c1s23_4 c1s24_4 0.06252f
CCc1s23_6 c1s23_6 c1s24_6 0.07948f
Rc1s24_0 c1s24_0 c1s24_1 3.223
Rc1s24_1 c1s24_1 c1s24_2 2.205
Rc1s24_2 c1s24_2 c1s24_3 1.49
Rc1s24_3 c1s24_3 c1s24_4 1.517
Rc1s24_4 c1s24_4 c1s24_5 2.918
Rc1s24_5 c1s24_5 c1s24_6 3.462
Cc1s24_0 c1s24_0 0 0.08153f
Cc1s24_1 c1s24_1 0 0.2285f
Cc1s24_2 c1s24_2 0 0.2463f
Cc1s24_3 c1s24_3 0 0.2004f
Cc1s24_4 c1s24_4 0 0.2957f
Cc1s24_5 c1s24_5 0 0.4254f
Cc1s24_6 c1s24_6 0 0.2308f
CCc1s24_0 c1s24_0 c1s25_0 0.1018f
CCc1s24_2 c1s24_2 c1s25_2 0.03466f
CCc1s24_4 c1s24_4 c1s25_4 0.1114f
CCc1s24_6 c1s24_6 c1s25_6 0.08281f
Rc1s25_0 c1s25_0 c1s25_1 5.562
Rc1s25_1 c1s25_1 c1s25_2 2.716
Rc1s25_2 c1s25_2 c1s25_3 3.08
Rc1s25_3 c1s25_3 c1s25_4 2.659
Rc1s25_4 c1s25_4 c1s25_5 2.137
Rc1s25_5 c1s25_5 c1s25_6 3.275
Cc1s25_0 c1s25_0 0 0.2375f
Cc1s25_1 c1s25_1 0 0.4186f
Cc1s25_2 c1s25_2 0 0.3864f
Cc1s25_3 c1s25_3 0 0.3826f
Cc1s25_4 c1s25_4 0 0.3198f
Cc1s25_5 c1s25_5 0 0.3608f
Cc1s25_6 c1s25_6 0 0.2183f
CCc1s25_0 c1s25_0 c1s26_0 0.1364f
CCc1s25_2 c1s25_2 c1s26_2 0.06079f
CCc1s25_4 c1s25_4 c1s26_4 0.04198f
CCc1s25_6 c1s25_6 c1s26_6 0.07185f
Rc1s26_0 c1s26_0 c1s26_1 4.091
Rc1s26_1 c1s26_1 c1s26_2 0.7567
Rc1s26_2 c1s26_2 c1s26_3 1.538
Rc1s26_3 c1s26_3 c1s26_4 2.261
Rc1s26_4 c1s26_4 c1s26_5 0.5873
Rc1s26_5 c1s26_5 c1s26_6 3.017
Cc1s26_0 c1s26_0 0 0.1394f
Cc1s26_1 c1s26_1 0 0.1899f
Cc1s26_2 c1s26_2 0 0.153f
Cc1s26_3 c1s26_3 0 0.2533f
Cc1s26_4 c1s26_4 0 0.1899f
Cc1s26_5 c1s26_5 0 0.2403f
Cc1s26_6 c1s26_6 0 0.2011f
CCc1s26_0 c1s26_0 c1s27_0 0.1112f
CCc1s26_2 c1s26_2 c1s27_2 0.06391f
CCc1s26_4 c1s26_4 c1s27_4 0.06176f
CCc1s26_6 c1s26_6 c1s27_6 0.06937f
Rc1s27_0 c1s27_0 c1s27_1 3.475
Rc1s27_1 c1s27_1 c1s27_2 2.808
Rc1s27_2 c1s27_2 c1s27_3 2.028
Rc1s27_3 c1s27_3 c1s27_4 2.107
Rc1s27_4 c1s27_4 c1s27_5 0.9186
Rc1s27_5 c1s27_5 c1s27_6 3.33
Cc1s27_0 c1s27_0 0 0.09831f
Cc1s27_1 c1s27_1 0 0.2855f
Cc1s27_2 c1s27_2 0 0.3224f
Cc1s27_3 c1s27_3 0 0.2757f
Cc1s27_4 c1s27_4 0 0.2017f
Cc1s27_5 c1s27_5 0 0.2833f
Cc1s27_6 c1s27_6 0 0.222f
CCc1s27_0 c1s27_0 c1s28_0 0.06558f
CCc1s27_2 c1s27_2 c1s28_2 0.06586f
CCc1s27_4 c1s27_4 c1s28_4 0.02964f
CCc1s27_6 c1s27_6 c1s28_6 0.1571f
Rc1s28_0 c1s28_0 c1s28_1 3.961
Rc1s28_1 c1s28_1 c1s28_2 3.326
Rc1s28_2 c1s28_2 c1s28_3 3.372
Rc1s28_3 c1s28_3 c1s28_4 3.505
Rc1s28_4 c1s28_4 c1s28_5 3.019
Rc1s28_5 c1s28_5 c1s28_6 3.365
Cc1s28_0 c1s28_0 0 0.1307f
Cc1s28_1 c1s28_1 0 0.3524f
Cc1s28_2 c1s28_2 0 0.4465f
Cc1s28_3 c1s28_3 0 0.4584f
Cc1s28_4 c1s28_4 0 0.4349f
Cc1s28_5 c1s28_5 0 0.4256f
Cc1s28_6 c1s28_6 0 0.2243f
CCc1s28_0 c1s28_0 c1s29_0 0.1491f
CCc1s28_2 c1s28_2 c1s29_2 0.1322f
CCc1s28_4 c1s28_4 c1s29_4 0.03884f
CCc1s28_6 c1s28_6 c1s29_6 0.09332f
Rc1s29_0 c1s29_0 c1s29_1 4.263
Rc1s29_1 c1s29_1 c1s29_2 3.576
Rc1s29_2 c1s29_2 c1s29_3 2.919
Rc1s29_3 c1s29_3 c1s29_4 2.664
Rc1s29_4 c1s29_4 c1s29_5 2.802
Rc1s29_5 c1s29_5 c1s29_6 1.589
Cc1s29_0 c1s29_0 0 0.1509f
Cc1s29_1 c1s29_1 0 0.3893f
Cc1s29_2 c1s29_2 0 0.4331f
Cc1s29_3 c1s29_3 0 0.3722f
Cc1s29_4 c1s29_4 0 0.3644f
Cc1s29_5 c1s29_5 0 0.2927f
Cc1s29_6 c1s29_6 0 0.1059f
CCc1s29_0 c1s29_0 c1s30_0 0.1519f
CCc1s29_2 c1s29_2 c1s30_2 0.1101f
CCc1s29_4 c1s29_4 c1s30_4 0.07636f
CCc1s29_6 c1s29_6 c1s30_6 0.08504f
Rc1s30_0 c1s30_0 c1s30_1 5.536
Rc1s30_1 c1s30_1 c1s30_2 2.126
Rc1s30_2 c1s30_2 c1s30_3 0.9786
Rc1s30_3 c1s30_3 c1s30_4 0.9173
Rc1s30_4 c1s30_4 c1s30_5 2.615
Rc1s30_5 c1s30_5 c1s30_6 2.223
Cc1s30_0 c1s30_0 0 0.2357f
Cc1s30_1 c1s30_1 0 0.3775f
Cc1s30_2 c1s30_2 0 0.207f
Cc1s30_3 c1s30_3 0 0.1264f
Cc1s30_4 c1s30_4 0 0.2355f
Cc1s30_5 c1s30_5 0 0.3225f
Cc1s30_6 c1s30_6 0 0.1482f
CCc1s30_0 c1s30_0 c1s31_0 0.147f
CCc1s30_2 c1s30_2 c1s31_2 0.04584f
CCc1s30_4 c1s30_4 c1s31_4 0.07756f
CCc1s30_6 c1s30_6 c1s31_6 0.1219f
Rc1s31_0 c1s31_0 c1s31_1 2.608
Rc1s31_1 c1s31_1 c1s31_2 0.7626
Rc1s31_2 c1s31_2 c1s31_3 2.169
Rc1s31_3 c1s31_3 c1s31_4 1.287
Rc1s31_4 c1s31_4 c1s31_5 0.7869
Rc1s31_5 c1s31_5 c1s31_6 1.274
Cc1s31_0 c1s31_0 0 0.04052f
Cc1s31_1 c1s31_1 0 0.09136f
Cc1s31_2 c1s31_2 0 0.1954f
Cc1s31_3 c1s31_3 0 0.2304f
Cc1s31_4 c1s31_4 0 0.1383f
Cc1s31_5 c1s31_5 0 0.1374f
Cc1s31_6 c1s31_6 0 0.08496f
CCc1s31_0 c1s31_0 c1s32_0 0.1085f
CCc1s31_2 c1s31_2 c1s32_2 0.09369f
CCc1s31_4 c1s31_4 c1s32_4 0.03099f
CCc1s31_6 c1s31_6 c1s32_6 0.03019f
Rc1s32_0 c1s32_0 c1s32_1 5.129
Rc1s32_1 c1s32_1 c1s32_2 2.476
Rc1s32_2 c1s32_2 c1s32_3 0.9961
Rc1s32_3 c1s32_3 c1s32_4 3.165
Rc1s32_4 c1s32_4 c1s32_5 0.5188
Rc1s32_5 c1s32_5 c1s32_6 1.61
Cc1s32_0 c1s32_0 0 0.2086f
Cc1s32_1 c1s32_1 0 0.3737f
Cc1s32_2 c1s32_2 0 0.2315f
Cc1s32_3 c1s32_3 0 0.2774f
Cc1s32_4 c1s32_4 0 0.2456f
Cc1s32_5 c1s32_5 0 0.1419f
Cc1s32_6 c1s32_6 0 0.1073f
CCc1s32_0 c1s32_0 c1s33_0 0.1387f
CCc1s32_2 c1s32_2 c1s33_2 0.1194f
CCc1s32_4 c1s32_4 c1s33_4 0.05973f
CCc1s32_6 c1s32_6 c1s33_6 0.1448f
Rc1s33_0 c1s33_0 c1s33_1 4.334
Rc1s33_1 c1s33_1 c1s33_2 3.176
Rc1s33_2 c1s33_2 c1s33_3 3.262
Rc1s33_3 c1s33_3 c1s33_4 1.79
Rc1s33_4 c1s33_4 c1s33_5 2.578
Rc1s33_5 c1s33_5 c1s33_6 2.165
Cc1s33_0 c1s33_0 0 0.1556f
Cc1s33_1 c1s33_1 0 0.3673f
Cc1s33_2 c1s33_2 0 0.4292f
Cc1s33_3 c1s33_3 0 0.3368f
Cc1s33_4 c1s33_4 0 0.2912f
Cc1s33_5 c1s33_5 0 0.3162f
Cc1s33_6 c1s33_6 0 0.1443f
CCc1s33_0 c1s33_0 c1s34_0 0.1523f
CCc1s33_2 c1s33_2 c1s34_2 0.1317f
CCc1s33_4 c1s33_4 c1s34_4 0.1216f
CCc1s33_6 c1s33_6 c1s34_6 0.134f
Rc1s34_0 c1s34_0 c1s34_1 5.594
Rc1s34_1 c1s34_1 c1s34_2 1.258
Rc1s34_2 c1s34_2 c1s34_3 1.084
Rc1s34_3 c1s34_3 c1s34_4 2.802
Rc1s34_4 c1s34_4 c1s34_5 2.877
Rc1s34_5 c1s34_5 c1s34_6 2.07
Cc1s34_0 c1s34_0 0 0.2396f
Cc1s34_1 c1s34_1 0 0.3235f
Cc1s34_2 c1s34_2 0 0.1562f
Cc1s34_3 c1s34_3 0 0.2591f
Cc1s34_4 c1s34_4 0 0.3786f
Cc1s34_5 c1s34_5 0 0.3298f
Cc1s34_6 c1s34_6 0 0.138f
CCc1s34_0 c1s34_0 c1s35_0 0.08819f
CCc1s34_2 c1s34_2 c1s35_2 0.07652f
CCc1s34_4 c1s34_4 c1s35_4 0.1436f
CCc1s34_6 c1s34_6 c1s35_6 0.1315f
Rc1s35_0 c1s35_0 c1s35_1 4.291
Rc1s35_1 c1s35_1 c1s35_2 0.5764
Rc1s35_2 c1s35_2 c1s35_3 3.131
Rc1s35_3 c1s35_3 c1s35_4 1.894
Rc1s35_4 c1s35_4 c1s35_5 1.048
Rc1s35_5 c1s35_5 c1s35_6 1.393
Cc1s35_0 c1s35_0 0 0.1528f
Cc1s35_1 c1s35_1 0 0.1912f
Cc1s35_2 c1s35_2 0 0.2472f
Cc1s35_3 c1s35_3 0 0.335f
Cc1s35_4 c1s35_4 0 0.1961f
Cc1s35_5 c1s35_5 0 0.1627f
Cc1s35_6 c1s35_6 0 0.09286f
CCc1s35_0 c1s35_0 c1s36_0 0.1168f
CCc1s35_2 c1s35_2 c1s36_2 0.02077f
CCc1s35_4 c1s35_4 c1s36_4 0.03681f
CCc1s35_6 c1s35_6 c1s36_6 0.06237f
Rc1s36_0 c1s36_0 c1s36_1 5.245
Rc1s36_1 c1s36_1 c1s36_2 2.803
Rc1s36_2 c1s36_2 c1s36_3 3.508
Rc1s36_3 c1s36_3 c1s36_4 2.161
Rc1s36_4 c1s36_4 c1s36_5 2.252
Rc1s36_5 c1s36_5 c1s36_6 2.187
Cc1s36_0 c1s36_0 0 0.2163f
Cc1s36_1 c1s36_1 0 0.4032f
Cc1s36_2 c1s36_2 0 0.4207f
Cc1s36_3 c1s36_3 0 0.3779f
Cc1s36_4 c1s36_4 0 0.2941f
Cc1s36_5 c1s36_5 0 0.2959f
Cc1s36_6 c1s36_6 0 0.1458f
CCc1s36_0 c1s36_0 c1s37_0 0.09359f
CCc1s36_2 c1s36_2 c1s37_2 0.09589f
CCc1s36_4 c1s36_4 c1s37_4 0.1346f
CCc1s36_6 c1s36_6 c1s37_6 0.1535f
Rc1s37_0 c1s37_0 c1s37_1 3.736
Rc1s37_1 c1s37_1 c1s37_2 2.434
Rc1s37_2 c1s37_2 c1s37_3 1.419
Rc1s37_3 c1s37_3 c1s37_4 1.401
Rc1s37_4 c1s37_4 c1s37_5 2.045
Rc1s37_5 c1s37_5 c1s37_6 2.297
Cc1s37_0 c1s37_0 0 0.1157f
Cc1s37_1 c1s37_1 0 0.278f
Cc1s37_2 c1s37_2 0 0.2569f
Cc1s37_3 c1s37_3 0 0.188f
Cc1s37_4 c1s37_4 0 0.2297f
Cc1s37_5 c1s37_5 0 0.2894f
Cc1s37_6 c1s37_6 0 0.1531f
CCc1s37_0 c1s37_0 c1s38_0 0.097f
CCc1s37_2 c1s37_2 c1s38_2 0.1567f
CCc1s37_4 c1s37_4 c1s38_4 0.04282f
CCc1s37_6 c1s37_6 c1s38_6 0.1091f
Rc1s38_0 c1s38_0 c1s38_1 5.583
Rc1s38_1 c1s38_1 c1s38_2 2.769
Rc1s38_2 c1s38_2 c1s38_3 2.233
Rc1s38_3 c1s38_3 c1s38_4 1.61
Rc1s38_4 c1s38_4 c1s38_5 1.717
Rc1s38_5 c1s38_5 c1s38_6 3.4
Cc1s38_0 c1s38_0 0 0.2389f
Cc1s38_1 c1s38_1 0 0.4234f
Cc1s38_2 c1s38_2 0 0.3334f
Cc1s38_3 c1s38_3 0 0.2562f
Cc1s38_4 c1s38_4 0 0.2218f
Cc1s38_5 c1s38_5 0 0.3411f
Cc1s38_6 c1s38_6 0 0.2267f
CCc1s38_0 c1s38_0 c1s39_0 0.1453f
CCc1s38_2 c1s38_2 c1s39_2 0.1138f
CCc1s38_4 c1s38_4 c1s39_4 0.1458f
CCc1s38_6 c1s38_6 c1s39_6 0.1495f
Rc1s39_0 c1s39_0 c1s39_1 5.116
Rc1s39_1 c1s39_1 c1s39_2 1.658
Rc1s39_2 c1s39_2 c1s39_3 1.913
Rc1s39_3 c1s39_3 c1s39_4 2.957
Rc1s39_4 c1s39_4 c1s39_5 1.624
Rc1s39_5 c1s39_5 c1s39_6 2.81
Cc1s39_0 c1s39_0 0 0.2077f
Cc1s39_1 c1s39_1 0 0.3182f
Cc1s39_2 c1s39_2 0 0.238f
Cc1s39_3 c1s39_3 0 0.3247f
Cc1s39_4 c1s39_4 0 0.3054f
Cc1s39_5 c1s39_5 0 0.2956f
Cc1s39_6 c1s39_6 0 0.1874f
CCc1s39_0 c1s39_0 c1s40_0 0.0874f
CCc1s39_2 c1s39_2 c1s40_2 0.06712f
CCc1s39_4 c1s39_4 c1s40_4 0.08386f
CCc1s39_6 c1s39_6 c1s40_6 0.03631f
Rc1s40_0 c1s40_0 c1s40_1 3.567
Rc1s40_1 c1s40_1 c1s40_2 1.758
Rc1s40_2 c1s40_2 c1s40_3 0.5072
Rc1s40_3 c1s40_3 c1s40_4 0.992
Rc1s40_4 c1s40_4 c1s40_5 1.27
Rc1s40_5 c1s40_5 c1s40_6 3.152
Cc1s40_0 c1s40_0 0 0.1044f
Cc1s40_1 c1s40_1 0 0.2216f
Cc1s40_2 c1s40_2 0 0.151f
Cc1s40_3 c1s40_3 0 0.09995f
Cc1s40_4 c1s40_4 0 0.1508f
Cc1s40_5 c1s40_5 0 0.2948f
Cc1s40_6 c1s40_6 0 0.2102f
CCc1s40_0 c1s40_0 c1s41_0 0.1025f
CCc1s40_2 c1s40_2 c1s41_2 0.0602f
CCc1s40_4 c1s40_4 c1s41_4 0.1597f
CCc1s40_6 c1s40_6 c1s41_6 0.05611f
Rc1s41_0 c1s41_0 c1s41_1 4.068
Rc1s41_1 c1s41_1 c1s41_2 2.779
Rc1s41_2 c1s41_2 c1s41_3 2.628
Rc1s41_3 c1s41_3 c1s41_4 1.816
Rc1s41_4 c1s41_4 c1s41_5 2.898
Rc1s41_5 c1s41_5 c1s41_6 1.98
Cc1s41_0 c1s41_0 0 0.1379f
Cc1s41_1 c1s41_1 0 0.3232f
Cc1s41_2 c1s41_2 0 0.3605f
Cc1s41_3 c1s41_3 0 0.2962f
Cc1s41_4 c1s41_4 0 0.3142f
Cc1s41_5 c1s41_5 0 0.3252f
Cc1s41_6 c1s41_6 0 0.132f
CCc1s41_0 c1s41_0 c1s42_0 0.1202f
CCc1s41_2 c1s41_2 c1s42_2 0.08879f
CCc1s41_4 c1s41_4 c1s42_4 0.156f
CCc1s41_6 c1s41_6 c1s42_6 0.1203f
Rc1s42_0 c1s42_0 c1s42_1 2.738
Rc1s42_1 c1s42_1 c1s42_2 0.8578
Rc1s42_2 c1s42_2 c1s42_3 3.495
Rc1s42_3 c1s42_3 c1s42_4 1.172
Rc1s42_4 c1s42_4 c1s42_5 0.5323
Rc1s42_5 c1s42_5 c1s42_6 1.248
Cc1s42_0 c1s42_0 0 0.04919f
Cc1s42_1 c1s42_1 0 0.1064f
Cc1s42_2 c1s42_2 0 0.2902f
Cc1s42_3 c1s42_3 0 0.3111f
Cc1s42_4 c1s42_4 0 0.1136f
Cc1s42_5 c1s42_5 0 0.1187f
Cc1s42_6 c1s42_6 0 0.08318f
CCc1s42_0 c1s42_0 c1s43_0 0.08717f
CCc1s42_2 c1s42_2 c1s43_2 0.1533f
CCc1s42_4 c1s42_4 c1s43_4 0.07588f
CCc1s42_6 c1s42_6 c1s43_6 0.1213f
Rc1s43_0 c1s43_0 c1s43_1 5.078
Rc1s43_1 c1s43_1 c1s43_2 0.7309
Rc1s43_2 c1s43_2 c1s43_3 2.377
Rc1s43_3 c1s43_3 c1s43_4 3.587
Rc1s43_4 c1s43_4 c1s43_5 2.181
Rc1s43_5 c1s43_5 c1s43_6 2.134
Cc1s43_0 c1s43_0 0 0.2052f
Cc1s43_1 c1s43_1 0 0.2539f
Cc1s43_2 c1s43_2 0 0.2072f
Cc1s43_3 c1s43_3 0 0.3976f
Cc1s43_4 c1s43_4 0 0.3845f
Cc1s43_5 c1s43_5 0 0.2877f
Cc1s43_6 c1s43_6 0 0.1422f
CCc1s43_0 c1s43_0 c1s44_0 0.06854f
CCc1s43_2 c1s43_2 c1s44_2 0.1525f
CCc1s43_4 c1s43_4 c1s44_4 0.1557f
CCc1s43_6 c1s43_6 c1s44_6 0.03444f
Rc1s44_0 c1s44_0 c1s44_1 4.191
Rc1s44_1 c1s44_1 c1s44_2 1.772
Rc1s44_2 c1s44_2 c1s44_3 2.566
Rc1s44_3 c1s44_3 c1s44_4 0.8237
Rc1s44_4 c1s44_4 c1s44_5 1.286
Rc1s44_5 c1s44_5 c1s44_6 1.328
Cc1s44_0 c1s44_0 0 0.1461f
Cc1s44_1 c1s44_1 0 0.2642f
Cc1s44_2 c1s44_2 0 0.2892f
Cc1s44_3 c1s44_3 0 0.226f
Cc1s44_4 c1s44_4 0 0.1406f
Cc1s44_5 c1s44_5 0 0.1743f
Cc1s44_6 c1s44_6 0 0.08854f
CCc1s44_0 c1s44_0 c1s45_0 0.08716f
CCc1s44_2 c1s44_2 c1s45_2 0.1311f
CCc1s44_4 c1s44_4 c1s45_4 0.1401f
CCc1s44_6 c1s44_6 c1s45_6 0.1301f
Rc1s45_0 c1s45_0 c1s45_1 4.582
Rc1s45_1 c1s45_1 c1s45_2 0.7247
Rc1s45_2 c1s45_2 c1s45_3 1.678
Rc1s45_3 c1s45_3 c1s45_4 2.556
Rc1s45_4 c1s45_4 c1s45_5 1.377
Rc1s45_5 c1s45_5 c1s45_6 2.05
Cc1s45_0 c1s45_0 0 0.1721f
Cc1s45_1 c1s45_1 0 0.2204f
Cc1s45_2 c1s45_2 0 0.1602f
Cc1s45_3 c1s45_3 0 0.2823f
Cc1s45_4 c1s45_4 0 0.2622f
Cc1s45_5 c1s45_5 0 0.2284f
Cc1s45_6 c1s45_6 0 0.1366f
CCc1s45_0 c1s45_0 c1s46_0 0.1467f
CCc1s45_2 c1s45_2 c1s46_2 0.03626f
CCc1s45_4 c1s45_4 c1s46_4 0.1395f
CCc1s45_6 c1s45_6 c1s46_6 0.03482f
Rc1s46_0 c1s46_0 c1s46_1 3.667
Rc1s46_1 c1s46_1 c1s46_2 3.302
Rc1s46_2 c1s46_2 c1s46_3 1.084
Rc1s46_3 c1s46_3 c1s46_4 2.09
Rc1s46_4 c1s46_4 c1s46_5 1.762
Rc1s46_5 c1s46_5 c1s46_6 3.247
Cc1s46_0 c1s46_0 0 0.1111f
Cc1s46_1 c1s46_1 0 0.3313f
Cc1s46_2 c1s46_2 0 0.2924f
Cc1s46_3 c1s46_3 0 0.2116f
Cc1s46_4 c1s46_4 0 0.2568f
Cc1s46_5 c1s46_5 0 0.334f
Cc1s46_6 c1s46_6 0 0.2165f
CCc1s46_0 c1s46_0 c1s47_0 0.1589f
CCc1s46_2 c1s46_2 c1s47_2 0.0604f
CCc1s46_4 c1s46_4 c1s47_4 0.08895f
CCc1s46_6 c1s46_6 c1s47_6 0.1453f
Rc1s47_0 c1s47_0 c1s47_1 4.166
Rc1s47_1 c1s47_1 c1s47_2 1.126
Rc1s47_2 c1s47_2 c1s47_3 2.843
Rc1s47_3 c1s47_3 c1s47_4 1.512
Rc1s47_4 c1s47_4 c1s47_5 1.981
Rc1s47_5 c1s47_5 c1s47_6 0.477
Cc1s47_0 c1s47_0 0 0.1444f
Cc1s47_1 c1s47_1 0 0.2195f
Cc1s47_2 c1s47_2 0 0.2646f
Cc1s47_3 c1s47_3 0 0.2903f
Cc1s47_4 c1s47_4 0 0.2328f
Cc1s47_5 c1s47_5 0 0.1639f
Cc1s47_6 c1s47_6 0 0.0318f
CCc1s47_0 c1s47_0 c1s48_0 0.1585f
CCc1s47_2 c1s47_2 c1s48_2 0.112f
CCc1s47_4 c1s47_4 c1s48_4 0.1496f
CCc1s47_6 c1s47_6 c1s48_6 0.1556f
Rc1s48_0 c1s48_0 c1s48_1 3.293
Rc1s48_1 c1s48_1 c1s48_2 2.153
Rc1s48_2 c1s48_2 c1s48_3 1.837
Rc1s48_3 c1s48_3 c1s48_4 2.844
Rc1s48_4 c1s48_4 c1s48_5 3.104
Rc1s48_5 c1s48_5 c1s48_6 1.17
Cc1s48_0 c1s48_0 0 0.08618f
Cc1s48_1 c1s48_1 0 0.2297f
Cc1s48_2 c1s48_2 0 0.266f
Cc1s48_3 c1s48_3 0 0.312f
Cc1s48_4 c1s48_4 0 0.3965f
Cc1s48_5 c1s48_5 0 0.2849f
Cc1s48_6 c1s48_6 0 0.078f
CCc1s48_0 c1s48_0 c1s49_0 0.05844f
Cc1s49_0 c1s49_0 0 0f
CCc1s49_0 c1s49_0 c2s0_0 0.1189f
Rc2s0_0 c2s0_0 c2s0_1 3.747
Rc2s0_1 c2s0_1 c2s0_2 0.8601
Rc2s0_2 c2s0_2 c2s0_3 1.065
Rc2s0_3 c2s0_3 c2s0_4 2.217
Rc2s0_4 c2s0_4 c2s0_5 2.335
Rc2s0_5 c2s0_5 c2s0_6 3.474
Cc2s0_0 c2s0_0 0 0.1164f
Cc2s0_1 c2s0_1 0 0.1738f
Cc2s0_2 c2s0_2 0 0.1284f
Cc2s0_3 c2s0_3 0 0.2188f
Cc2s0_4 c2s0_4 0 0.3035f
Cc2s0_5 c2s0_5 0 0.3873f
Cc2s0_6 c2s0_6 0 0.2316f
CCc2s0_0 c2s0_0 c2s1_0 0.09459f
CCc2s0_2 c2s0_2 c2s1_2 0.1053f
CCc2s0_4 c2s0_4 c2s1_4 0.04084f
CCc2s0_6 c2s0_6 c2s1_6 0.07793f
Rc2s1_0 c2s1_0 c2s1_1 3.331
Rc2s1_1 c2s1_1 c2s1_2 2.641
Rc2s1_2 c2s1_2 c2s1_3 1.291
Rc2s1_3 c2s1_3 c2s1_4 1.125
Rc2s1_4 c2s1_4 c2s1_5 1.608
Rc2s1_5 c2s1_5 c2s1_6 1.932
Cc2s1_0 c2s1_0 0 0.08876f
Cc2s1_1 c2s1_1 0 0.2648f
Cc2s1_2 c2s1_2 0 0.2621f
Cc2s1_3 c2s1_3 0 0.1611f
Cc2s1_4 c2s1_4 0 0.1822f
Cc2s1_5 c2s1_5 0 0.236f
Cc2s1_6 c2s1_6 0 0.1288f
CCc2s1_0 c2s1_0 c2s2_0 0.06738f
CCc2s1_2 c2s1_2 c2s2_2 0.1048f
CCc2s1_4 c2s1_4 c2s2_4 0.04537f
CCc2s1_6 c2s1_6 c2s2_6 0.1432f
Rc2s2_0 c2s2_0 c2s2_1 4.637
Rc2s2_1 c2s2_1 c2s2_2 2.135
Rc2s2_2 c2s2_2 c2s2_3 0.6332
Rc2s2_3 c2s2_3 c2s2_4 1.477
Rc2s2_4 c2s2_4 c2s2_5 2.624
Rc2s2_5 c2s2_5 c2s2_6 2.482
Cc2s2_0 c2s2_0 0 0.1758f
Cc2s2_1 c2s2_1 0 0.3181f
Cc2s2_2 c2s2_2 0 0.1845f
Cc2s2_3 c2s2_3 0 0.1407f
Cc2s2_4 c2s2_4 0 0.2734f
Cc2s2_5 c2s2_5 0 0.3404f
Cc2s2_6 c2s2_6 0 0.1655f
CCc2s2_0 c2s2_0 c2s3_0 0.1337f
CCc2s2_2 c2s2_2 c2s3_2 0.1448f
CCc2s2_4 c2s2_4 c2s3_4 0.06415f
CCc2s2_6 c2s2_6 c2s3_6 0.08912f
Rc2s3_0 c2s3_0 c2s3_1 3.49
Rc2s3_1 c2s3_1 c2s3_2 0.853
Rc2s3_2 c2s3_2 c2s3_3 0.8914
Rc2s3_3 c2s3_3 c2s3_4 1.258
Rc2s3_4 c2s3_4 c2s3_5 0.7273
Rc2s3_5 c2s3_5 c2s3_6 2.147
Cc2s3_0 c2s3_0 0 0.09931f
Cc2s3_1 c2s3_1 0 0.1562f
Cc2s3_2 c2s3_2 0 0.1163f
Cc2s3_3 c2s3_3 0 0.1433f
Cc2s3_4 c2s3_4 0 0.1323f
Cc2s3_5 c2s3_5 0 0.1916f
Cc2s3_6 c2s3_6 0 0.1432f
CCc2s3_0 c2s3_0 c2s4_0 0.1184f
CCc2s3_2 c2s3_2 c2s4_2 0.09883f
CCc2s3_4 c2s3_4 c2s4_4 0.1159f
CCc2s3_6 c2s3_6 c2s4_6 0.05167f
Rc2s4_0 c2s4_0 c2s4_1 3.078
Rc2s4_1 c2s4_1 c2s4_2 2.238
Rc2s4_2 c2s4_2 c2s4_3 3.235
Rc2s4_3 c2s4_3 c2s4_4 1.78
Rc2s4_4 c2s4_4 c2s4_5 0.4633
Rc2s4_5 c2s4_5 c2s4_6 0.5132
Cc2s4_0 c2s4_0 0 0.07187f
Cc2s4_1 c2s4_1 0 0.2211f
Cc2s4_2 c2s4_2 0 0.3649f
Cc2s4_3 c2s4_3 0 0.3344f
Cc2s4_4 c2s4_4 0 0.1496f
Cc2s4_5 c2s4_5 0 0.0651f
Cc2s4_6 c2s4_6 0 0.03421f
CCc2s4_0 c2s4_0 c2s5_0 0.06274f
CCc2s4_2 c2s4_2 c2s5_2 0.1062f
CCc2s4_4 c2s4_4 c2s5_4 0.03184f
CCc2s4_6 c2s4_6 c2s5_6 0.05143f
Rc2s5_0 c2s5_0 c2s5_1 4.594
Rc2s5_1 c2s5_1 c2s5_2 3.553
Rc2s5_2 c2s5_2 c2s5_3 1.524
Rc2s5_3 c2s5_3 c2s5_4 2.344
Rc2s5_4 c2s5_4 c2s5_5 2.083
Rc2s5_5 c2s5_5 c2s5_6 0.5228
Cc2s5_0 c2s5_0 0 0.1729f
Cc2s5_1 c2s5_1 0 0.4098f
Cc2s5_2 c2s5_2 0 0.3385f
Cc2s5_3 c2s5_3 0 0.2579f
Cc2s5_4 c2s5_4 0 0.2951f
Cc2s5_5 c2s5_5 0 0.1737f
Cc2s5_6 c2s5_6 0 0.03486f
CCc2s5_0 c2s5_0 c2s6_0 0.06618f
CCc2s5_2 c2s5_2 c2s6_2 0.03952f
CCc2s5_4 c2s5_4 c2s6_4 0.05512f
CCc2s5_6 c2s5_6 c2s6_6 0.1278f
Rc2s6_0 c2s6_0 c2s6_1 4.596
Rc2s6_1 c2s6_1 c2s6_2 0.5792
Rc2s6_2 c2s6_2 c2s6_3 0.6937
Rc2s6_3 c2s6_3 c2s6_4 2.734
Rc2s6_4 c2s6_4 c2s6_5 0.7751
Rc2s6_5 c2s6_5 c2s6_6 1.449
Cc2s6_0 c2s6_0 0 0.1731f
Cc2s6_1 c2s6_1 0 0.2117f
Cc2s6_2 c2s6_2 0 0.08486f
Cc2s6_3 c2s6_3 0 0.2285f
Cc2s6_4 c2s6_4 0 0.2339f
Cc2s6_5 c2s6_5 0 0.1482f
Cc2s6_6 c2s6_6 0 0.09657f
CCc2s6_0 c2s6_0 c2s7_0 0.05771f
CCc2s6_2 c2s6_2 c2s7_2 0.02697f
CCc2s6_4 c2s6_4 c2s7_4 0.02436f
CCc2s6_6 c2s6_6 c2s7_6 0.03946f
Rc2s7_0 c2s7_0 c2s7_1 3.708
Rc2s7_1 c2s7_1 c2s7_2 3.391
Rc2s7_2 c2s7_2 c2s7_3 2.461
Rc2s7_3 c2s7_3 c2s7_4 1.212
Rc2s7_4 c2s7_4 c2s7_5 2.591
Rc2s7_5 c2s7_5 c2s7_6 1.312
Cc2s7_0 c2s7_0 0 0.1139f
Cc2s7_1 c2s7_1 0 0.3399f
Cc2s7_2 c2s7_2 0 0.3901f
Cc2s7_3 c2s7_3 0 0.2449f
Cc2s7_4 c2s7_4 0 0.2536f
Cc2s7_5 c2s7_5 0 0.2602f
Cc2s7_6 c2s7_6 0 0.08746f
CCc2s7_0 c2s7_0 c2s8_0 0.09213f
CCc2s7_2 c2s7_2 c2s8_2 0.06506f
CCc2s7_4 c2s7_4 c2s8_4 0.1528f
CCc2s7_6 c2s7_6 c2s8_6 0.06933f
Rc2s8_0 c2s8_0 c2s8_1 4.981
Rc2s8_1 c2s8_1 c2s8_2 2.47
Rc2s8_2 c2s8_2 c2s8_3 3.106
Rc2s8_3 c2s8_3 c2s8_4 2.359
Rc2s8_4 c2s8_4 c2s8_5 3.192
Rc2s8_5 c2s8_5 c2s8_6 1.726
Cc2s8_0 c2s8_0 0 0.1987f
Cc2s8_1 c2s8_1 0 0.3634f
Cc2s8_2 c2s8_2 0 0.3717f
Cc2s8_3 c2s8_3 0 0.3644f
Cc2s8_4 c2s8_4 0 0.3701f
Cc2s8_5 c2s8_5 0 0.3279f
Cc2s8_6 c2s8_6 0 0.1151f
CCc2s8_0 c2s8_0 c2s9_0 0.1151f
CCc2s8_2 c2s8_2 c2s9_2 0.1069f
CCc2s8_4 c2s8_4 c2s9_4 0.09388f
CCc2s8_6 c2s8_6 c2s9_6 0.09902f
Rc2s9_0 c2s9_0 c2s9_1 4.138
Rc2s9_1 c2s9_1 c2s9_2 1.69
Rc2s9_2 c2s9_2 c2s9_3 3.28
Rc2s9_3 c2s9_3 c2s9_4 2.443
Rc2s9_4 c2s9_4 c2s9_5 2.18
Rc2s9_5 c2s9_5 c2s9_6 0.6199
Cc2s9_0 c2s9_0 0 0.1425f
Cc2s9_1 c2s9_1 0 0.2552f
Cc2s9_2 c2s9_2 0 0.3313f
Cc2s9_3 c2s9_3 0 0.3815f
Cc2s9_4 c2s9_4 0 0.3082f
Cc2s9_5 c2s9_5 0 0.1866f
Cc2s9_6 c2s9_6 0 0.04133f
CCc2s9_0 c2s9_0 c2s10_0 0.09119f
CCc2s9_2 c2s9_2 c2s10_2 0.04452f
CCc2s9_4 c2s9_4 c2s10_4 0.0501f
CCc2s9_6 c2s9_6 c2s10_6 0.08085f
Rc2s10_0 c2s10_0 c2s10_1 4.17
Rc2s10_1 c2s10_1 c2s10_2 1.239
Rc2s10_2 c2s10_2 c2s10_3 1.303
Rc2s10_3 c2s10_3 c2s10_4 2.12
Rc2s10_4 c2s10_4 c2s10_5 1.941
Rc2s10_5 c2s10_5 c2s10_6 1.72
Cc2s10_0 c2s10_0 0 0.1447f
Cc2s10_1 c2s10_1 0 0.2272f
Cc2s10_2 c2s10_2 0 0.1695f
Cc2s10_3 c2s10_3 0 0.2282f
Cc2s10_4 c2s10_4 0 0.2707f
Cc2s10_5 c2s10_5 0 0.2441f
Cc2s10_6 c2s10_6 0 0.1147f
CCc2s10_0 c2s10_0 c2s11_0 0.03453f
CCc2s10_2 c2s10_2 c2s11_2 0.07229f
CCc2s10_4 c2s10_4 c2s11_4 0.1116f
CCc2s10_6 c2s10_6 c2s11_6 0.09619f
Rc2s11_0 c2s11_0 c2s11_1 4.166
Rc2s11_1 c2s11_1 c2s11_2 3.108
Rc2s11_2 c2s11_2 c2s11_3 2.728
Rc2s11_3 c2s11_3 c2s11_4 2.606
Rc2s11_4 c2s11_4 c2s11_5 0.5458
Rc2s11_5 c2s11_5 c2s11_6 1.421
Cc2s11_0 c2s11_0 0 0.1444f
Cc2s11_1 c2s11_1 0 0.3516f
Cc2s11_2 c2s11_2 0 0.3891f
Cc2s11_3 c2s11_3 0 0.3556f
Cc2s11_4 c2s11_4 0 0.2102f
Cc2s11_5 c2s11_5 0 0.1311f
Cc2s11_6 c2s11_6 0 0.09471f
CCc2s11_0 c2s11_0 c2s12_0 0.1155f
CCc2s11_2 c2s11_2 c2s12_2 0.04181f
CCc2s11_4 c2s11_4 c2s12_4 0.1479f
CCc2s11_6 c2s11_6 c2s12_6 0.03987f
Rc2s12_0 c2s12_0 c2s12_1 5.219
Rc2s12_1 c2s12_1 c2s12_2 1.131
Rc2s12_2 c2s12_2 c2s12_3 3.101
Rc2s12_3 c2s12_3 c2s12_4 3.122
Rc2s12_4 c2s12_4 c2s12_5 1.507
Rc2s12_5 c2s12_5 c2s12_6 3.249
Cc2s12_0 c2s12_0 0 0.2146f
Cc2s12_1 c2s12_1 0 0.29f
Cc2s12_2 c2s12_2 0 0.2822f
Cc2s12_3 c2s12_3 0 0.4149f
Cc2s12_4 c2s12_4 0 0.3086f
Cc2s12_5 c2s12_5 0 0.3171f
Cc2s12_6 c2s12_6 0 0.2166f
CCc2s12_0 c2s12_0 c2s13_0 0.04237f
CCc2s12_2 c2s12_2 c2s13_2 0.1389f
CCc2s12_4 c2s12_4 c2s13_4 0.07344f
CCc2s12_6 c2s12_6 c2s13_6 0.08156f
Rc2s13_0 c2s13_0 c2s13_1 2.821
Rc2s13_1 c2s13_1 c2s13_2 2.343
Rc2s13_2 c2s13_2 c2s13_3 1.3
Rc2s13_3 c2s13_3 c2s13_4 2.551
Rc2s13_4 c2s13_4 c2s13_5 2.968
Rc2s13_5 c2s13_5 c2s13_6 2.352
Cc2s13_0 c2s13_0 0 0.05475f
Cc2s13_1 c2s13_1 0 0.211f
Cc2s13_2 c2s13_2 0 0.2429f
Cc2s13_3 c2s13_3 0 0.2567f
Cc2s13_4 c2s13_4 0 0.3679f
Cc2s13_5 c2s13_5 0 0.3546f
Cc2s13_6 c2s13_6 0 0.1568f
CCc2s13_0 c2s13_0 c2s14_0 0.02115f
CCc2s13_2 c2s13_2 c2s14_2 0.1533f
CCc2s13_4 c2s13_4 c2s14_4 0.1488f
CCc2s13_6 c2s13_6 c2s14_6 0.11f
Rc2s14_0 c2s14_0 c2s14_1 3.645
Rc2s14_1 c2s14_1 c2s14_2 2.22
Rc2s14_2 c2s14_2 c2s14_3 3.231
Rc2s14_3 c2s14_3 c2s14_4 1.898
Rc2s14_4 c2s14_4 c2s14_5 2.905
Rc2s14_5 c2s14_5 c2s14_6 2.335
Cc2s14_0 c2s14_0 0 0.1097f
Cc2s14_1 c2s14_1 0 0.2577f
Cc2s14_2 c2s14_2 0 0.3634f
Cc2s14_3 c2s14_3 0 0.3419f
Cc2s14_4 c2s14_4 0 0.3201f
Cc2s14_5 c2s14_5 0 0.3493f
Cc2s14_6 c2s14_6 0 0.1557f
CCc2s14_0 c2s14_0 c2s15_0 0.07912f
CCc2s14_2 c2s14_2 c2s15_2 0.1507f
CCc2s14_4 c2s14_4 c2s15_4 0.07718f
CCc2s14_6 c2s14_6 c2s15_6 0.1048f
Rc2s15_0 c2s15_0 c2s15_1 2.618
Rc2s15_1 c2s15_1 c2s15_2 1.933
Rc2s15_2 c2s15_2 c2s15_3 0.5679
Rc2s15_3 c2s15_3 c2s15_4 2.668
Rc2s15_4 c2s15_4 c2s15_5 0.4519
Rc2s15_5 c2s15_5 c2s15_6 0.5825
Cc2s15_0 c2s15_0 0 0.04119f
Cc2s15_1 c2s15_1 0 0.17f
Cc2s15_2 c2s15_2 0 0.1667f
Cc2s15_3 c2s15_3 0 0.2157f
Cc2s15_4 c2s15_4 0 0.208f
Cc2s15_5 c2s15_5 0 0.06896f
Cc2s15_6 c2s15_6 0 0.03883f
CCc2s15_0 c2s15_0 c2s16_0 0.03556f
CCc2s15_2 c2s15_2 c2s16_2 0.03954f
CCc2s15_4 c2s15_4 c2s16_4 0.09113f
CCc2s15_6 c2s15_6 c2s16_6 0.06988f
Rc2s16_0 c2s16_0 c2s16_1 3.303
Rc2s16_1 c2s16_1 c2s16_2 3.548
Rc2s16_2 c2s16_2 c2s16_3 3.313
Rc2s16_3 c2s16_3 c2s16_4 2.513
Rc2s16_4 c2s16_4 c2s16_5 2.977
Rc2s16_5 c2s16_5 c2s16_6 3.032
Cc2s16_0 c2s16_0 0 0.08689f
Cc2s16_1 c2s16_1 0 0.3235f
Cc2s16_2 c2s16_2 0 0.4575f
Cc2s16_3 c2s16_3 0 0.3884f
Cc2s16_4 c2s16_4 0 0.366f
Cc2s16_5 c2s16_5 0 0.4006f
Cc2s16_6 c2s16_6 0 0.2021f
CCc2s16_0 c2s16_0 c2s17_0 0.05432f
CCc2s16_2 c2s16_2 c2s17_2 0.1332f
CCc2s16_4 c2s16_4 c2s17_4 0.05357f
CCc2s16_6 c2s16_6 c2s17_6 0.09873f
Rc2s17_0 c2s17_0 c2s17_1 3.577
Rc2s17_1 c2s17_1 c2s17_2 0.9498
Rc2s17_2 c2s17_2 c2s17_3 2.897
Rc2s17_3 c2s17_3 c2s17_4 3.336
Rc2s17_4 c2s17_4 c2s17_5 1.438
Rc2s17_5 c2s17_5 c2s17_6 3.221
Cc2s17_0 c2s17_0 0 0.1051f
Cc2s17_1 c2s17_1 0 0.1684f
Cc2s17_2 c2s17_2 0 0.2565f
Cc2s17_3 c2s17_3 0 0.4156f
Cc2s17_4 c2s17_4 0 0.3183f
Cc2s17_5 c2s17_5 0 0.3106f
Cc2s17_6 c2s17_6 0 0.2148f
CCc2s17_0 c2s17_0 c2s18_0 0.06848f
CCc2s17_2 c2s17_2 c2s18_2 0.1121f
CCc2s17_4 c2s17_4 c2s18_4 0.1594f
CCc2s17_6 c2s17_6 c2s18_6 0.1281f
Rc2s18_0 c2s18_0 c2s18_1 2.625
Rc2s18_1 c2s18_1 c2s18_2 1.82
Rc2s18_2 c2s18_2 c2s18_3 1.635
Rc2s18_3 c2s18_3 c2s18_4 1.376
Rc2s18_4 c2s18_4 c2s18_5 3.021
Rc2s18_5 c2s18_5 c2s18_6 1.839
Cc2s18_0 c2s18_0 0 0.04169f
Cc2s18_1 c2s18_1 0 0.163f
Cc2s18_2 c2s18_2 0 0.2303f
Cc2s18_3 c2s18_3 0 0.2007f
Cc2s18_4 c2s18_4 0 0.2931f
Cc2s18_5 c2s18_5 0 0.324f
Cc2s18_6 c2s18_6 0 0.1226f
CCc2s18_0 c2s18_0 c2s19_0 0.1179f
CCc2s18_2 c2s18_2 c2s19_2 0.1089f
CCc2s18_4 c2s18_4 c2s19_4 0.09266f
CCc2s18_6 c2s18_6 c2s19_6 0.02784f
Rc2s19_0 c2s19_0 c2s19_1 4.57
Rc2s19_1 c2s19_1 c2s19_2 3.258
Rc2s19_2 c2s19_2 c2s19_3 0.9924
Rc2s19_3 c2s19_3 c2s19_4 2.475
Rc2s19_4 c2s19_4 c2s19_5 1.985
Rc2s19_5 c2s19_5 c2s19_6 1.524
Cc2s19_0 c2s19_0 0 0.1713f
Cc2s19_1 c2s19_1 0 0.3885f
Cc2s19_2 c2s19_2 0 0.2834f
Cc2s19_3 c2s19_3 0 0.2311f
Cc2s19_4 c2s19_4 0 0.2973f
Cc2s19_5 c2s19_5 0 0.234f
Cc2s19_6 c2s19_6 0 0.1016f
CCc2s19_0 c2s19_0 c2s20_0 0.1195f
CCc2s19_2 c2s19_2 c2s20_2 0.1565f
CCc2s19_4 c2s19_4 c2s20_4 0.02303f
CCc2s19_6 c2s19_6 c2s20_6 0.1456f
Rc2s20_0 c2s20_0 c2s20_1 3.657
Rc2s20_1 c2s20_1 c2s20_2 3.077
Rc2s20_2 c2s20_2 c2s20_3 1
Rc2s20_3 c2s20_3 c2s20_4 2.707
Rc2s20_4 c2s20_4 c2s20_5 0.764
Rc2s20_5 c2s20_5 c2s20_6 1.507
Cc2s20_0 c2s20_0 0 0.1105f
Cc2s20_1 c2s20_1 0 0.3156f
Cc2s20_2 c2s20_2 0 0.2718f
Cc2s20_3 c2s20_3 0 0.2472f
Cc2s20_4 c2s20_4 0 0.2314f
Cc2s20_5 c2s20_5 0 0.1514f
Cc2s20_6 c2s20_6 0 0.1005f
CCc2s20_0 c2s20_0 c2s21_0 0.1558f
CCc2s20_2 c2s20_2 c2s21_2 0.1119f
CCc2s20_4 c2s20_4 c2s21_4 0.1298f
CCc2s20_6 c2s20_6 c2s21_6 0.08458f
Rc2s21_0 c2s21_0 c2s21_1 3.934
Rc2s21_1 c2s21_1 c2s21_2 2.002
Rc2s21_2 c2s21_2 c2s21_3 2.885
Rc2s21_3 c2s21_3 c2s21_4 2.728
Rc2s21_4 c2s21_4 c2s21_5 1.06
Rc2s21_5 c2s21_5 c2s21_6 1.838
Cc2s21_0 c2s21_0 0 0.1289f
Cc2s21_1 c2s21_1 0 0.2624f
Cc2s21_2 c2s21_2 0 0.3258f
Cc2s21_3 c2s21_3 0 0.3742f
Cc2s21_4 c2s21_4 0 0.2526f
Cc2s21_5 c2s21_5 0 0.1932f
Cc2s21_6 c2s21_6 0 0.1225f
CCc2s21_0 c2s21_0 c2s22_0 0.09588f
CCc2s21_2 c2s21_2 c2s22_2 0.1f
CCc2s21_4 c2s21_4 c2s22_4 0.1497f
CCc2s21_6 c2s21_6 c2s22_6 0.1376f
Rc2s22_0 c2s22_0 c2s22_1 2.922
Rc2s22_1 c2s22_1 c2s22_2 1.635
Rc2s22_2 c2s22_2 c2s22_3 0.7933
Rc2s22_3 c2s22_3 c2s22_4 0.5326
Rc2s22_4 c2s22_4 c2s22_5 0.6849
Rc2s22_5 c2s22_5 c2s22_6 1.026
Cc2s22_0 c2s22_0 0 0.06148f
Cc2s22_1 c2s22_1 0 0.1705f
Cc2s22_2 c2s22_2 0 0.1619f
Cc2s22_3 c2s22_3 0 0.08839f
Cc2s22_4 c2s22_4 0 0.08117f
Cc2s22_5 c2s22_5 0 0.1141f
Cc2s22_6 c2s22_6 0 0.06842f
CCc2s22_0 c2s22_0 c2s23_0 0.1273f
CCc2s22_2 c2s22_2 c2s23_2 0.1134f
CCc2s22_4 c2s22_4 c2s23_4 0.1317f
CCc2s22_6 c2s22_6 c2s23_6 0.06039f
Rc2s23_0 c2s23_0 c2s23_1 2.94
Rc2s23_1 c2s23_1 c2s23_2 3.512
Rc2s23_2 c2s23_2 c2s23_3 3.052
Rc2s23_3 c2s23_3 c2s23_4 3.432
Rc2s23_4 c2s23_4 c2s23_5 0.5092
Rc2s23_5 c2s23_5 c2s23_6 1.699
Cc2s23_0 c2s23_0 0 0.06266f
Cc2s23_1 c2s23_1 0 0.2968f
Cc2s23_2 c2s23_2 0 0.4376f
Cc2s23_3 c2s23_3 0 0.4323f
Cc2s23_4 c2s23_4 0 0.2628f
Cc2s23_5 c2s23_5 0 0.1472f
Cc2s23_6 c2s23_6 0 0.1133f
CCc2s23_0 c2s23_0 c2s24_0 0.1087f
CCc2s23_2 c2s23_2 c2s24_2 0.1231f
CCc2s23_4 c2s23_4 c2s24_4 0.1478f
CCc2s23_6 c2s23_6 c2s24_6 0.09528f
Rc2s24_0 c2s24_0 c2s24_1 3.681
Rc2s24_1 c2s24_1 c2s24_2 0.4668
Rc2s24_2 c2s24_2 c2s24_3 2.982
Rc2s24_3 c2s24_3 c2s24_4 3.544
Rc2s24_4 c2s24_4 c2s24_5 3.308
Rc2s24_5 c2s24_5 c2s24_6 2.536
Cc2s24_0 c2s24_0 0 0.1121f
Cc2s24_1 c2s24_1 0 0.1432f
Cc2s24_2 c2s24_2 0 0.2299f
Cc2s24_3 c2s24_3 0 0.4351f
Cc2s24_4 c2s24_4 0 0.4568f
Cc2s24_5 c2s24_5 0 0.3896f
Cc2s24_6 c2s24_6 0 0.1691f
CCc2s24_0 c2s24_0 c2s25_0 0.06795f
CCc2s24_2 c2s24_2 c2s25_2 0.05348f
CCc2s24_4 c2s24_4 c2s25_4 0.1285f
CCc2s24_6 c2s24_6 c2s25_6 0.151f
Rc2s25_0 c2s25_0 c2s25_1 5.475
Rc2s25_1 c2s25_1 c2s25_2 1.003
Rc2s25_2 c2s25_2 c2s25_3 2.294
Rc2s25_3 c2s25_3 c2s25_4 2.066
Rc2s25_4 c2s25_4 c2s25_5 1.796
Rc2s25_5 c2s25_5 c2s25_6 2.952
Cc2s25_0 c2s25_0 0 0.2317f
Cc2s25_1 c2s25_1 0 0.2985f
Cc2s25_2 c2s25_2 0 0.2198f
Cc2s25_3 c2s25_3 0 0.2907f
Cc2s25_4 c2s25_4 0 0.2575f
Cc2s25_5 c2s25_5 0 0.3166f
Cc2s25_6 c2s25_6 0 0.1968f
CCc2s25_0 c2s25_0 c2s26_0 0.151f
CCc2s25_2 c2s25_2 c2s26_2 0.1214f
CCc2s25_4 c2s25_4 c2s26_4 0.118f
CCc2s25_6 c2s25_6 c2s26_6 0.1167f
Rc2s26_0 c2s26_0 c2s26_1 4.509
Rc2s26_1 c2s26_1 c2s26_2 2.141
Rc2s26_2 c2s26_2 c2s26_3 1.231
Rc2s26_3 c2s26_3 c2s26_4 2.905
Rc2s26_4 c2s26_4 c2s26_5 0.8251
Rc2s26_5 c2s26_5 c2s26_6 2.478
Cc2s26_0 c2s26_0 0 0.1672f
Cc2s26_1 c2s26_1 0 0.31f
Cc2s26_2 c2s26_2 0 0.2248f
Cc2s26_3 c2s26_3 0 0.2758f
Cc2s26_4 c2s26_4 0 0.2487f
Cc2s26_5 c2s26_5 0 0.2202f
Cc2s26_6 c2s26_6 0 0.1652f
CCc2s26_0 c2s26_0 c2s27_0 0.07418f
CCc2s26_2 c2s26_2 c2s27_2 0.09839f
CCc2s26_4 c2s26_4 c2s27_4 0.1098f
CCc2s26_6 c2s26_6 c2s27_6 0.08705f
Rc2s27_0 c2s27_0 c2s27_1 5.531
Rc2s27_1 c2s27_1 c2s27_2 1.203
Rc2s27_2 c2s27_2 c2s27_3 0.4883
Rc2s27_3 c2s27_3 c2s27_4 3.459
Rc2s27_4 c2s27_4 c2s27_5 1.433
Rc2s27_5 c2s27_5 c2s27_6 1.326
Cc2s27_0 c2s27_0 0 0.2354f
Cc2s27_1 c2s27_1 0 0.3156f
Cc2s27_2 c2s27_2 0 0.1128f
Cc2s27_3 c2s27_3 0 0.2632f
Cc2s27_4 c2s27_4 0 0.3261f
Cc2s27_5 c2s27_5 0 0.1839f
Cc2s27_6 c2s27_6 0 0.0884f
CCc2s27_0 c2s27_0 c2s28_0 0.07818f
CCc2s27_2 c2s27_2 c2s28_2 0.1033f
CCc2s27_4 c2s27_4 c2s28_4 0.1581f
CCc2s27_6 c2s27_6 c2s28_6 0.1191f
Rc2s28_0 c2s28_0 c2s28_1 3.453
Rc2s28_1 c2s28_1 c2s28_2 2.134
Rc2s28_2 c2s28_2 c2s28_3 1.863
Rc2s28_3 c2s28_3 c2s28_4 2.03
Rc2s28_4 c2s28_4 c2s28_5 1.765
Rc2s28_5 c2s28_5 c2s28_6 0.978
Cc2s28_0 c2s28_0 0 0.09685f
Cc2s28_1 c2s28_1 0 0.2391f
Cc2s28_2 c2s28_2 0 0.2665f
Cc2s28_3 c2s28_3 0 0.2596f
Cc2s28_4 c2s28_4 0 0.253f
Cc2s28_5 c2s28_5 0 0.1829f
Cc2s28_6 c2s28_6 0 0.0652f
CCc2s28_0 c2s28_0 c2s29_0 0.07537f
CCc2s28_2 c2s28_2 c2s29_2 0.07447f
CCc2s28_4 c2s28_4 c2s29_4 0.0481f
CCc2s28_6 c2s28_6 c2s29_6 0.1344f
Rc2s29_0 c2s29_0 c2s29_1 3.584
Rc2s29_1 c2s29_1 c2s29_2 0.9272
Rc2s29_2 c2s29_2 c2s29_3 2.236
Rc2s29_3 c2s29_3 c2s29_4 3.111
Rc2s29_4 c2s29_4 c2s29_5 2.909
Rc2s29_5 c2s29_5 c2s29_6 2.409
Cc2s29_0 c2s29_0 0 0.1056f
Cc2s29_1 c2s29_1 0 0.1674f
Cc2s29_2 c2s29_2 0 0.2109f
Cc2s29_3 c2s29_3 0 0.3565f
Cc2s29_4 c2s29_4 0 0.4013f
Cc2s29_5 c2s29_5 0 0.3545f
Cc2s29_6 c2s29_6 0 0.1606f
CCc2s29_0 c2s29_0 c2s30_0 0.1223f
CCc2s29_2 c2s29_2 c2s30_2 0.06706f
CCc2s29_4 c2s29_4 c2s30_4 0.03998f
CCc2s29_6 c2s29_6 c2s30_6 0.0557f
Rc2s30_0 c2s30_0 c2s30_1 3.55
Rc2s30_1 c2s30_1 c2s30_2 1.329
Rc2s30_2 c2s30_2 c2s30_3 1.923
Rc2s30_3 c2s30_3 c2s30_4 0.9195
Rc2s30_4 c2s30_4 c2s30_5 0.8603
Rc2s30_5 c2s30_5 c2s30_6 1.246
Cc2s30_0 c2s30_0 0 0.1034f
Cc2s30_1 c2s30_1 0 0.192f
Cc2s30_2 c2s30_2 0 0.2168f
Cc2s30_3 c2s30_3 0 0.1895f
Cc2s30_4 c2s30_4 0 0.1187f
Cc2s30_5 c2s30_5 0 0.1404f
Cc2s30_6 c2s30_6 0 0.08307f
CCc2s30_0 c2s30_0 c2s31_0 0.04751f
CCc2s30_2 c2s30_2 c2s31_2 0.1322f
CCc2s30_4 c2s30_4 c2s31_4 0.09526f
CCc2s30_6 c2s30_6 c2s31_6 0.04778f
Rc2s31_0 c2s31_0 c2s31_1 3.802
Rc2s31_1 c2s31_1 c2s31_2 3.197
Rc2s31_2 c2s31_2 c2s31_3 2.269
Rc2s31_3 c2s31_3 c2s31_4 2.195
Rc2s31_4 c2s31_4 c2s31_5 1.683
Rc2s31_5 c2s31_5 c2s31_6 1.067
Cc2s31_0 c2s31_0 0 0.1201f
Cc2s31_1 c2s31_1 0 0.3332f
Cc2s31_2 c2s31_2 0 0.3644f
Cc2s31_3 c2s31_3 0 0.2976f
Cc2s31_4 c2s31_4 0 0.2585f
Cc2s31_5 c2s31_5 0 0.1833f
Cc2s31_6 c2s31_6 0 0.07113f
CCc2s31_0 c2s31_0 c2s32_0 0.1076f
CCc2s31_2 c2s31_2 c2s32_2 0.0308f
CCc2s31_4 c2s31_4 c2s32_4 0.1301f
CCc2s31_6 c2s31_6 c2s32_6 0.02805f
Rc2s32_0 c2s32_0 c2s32_1 4.801
Rc2s32_1 c2s32_1 c2s32_2 1.655
Rc2s32_2 c2s32_2 c2s32_3 2.6
Rc2s32_3 c2s32_3 c2s32_4 2.312
Rc2s32_4 c2s32_4 c2s32_5 0.8569
Rc2s32_5 c2s32_5 c2s32_6 2.146
Cc2s32_0 c2s32_0 0 0.1867f
Cc2s32_1 c2s32_1 0 0.2971f
Cc2s32_2 c2s32_2 0 0.2837f
Cc2s32_3 c2s32_3 0 0.3274f
Cc2s32_4 c2s32_4 0 0.2112f
Cc2s32_5 c2s32_5 0 0.2002f
Cc2s32_6 c2s32_6 0 0.1431f
CCc2s32_0 c2s32_0 c2s33_0 0.03038f
CCc2s32_2 c2s32_2 c2s33_2 0.05377f
CCc2s32_4 c2s32_4 c2s33_4 0.07343f
CCc2s32_6 c2s32_6 c2s33_6 0.05999f
Rc2s33_0 c2s33_0 c2s33_1 4.535
Rc2s33_1 c2s33_1 c2s33_2 3.559
Rc2s33_2 c2s33_2 c2s33_3 1.574
Rc2s33_3 c2s33_3 c2s33_4 3.092
Rc2s33_4 c2s33_4 c2s33_5 1.159
Rc2s33_5 c2s33_5 c2s33_6 2.684
Cc2s33_0 c2s33_0 0 0.169f
Cc2s33_1 c2s33_1 0 0.4062f
Cc2s33_2 c2s33_2 0 0.3422f
Cc2s33_3 c2s33_3 0 0.311f
Cc2s33_4 c2s33_4 0 0.2834f
Cc2s33_5 c2s33_5 0 0.2562f
Cc2s33_6 c2s33_6 0 0.179f
CCc2s33_0 c2s33_0 c2s34_0 0.06868f
CCc2s33_2 c2s33_2 c2s34_2 0.09495f
CCc2s33_4 c2s33_4 c2s34_4 0.0324f
CCc2s33_6 c2s33_6 c2s34_6 0.1358f
Rc2s34_0 c2s34_0 c2s34_1 3.108
Rc2s34_1 c2s34_1 c2s34_2 1.91
Rc2s34_2 c2s34_2 c2s34_3 1.364
Rc2s34_3 c2s34_3 c2s34_4 3.002
Rc2s34_4 c2s34_4 c2s34_5 2.317
Rc2s34_5 c2s34_5 c2s34_6 2.388
Cc2s34_0 c2s34_0 0 0.07386f
Cc2s34_1 c2s34_1 0 0.2012f
Cc2s34_2 c2s34_2 0 0.2183f
Cc2s34_3 c2s34_3 0 0.2911f
Cc2s34_4 c2s34_4 0 0.3546f
Cc2s34_5 c2s34_5 0 0.3136f
Cc2s34_6 c2s34_6 0 0.1592f
CCc2s34_0 c2s34_0 c2s35_0 0.1257f
CCc2s34_2 c2s34_2 c2s35_2 0.05569f
CCc2s34_4 c2s34_4 c2s35_4 0.02815f
CCc2s34_6 c2s34_6 c2s35_6 0.136f
Rc2s35_0 c2s35_0 c2s35_1 3.444
Rc2s35_1 c2s35_1 c2s35_2 3.009
Rc2s35_2 c2s35_2 c2s35_3 3.463
Rc2s35_3 c2s35_3 c2s35_4 2.432
Rc2s35_4 c2s35_4 c2s35_5 0.7754
Rc2s35_5 c2s35_5 c2s35_6 3.14
Cc2s35_0 c2s35_0 0 0.09628f
Cc2s35_1 c2s35_1 0 0.2969f
Cc2s35_2 c2s35_2 0 0.4315f
Cc2s35_3 c2s35_3 0 0.393f
Cc2s35_4 c2s35_4 0 0.2138f
Cc2s35_5 c2s35_5 0 0.261f
Cc2s35_6 c2s35_6 0 0.2093f
CCc2s35_0 c2s35_0 c2s36_0 0.1087f
CCc2s35_2 c2s35_2 c2s36_2 0.05443f
CCc2s35_4 c2s35_4 c2s36_4 0.0491f
CCc2s35_6 c2s35_6 c2s36_6 0.09108f
Rc2s36_0 c2s36_0 c2s36_1 2.833
Rc2s36_1 c2s36_1 c2s36_2 3.304
Rc2s36_2 c2s36_2 c2s36_3 2.68
Rc2s36_3 c2s36_3 c2s36_4 3.031
Rc2s36_4 c2s36_4 c2s36_5 1.659
Rc2s36_5 c2s36_5 c2s36_6 3.358
Cc2s36_0 c2s36_0 0 0.05553f
Cc2s36_1 c2s36_1 0 0.2758f
Cc2s36_2 c2s36_2 0 0.3989f
Cc2s36_3 c2s36_3 0 0.3807f
Cc2s36_4 c2s36_4 0 0.3127f
Cc2s36_5 c2s36_5 0 0.3345f
Cc2s36_6 c2s36_6 0 0.2239f
CCc2s36_0 c2s36_0 c2s37_0 0.03875f
CCc2s36_2 c2s36_2 c2s37_2 0.1203f
CCc2s36_4 c2s36_4 c2s37_4 0.05564f
CCc2s36_6 c2s36_6 c2s37_6 0.02051f
Rc2s37_0 c2s37_0 c2s37_1 2.831
Rc2s37_1 c2s37_1 c2s37_2 1.085
Rc2s37_2 c2s37_2 c2s37_3 2.855
Rc2s37_3 c2s37_3 c2s37_4 1.641
Rc2s37_4 c2s37_4 c2s37_5 1.968
Rc2s37_5 c2s37_5 c2s37_6 2.383
Cc2s37_0 c2s37_0 0 0.05539f
Cc2s37_1 c2s37_1 0 0.1277f
Cc2s37_2 c2s37_2 0 0.2626f
Cc2s37_3 c2s37_3 0 0.2997f
Cc2s37_4 c2s37_4 0 0.2406f
Cc2s37_5 c2s37_5 0 0.2901f
Cc2s37_6 c2s37_6 0 0.1589f
CCc2s37_0 c2s37_0 c2s38_0 0.05747f
CCc2s37_2 c2s37_2 c2s38_2 0.1094f
CCc2s37_4 c2s37_4 c2s38_4 0.114f
CCc2s37_6 c2s37_6 c2s38_6 0.149f
Rc2s38_0 c2s38_0 c2s38_1 4.034
Rc2s38_1 c2s38_1 c2s38_2 3.144
Rc2s38_2 c2s38_2 c2s38_3 3.498
Rc2s38_3 c2s38_3 c2s38_4 2.872
Rc2s38_4 c2s38_4 c2s38_5 1.777
Rc2s38_5 c2s38_5 c2s38_6 1.307
Cc2s38_0 c2s38_0 0 0.1356f
Cc2s38_1 c2s38_1 0 0.3452f
Cc2s38_2 c2s38_2 0 0.4428f
Cc2s38_3 c2s38_3 0 0.4247f
Cc2s38_4 c2s38_4 0 0.3099f
Cc2s38_5 c2s38_5 0 0.2056f
Cc2s38_6 c2s38_6 0 0.08712f
CCc2s38_0 c2s38_0 c2s39_0 0.03368f
CCc2s38_2 c2s38_2 c2s39_2 0.1363f
CCc2s38_4 c2s38_4 c2s39_4 0.03814f
CCc2s38_6 c2s38_6 c2s39_6 0.09833f
Rc2s39_0 c2s39_0 c2s39_1 3.88
Rc2s39_1 c2s39_1 c2s39_2 0.5913
Rc2s39_2 c2s39_2 c2s39_3 1.125
Rc2s39_3 c2s39_3 c2s39_4 3.042
Rc2s39_4 c2s39_4 c2s39_5 2.147
Rc2s39_5 c2s39_5 c2s39_6 3.362
Cc2s39_0 c2s39_0 0 0.1253f
Cc2s39_1 c2s39_1 0 0.1647f
Cc2s39_2 c2s39_2 0 0.1144f
Cc2s39_3 c2s39_3 0 0.2778f
Cc2s39_4 c2s39_4 0 0.3459f
Cc2s39_5 c2s39_5 0 0.3672f
Cc2s39_6 c2s39_6 0 0.2241f
CCc2s39_0 c2s39_0 c2s40_0 0.1471f
CCc2s39_2 c2s39_2 c2s40_2 0.03316f
CCc2s39_4 c2s39_4 c2s40_4 0.1149f
CCc2s39_6 c2s39_6 c2s40_6 0.02597f
Rc2s40_0 c2s40_0 c2s40_1 3.781
Rc2s40_1 c2s40_1 c2s40_2 1.842
Rc2s40_2 c2s40_2 c2s40_3 3.464
Rc2s40_3 c2s40_3 c2s40_4 2.325
Rc2s40_4 c2s40_4 c2s40_5 1.049
Rc2s40_5 c2s40_5 c2s40_6 2.056
Cc2s40_0 c2s40_0 0 0.1188f
Cc2s40_1 c2s40_1 0 0.2415f
Cc2s40_2 c2s40_2 0 0.3537f
Cc2s40_3 c2s40_3 0 0.386f
Cc2s40_4 c2s40_4 0 0.2249f
Cc2s40_5 c2s40_5 0 0.2069f
Cc2s40_6 c2s40_6 0 0.137f
CCc2s40_0 c2s40_0 c2s41_0 0.09306f
CCc2s40_2 c2s40_2 c2s41_2 0.04759f
CCc2s40_4 c2s40_4 c2s41_4 0.07036f
CCc2s40_6 c2s40_6 c2s41_6 0.1428f
Rc2s41_0 c2s41_0 c2s41_1 5.542
Rc2s41_1 c2s41_1 c2s41_2 2.897
Rc2s41_2 c2s41_2 c2s41_3 0.6532
Rc2s41_3 c2s41_3 c2s41_4 3.304
Rc2s41_4 c2s41_4 c2s41_5 1.894
Rc2s41_5 c2s41_5 c2s41_6 3.077
Cc2s41_0 c2s41_0 0 0.2361f
Cc2s41_1 c2s41_1 0 0.4293f
Cc2s41_2 c2s41_2 0 0.2367f
Cc2s41_3 c2s41_3 0 0.2638f
Cc2s41_4 c2s41_4 0 0.3465f
Cc2s41_5 c2s41_5 0 0.3314f
Cc2s41_6 c2s41_6 0 0.2052f
CCc2s41_0 c2s41_0 c2s42_0 0.04475f
CCc2s41_2 c2s41_2 c2s42_2 0.04068f
CCc2s41_4 c2s41_4 c2s42_4 0.1469f
CCc2s41_6 c2s41_6 c2s42_6 0.05997f
Rc2s42_0 c2s42_0 c2s42_1 2.586
Rc2s42_1 c2s42_1 c2s42_2 2.028
Rc2s42_2 c2s42_2 c2s42_3 3.57
Rc2s42_3 c2s42_3 c2s42_4 3.082
Rc2s42_4 c2s42_4 c2s42_5 1.698
Rc2s42_5 c2s42_5 c2s42_6 3.578
Cc2s42_0 c2s42_0 0 0.03904f
Cc2s42_1 c2s42_1 0 0.1743f
Cc2s42_2 c2s42_2 0 0.3732f
Cc2s42_3 c2s42_3 0 0.4435f
Cc2s42_4 c2s42_4 0 0.3187f
Cc2s42_5 c2s42_5 0 0.3518f
Cc2s42_6 c2s42_6 0 0.2385f
CCc2s42_0 c2s42_0 c2s43_0 0.1315f
CCc2s42_2 c2s42_2 c2s43_2 0.1379f
CCc2s42_4 c2s42_4 c2s43_4 0.1105f
CCc2s42_6 c2s42_6 c2s43_6 0.07521f
Rc2s43_0 c2s43_0 c2s43_1 5.303
Rc2s43_1 c2s43_1 c2s43_2 1.932
Rc2s43_2 c2s43_2 c2s43_3 3.394
Rc2s43_3 c2s43_3 c2s43_4 2.189
Rc2s43_4 c2s43_4 c2s43_5 3.316
Rc2s43_5 c2s43_5 c2s43_6 1.953
Cc2s43_0 c2s43_0 0 0.2202f
Cc2s43_1 c2s43_1 0 0.349f
Cc2s43_2 c2s43_2 0 0.3551f
Cc2s43_3 c2s43_3 0 0.3722f
Cc2s43_4 c2s43_4 0 0.367f
Cc2s43_5 c2s43_5 0 0.3513f
Cc2s43_6 c2s43_6 0 0.1302f
CCc2s43_0 c2s43_0 c2s44_0 0.07975f
CCc2s43_2 c2s43_2 c2s44_2 0.1024f
CCc2s43_4 c2s43_4 c2s44_4 0.06442f
CCc2s43_6 c2s43_6 c2s44_6 0.04092f
Rc2s44_0 c2s44_0 c2s44_1 4.306
Rc2s44_1 c2s44_1 c2s44_2 3.131
Rc2s44_2 c2s44_2 c2s44_3 1.325
Rc2s44_3 c2s44_3 c2s44_4 3.175
Rc2s44_4 c2s44_4 c2s44_5 2.929
Rc2s44_5 c2s44_5 c2s44_6 2.893
Cc2s44_0 c2s44_0 0 0.1538f
Cc2s44_1 c2s44_1 0 0.3625f
Cc2s44_2 c2s44_2 0 0.297f
Cc2s44_3 c2s44_3 0 0.3f
Cc2s44_4 c2s44_4 0 0.407f
Cc2s44_5 c2s44_5 0 0.3882f
Cc2s44_6 c2s44_6 0 0.1929f
CCc2s44_0 c2s44_0 c2s45_0 0.07812f
CCc2s44_2 c2s44_2 c2s45_2 0.1598f
CCc2s44_4 c2s44_4 c2s45_4 0.1307f
CCc2s44_6 c2s44_6 c2s45_6 0.1006f
Rc2s45_0 c2s45_0 c2s45_1 2.808
Rc2s45_1 c2s45_1 c2s45_2 2.258
Rc2s45_2 c2s45_2 c2s45_3 0.4953
Rc2s45_3 c2s45_3 c2s45_4 3.292
Rc2s45_4 c2s45_4 c2s45_5 1.511
Rc2s45_5 c2s45_5 c2s45_6 1.61
Cc2s45_0 c2s45_0 0 0.05384f
Cc2s45_1 c2s45_1 0 0.2043f
Cc2s45_2 c2s45_2 0 0.1835f
Cc2s45_3 c2s45_3 0 0.2525f
Cc2s45_4 c2s45_4 0 0.3202f
Cc2s45_5 c2s45_5 0 0.2081f
Cc2s45_6 c2s45_6 0 0.1074f
CCc2s45_0 c2s45_0 c2s46_0 0.09712f
CCc2s45_2 c2s45_2 c2s46_2 0.1092f
CCc2s45_4 c2s45_4 c2s46_4 0.1016f
CCc2s45_6 c2s45_6 c2s46_6 0.08789f
Rc2s46_0 c2s46_0 c2s46_1 4.448
Rc2s46_1 c2s46_1 c2s46_2 3.118
Rc2s46_2 c2s46_2 c2s46_3 1.856
Rc2s46_3 c2s46_3 c2s46_4 2.025
Rc2s46_4 c2s46_4 c2s46_5 3.003
Rc2s46_5 c2s46_5 c2s46_6 0.4607
Cc2s46_0 c2s46_0 0 0.1632f
Cc2s46_1 c2s46_1 0 0.3711f
Cc2s46_2 c2s46_2 0 0.3316f
Cc2s46_3 c2s46_3 0 0.2587f
Cc2s46_4 c2s46_4 0 0.3352f
Cc2s46_5 c2s46_5 0 0.2309f
Cc2s46_6 c2s46_6 0 0.03072f
CCc2s46_0 c2s46_0 c2s47_0 0.0425f
CCc2s46_2 c2s46_2 c2s47_2 0.0655f
CCc2s46_4 c2s46_4 c2s47_4 0.04995f
CCc2s46_6 c2s46_6 c2s47_6 0.1454f
Rc2s47_0 c2s47_0 c2s47_1 2.917
Rc2s47_1 c2s47_1 c2s47_2 0.7898
Rc2s47_2 c2s47_2 c2s47_3 1.449
Rc2s47_3 c2s47_3 c2s47_4 2.052
Rc2s47_4 c2s47_4 c2s47_5 3.038
Rc2s47_5 c2s47_5 c2s47_6 3.586
Cc2s47_0 c2s47_0 0 0.06113f
Cc2s47_1 c2s47_1 0 0.1138f
Cc2s47_2 c2s47_2 0 0.1493f
Cc2s47_3 c2s47_3 0 0.2334f
Cc2s47_4 c2s47_4 0 0.3393f
Cc2s47_5 c2s47_5 0 0.4416f
Cc2s47_6 c2s47_6 0 0.2391f
CCc2s47_0 c2s47_0 c2s48_0 0.1393f
CCc2s47_2 c2s47_2 c2s48_2 0.1052f
CCc2s47_4 c2s47_4 c2s48_4 0.02526f
CCc2s47_6 c2s47_6 c2s48_6 0.02889f
Rc2s48_0 c2s48_0 c2s48_1 4.437
Rc2s48_1 c2s48_1 c2s48_2 3.033
Rc2s48_2 c2s48_2 c2s48_3 1.286
Rc2s48_3 c2s48_3 c2s48_4 3.503
Rc2s48_4 c2s48_4 c2s48_5 2.184
Rc2s48_5 c2s48_5 c2s48_6 2.257
Cc2s48_0 c2s48_0 0 0.1625f
Cc2s48_1 c2s48_1 0 0.3646f
Cc2s48_2 c2s48_2 0 0.2879f
Cc2s48_3 c2s48_3 0 0.3193f
Cc2s48_4 c2s48_4 0 0.3791f
Cc2s48_5 c2s48_5 0 0.2961f
Cc2s48_6 c2s48_6 0 0.1505f
CCc2s48_0 c2s48_0 c2s49_0 0.1066f
Cc2s49_0 c2s49_0 0 0f
CCc2s49_0 c2s49_0 c3s0_0 0.03049f
Rc3s0_0 c3s0_0 c3s0_1 2.987
Rc3s0_1 c3s0_1 c3s0_2 3.399
Rc3s0_2 c3s0_2 c3s0_3 1.292
Rc3s0_3 c3s0_3 c3s0_4 0.7124
Rc3s0_4 c3s0_4 c3s0_5 1.34
Rc3s0_5 c3s0_5 c3s0_6 2.737
Cc3s0_0 c3s0_0 0 0.06578f
Cc3s0_1 c3s0_1 0 0.2924f
Cc3s0_2 c3s0_2 0 0.3127f
Cc3s0_3 c3s0_3 0 0.1336f
Cc3s0_4 c3s0_4 0 0.1368f
Cc3s0_5 c3s0_5 0 0.2718f
Cc3s0_6 c3s0_6 0 0.1825f
CCc3s0_0 c3s0_0 c3s1_0 0.05679f
CCc3s0_2 c3s0_2 c3s1_2 0.04948f
CCc3s0_4 c3s0_4 c3s1_4 0.0588f
CCc3s0_6 c3s0_6 c3s1_6 0.08726f
Rc3s1_0 c3s1_0 c3s1_1 4.773
Rc3s1_1 c3s1_1 c3s1_2 1.399
Rc3s1_2 c3s1_2 c3s1_3 3.202
Rc3s1_3 c3s1_3 c3s1_4 3.524
Rc3s1_4 c3s1_4 c3s1_5 3.039
Rc3s1_5 c3s1_5 c3s1_6 0.6866
Cc3s1_0 c3s1_0 0 0.1849f
Cc3s1_1 c3s1_1 0 0.2782f
Cc3s1_2 c3s1_2 0 0.3067f
Cc3s1_3 c3s1_3 0 0.4484f
Cc3s1_4 c3s1_4 0 0.4376f
Cc3s1_5 c3s1_5 0 0.2484f
Cc3s1_6 c3s1_6 0 0.04578f
CCc3s1_0 c3s1_0 c3s2_0 0.06416f
CCc3s1_2 c3s1_2 c3s2_2 0.1496f
CCc3s1_4 c3s1_4 c3s2_4 0.1403f
CCc3s1_6 c3s1_6 c3s2_6 0.03866f
Rc3s2_0 c3s2_0 c3s2_1 3.843
Rc3s2_1 c3s2_1 c3s2_2 1.596
Rc3s2_2 c3s2_2 c3s2_3 2.805
Rc3s2_3 c3s2_3 c3s2_4 0.5404
Rc3s2_4 c3s2_4 c3s2_5 1.444
Rc3s2_5 c3s2_5 c3s2_6 2.812
Cc3s2_0 c3s2_0 0 0.1229f
Cc3s2_1 c3s2_1 0 0.2293f
Cc3s2_2 c3s2_2 0 0.2934f
Cc3s2_3 c3s2_3 0 0.223f
Cc3s2_4 c3s2_4 0 0.1323f
Cc3s2_5 c3s2_5 0 0.2837f
Cc3s2_6 c3s2_6 0 0.1875f
CCc3s2_0 c3s2_0 c3s3_0 0.1442f
CCc3s2_2 c3s2_2 c3s3_2 0.02569f
CCc3s2_4 c3s2_4 c3s3_4 0.1024f
CCc3s2_6 c3s2_6 c3s3_6 0.1129f
Rc3s3_0 c3s3_0 c3s3_1 5.2
Rc3s3_1 c3s3_1 c3s3_2 1.787
Rc3s3_2 c3s3_2 c3s3_3 3.515
Rc3s3_3 c3s3_3 c3s3_4 1.072
Rc3s3_4 c3s3_4 c3s3_5 0.8115
Rc3s3_5 c3s3_5 c3s3_6 0.8596
Cc3s3_0 c3s3_0 0 0.2133f
Cc3s3_1 c3s3_1 0 0.3325f
Cc3s3_2 c3s3_2 0 0.3535f
Cc3s3_3 c3s3_3 0 0.3058f
Cc3s3_4 c3s3_4 0 0.1256f
Cc3s3_5 c3s3_5 0 0.1114f
Cc3s3_6 c3s3_6 0 0.05731f
CCc3s3_0 c3s3_0 c3s4_0 0.1021f
CCc3s3_2 c3s3_2 c3s4_2 0.03714f
CCc3s3_4 c3s3_4 c3s4_4 0.05732f
CCc3s3_6 c3s3_6 c3s4_6 0.04748f
Rc3s4_0 c3s4_0 c3s4_1 2.624
Rc3s4_1 c3s4_1 c3s4_2 3.482
Rc3s4_2 c3s4_2 c3s4_3 1.505
Rc3s4_3 c3s4_3 c3s4_4 3.487
Rc3s4_4 c3s4_4 c3s4_5 2.728
Rc3s4_5 c3s4_5 c3s4_6 1.142
Cc3s4_0 c3s4_0 0 0.04161f
Cc3s4_1 c3s4_1 0 0.2737f
Cc3s4_2 c3s4_2 0 0.3324f
Cc3s4_3 c3s4_3 0 0.3328f
Cc3s4_4 c3s4_4 0 0.4143f
Cc3s4_5 c3s4_5 0 0.258f
Cc3s4_6 c3s4_6 0 0.07615f
CCc3s4_0 c3s4_0 c3s5_0 0.1506f
CCc3s4_2 c3s4_2 c3s5_2 0.02131f
CCc3s4_4 c3s4_4 c3s5_4 0.1574f
CCc3s4_6 c3s4_6 c3s5_6 0.02452f
Rc3s5_0 c3s5_0 c3s5_1 3.248
Rc3s5_1 c3s5_1 c3s5_2 2.189
Rc3s5_2 c3s5_2 c3s5_3 0.4789
Rc3s5_3 c3s5_3 c3s5_4 2.859
Rc3s5_4 c3s5_4 c3s5_5 0.7167
Rc3s5_5 c3s5_5 c3s5_6 3.024
Cc3s5_0 c3s5_0 0 0.0832f
Cc3s5_1 c3s5_1 0 0.2291f
Cc3s5_2 c3s5_2 0 0.1778f
Cc3s5_3 c3s5_3 0 0.2225f
Cc3s5_4 c3s5_4 0 0.2384f
Cc3s5_5 c3s5_5 0 0.2494f
Cc3s5_6 c3s5_6 0 0.2016f
CCc3s5_0 c3s5_0 c3s6_0 0.02491f
CCc3s5_2 c3s5_2 c3s6_2 0.09394f
CCc3s5_4 c3s5_4 c3s6_4 0.04932f
CCc3s5_6 c3s5_6 c3s6_6 0.06043f
Rc3s6_0 c3s6_0 c3s6_1 3.995
Rc3s6_1 c3s6_1 c3s6_2 1.62
Rc3s6_2 c3s6_2 c3s6_3 1.685
Rc3s6_3 c3s6_3 c3s6_4 2.508
Rc3s6_4 c3s6_4 c3s6_5 1.065
Rc3s6_5 c3s6_5 c3s6_6 1.022
Cc3s6_0 c3s6_0 0 0.133f
Cc3s6_1 c3s6_1 0 0.241f
Cc3s6_2 c3s6_2 0 0.2203f
Cc3s6_3 c3s6_3 0 0.2795f
Cc3s6_4 c3s6_4 0 0.2382f
Cc3s6_5 c3s6_5 0 0.1391f
Cc3s6_6 c3s6_6 0 0.06812f
CCc3s6_0 c3s6_0 c3s7_0 0.1158f
CCc3s6_2 c3s6_2 c3s7_2 0.06157f
CCc3s6_4 c3s6_4 c3s7_4 0.1506f
CCc3s6_6 c3s6_6 c3s7_6 0.07967f
Rc3s7_0 c3s7_0 c3s7_1 3.943
Rc3s7_1 c3s7_1 c3s7_2 0.523
Rc3s7_2 c3s7_2 c3s7_3 0.5151
Rc3s7_3 c3s7_3 c3s7_4 0.78
Rc3s7_4 c3s7_4 c3s7_5 2.421
Rc3s7_5 c3s7_5 c3s7_6 2.543
Cc3s7_0 c3s7_0 0 0.1295f
Cc3s7_1 c3s7_1 0 0.1644f
Cc3s7_2 c3s7_2 0 0.0692f
Cc3s7_3 c3s7_3 0 0.08634f
Cc3s7_4 c3s7_4 0 0.2134f
Cc3s7_5 c3s7_5 0 0.3309f
Cc3s7_6 c3s7_6 0 0.1696f
CCc3s7_0 c3s7_0 c3s8_0 0.1533f
CCc3s7_2 c3s7_2 c3s8_2 0.08055f
CCc3s7_4 c3s7_4 c3s8_4 0.1191f
CCc3s7_6 c3s7_6 c3s8_6 0.0681f
Rc3s8_0 c3s8_0 c3s8_1 2.683
Rc3s8_1 c3s8_1 c3s8_2 1.774
Rc3s8_2 c3s8_2 c3s8_3 2.66
Rc3s8_3 c3s8_3 c3s8_4 2.983
Rc3s8_4 c3s8_4 c3s8_5 3.449
Rc3s8_5 c3s8_5 c3s8_6 3.071
Cc3s8_0 c3s8_0 0 0.04555f
Cc3s8_1 c3s8_1 0 0.1638f
Cc3s8_2 c3s8_2 0 0.2956f
Cc3s8_3 c3s8_3 0 0.3762f
Cc3s8_4 c3s8_4 0 0.4288f
Cc3s8_5 c3s8_5 0 0.4347f
Cc3s8_6 c3s8_6 0 0.2048f
CCc3s8_0 c3s8_0 c3s9_0 0.09891f
CCc3s8_2 c3s8_2 c3s9_2 0.09705f
CCc3s8_4 c3s8_4 c3s9_4 0.09015f
CCc3s8_6 c3s8_6 c3s9_6 0.08686f
Rc3s9_0 c3s9_0 c3s9_1 4.594
Rc3s9_1 c3s9_1 c3s9_2 2.263
Rc3s9_2 c3s9_2 c3s9_3 3.15
Rc3s9_3 c3s9_3 c3s9_4 1.868
Rc3s9_4 c3s9_4 c3s9_5 1.934
Rc3s9_5 c3s9_5 c3s9_6 3.071
Cc3s9_0 c3s9_0 0 0.1729f
Cc3s9_1 c3s9_1 0 0.3238f
Cc3s9_2 c3s9_2 0 0.3609f
Cc3s9_3 c3s9_3 0 0.3345f
Cc3s9_4 c3s9_4 0 0.2535f
Cc3s9_5 c3s9_5 0 0.3337f
Cc3s9_6 c3s9_6 0 0.2047f
CCc3s9_0 c3s9_0 c3s10_0 0.1146f
CCc3s9_2 c3s9_2 c3s10_2 0.09342f
CCc3s9_4 c3s9_4 c3s10_4 0.09888f
CCc3s9_6 c3s9_6 c3s10_6 0.1328f
Rc3s10_0 c3s10_0 c3s10_1 4.363
Rc3s10_1 c3s10_1 c3s10_2 1.266
Rc3s10_2 c3s10_2 c3s10_3 1.427
Rc3s10_3 c3s10_3 c3s10_4 2.355
Rc3s10_4 c3s10_4 c3s10_5 0.5944
Rc3s10_5 c3s10_5 c3s10_6 1.891
Cc3s10_0 c3s10_0 0 0.1576f
Cc3s10_1 c3s10_1 0 0.242f
Cc3s10_2 c3s10_2 0 0.1796f
Cc3s10_3 c3s10_3 0 0.2521f
Cc3s10_4 c3s10_4 0 0.1966f
Cc3s10_5 c3s10_5 0 0.1657f
Cc3s10_6 c3s10_6 0 0.1261f
CCc3s10_0 c3s10_0 c3s11_0 0.1449f
CCc3s10_2 c3s10_2 c3s11_2 0.0525f
CCc3s10_4 c3s10_4 c3s11_4 0.08218f
CCc3s10_6 c3s10_6 c3s11_6 0.1179f
Rc3s11_0 c3s11_0 c3s11_1 5.365
Rc3s11_1 c3s11_1 c3s11_2 2.643
Rc3s11_2 c3s11_2 c3s11_3 2.421
Rc3s11_3 c3s11_3 c3s11_4 1.659
Rc3s11_4 c3s11_4 c3s11_5 1.828
Rc3s11_5 c3s11_5 c3s11_6 2.472
Cc3s11_0 c3s11_0 0 0.2244f
Cc3s11_1 c3s11_1 0 0.4006f
Cc3s11_2 c3s11_2 0 0.3376f
Cc3s11_3 c3s11_3 0 0.272f
Cc3s11_4 c3s11_4 0 0.2325f
Cc3s11_5 c3s11_5 0 0.2867f
Cc3s11_6 c3s11_6 0 0.1648f
CCc3s11_0 c3s11_0 c3s12_0 0.06988f
CCc3s11_2 c3s11_2 c3s12_2 0.1299f
CCc3s11_4 c3s11_4 c3s12_4 0.02115f
CCc3s11_6 c3s11_6 c3s12_6 0.1252f
Rc3s12_0 c3s12_0 c3s12_1 4.787
Rc3s12_1 c3s12_1 c3s12_2 1.415
Rc3s12_2 c3s12_2 c3s12_3 0.4971
Rc3s12_3 c3s12_3 c3s12_4 1.515
Rc3s12_4 c3s12_4 c3s12_5 2.306
Rc3s12_5 c3s12_5 c3s12_6 2.929
Cc3s12_0 c3s12_0 0 0.1858f
Cc3s12_1 c3s12_1 0 0.2802f
Cc3s12_2 c3s12_2 0 0.1275f
Cc3s12_3 c3s12_3 0 0.1342f
Cc3s12_4 c3s12_4 0 0.2547f
Cc3s12_5 c3s12_5 0 0.349f
Cc3s12_6 c3s12_6 0 0.1953f
CCc3s12_0 c3s12_0 c3s13_0 0.1419f
CCc3s12_2 c3s12_2 c3s13_2 0.0492f
CCc3s12_4 c3s12_4 c3s13_4 0.03144f
CCc3s12_6 c3s12_6 c3s13_6 0.03678f
Rc3s13_0 c3s13_0 c3s13_1 5.566
Rc3s13_1 c3s13_1 c3s13_2 2.483
Rc3s13_2 c3s13_2 c3s13_3 0.8543
Rc3s13_3 c3s13_3 c3s13_4 2.626
Rc3s13_4 c3s13_4 c3s13_5 3.472
Rc3s13_5 c3s13_5 c3s13_6 2.363
Cc3s13_0 c3s13_0 0 0.2377f
Cc3s13_1 c3s13_1 0 0.4032f
Cc3s13_2 c3s13_2 0 0.2225f
Cc3s13_3 c3s13_3 0 0.232f
Cc3s13_4 c3s13_4 0 0.4066f
Cc3s13_5 c3s13_5 0 0.3891f
Cc3s13_6 c3s13_6 0 0.1576f
CCc3s13_0 c3s13_0 c3s14_0 0.05256f
CCc3s13_2 c3s13_2 c3s14_2 0.1547f
CCc3s13_4 c3s13_4 c3s14_4 0.1181f
CCc3s13_6 c3s13_6 c3s14_6 0.04562f
Rc3s14_0 c3s14_0 c3s14_1 4.864
Rc3s14_1 c3s14_1 c3s14_2 2.038
Rc3s14_2 c3s14_2 c3s14_3 2.258
Rc3s14_3 c3s14_3 c3s14_4 1.602
Rc3s14_4 c3s14_4 c3s14_5 1.375
Rc3s14_5 c3s14_5 c3s14_6 1.774
Cc3s14_0 c3s14_0 0 0.1909f
Cc3s14_1 c3s14_1 0 0.3268f
Cc3s14_2 c3s14_2 0 0.2864f
Cc3s14_3 c3s14_3 0 0.2574f
Cc3s14_4 c3s14_4 0 0.1985f
Cc3s14_5 c3s14_5 0 0.21f
Cc3s14_6 c3s14_6 0 0.1183f
CCc3s14_0 c3s14_0 c3s15_0 0.0937f
CCc3s14_2 c3s14_2 c3s15_2 0.0846f
CCc3s14_4 c3s14_4 c3s15_4 0.1413f
CCc3s14_6 c3s14_6 c3s15_6 0.03039f
Rc3s15_0 c3s15_0 c3s15_1 3.077
Rc3s15_1 c3s15_1 c3s15_2 3.403
Rc3s15_2 c3s15_2 c3s15_3 2.365
Rc3s15_3 c3s15_3 c3s15_4 2.395
Rc3s15_4 c3s15_4 c3s15_5 2.434
Rc3s15_5 c3s15_5 c3s15_6 1.217
Cc3s15_0 c3s15_0 0 0.07179f
Cc3s15_1 c3s15_1 0 0.2987f
Cc3s15_2 c3s15_2 0 0.3845f
Cc3s15_3 c3s15_3 0 0.3173f
Cc3s15_4 c3s15_4 0 0.3219f
Cc3s15_5 c3s15_5 0 0.2434f
Cc3s15_6 c3s15_6 0 0.08113f
CCc3s15_0 c3s15_0 c3s16_0 0.07526f
CCc3s15_2 c3s15_2 c3s16_2 0.04942f
CCc3s15_4 c3s15_4 c3s16_4 0.04128f
CCc3s15_6 c3s15_6 c3s16_6 0.1585f
Rc3s16_0 c3s16_0 c3s16_1 4.793
Rc3s16_1 c3s16_1 c3s16_2 3.219
Rc3s16_2 c3s16_2 c3s16_3 0.4546
Rc3s16_3 c3s16_3 c3s16_4 2.669
Rc3s16_4 c3s16_4 c3s16_5 1.418
Rc3s16_5 c3s16_5 c3s16_6 2.018
Cc3s16_0 c3s16_0 0 0.1862f
Cc3s16_1 c3s16_1 0 0.4008f
Cc3s16_2 c3s16_2 0 0.2449f
Cc3s16_3 c3s16_3 0 0.2082f
Cc3s16_4 c3s16_4 0 0.2725f
Cc3s16_5 c3s16_5 0 0.2291f
Cc3s16_6 c3s16_6 0 0.1346f
CCc3s16_0 c3s16_0 c3s17_0 0.1145f
CCc3s16_2 c3s16_2 c3s17_2 0.02437f
CCc3s16_4 c3s16_4 c3s17_4 0.07191f
CCc3s16_6 c3s16_6 c3s17_6 0.09755f
Rc3s17_0 c3s17_0 c3s17_1 5.204
Rc3s17_1 c3s17_1 c3s17_2 2.067
Rc3s17_2 c3s17_2 c3s17_3 1.45
Rc3s17_3 c3s17_3 c3s17_4 2.352
Rc3s17_4 c3s17_4 c3s17_5 2.288
Rc3s17_5 c3s17_5 c3s17_6 1.371
Cc3s17_0 c3s17_0 0 0.2136f
Cc3s17_1 c3s17_1 0 0.3514f
Cc3s17_2 c3s17_2 0 0.2345f
Cc3s17_3 c3s17_3 0 0.2535f
Cc3s17_4 c3s17_4 0 0.3093f
Cc3s17_5 c3s17_5 0 0.2439f
Cc3s17_6 c3s17_6 0 0.09138f
CCc3s17_0 c3s17_0 c3s18_0 0.09673f
CCc3s17_2 c3s17_2 c3s18_2 0.05866f
CCc3s17_4 c3s17_4 c3s18_4 0.02158f
CCc3s17_6 c3s17_6 c3s18_6 0.0635f
Rc3s18_0 c3s18_0 c3s18_1 2.722
Rc3s18_1 c3s18_1 c3s18_2 1.999
Rc3s18_2 c3s18_2 c3s18_3 2.029
Rc3s18_3 c3s18_3 c3s18_4 3.191
Rc3s18_4 c3s18_4 c3s18_5 2.806
Rc3s18_5 c3s18_5 c3s18_6 2.811
Cc3s18_0 c3s18_0 0 0.04815f
Cc3s18_1 c3s18_1 0 0.1814f
Cc3s18_2 c3s18_2 0 0.2685f
Cc3s18_3 c3s18_3 0 0.348f
Cc3s18_4 c3s18_4 0 0.3998f
Cc3s18_5 c3s18_5 0 0.3744f
Cc3s18_6 c3s18_6 0 0.1874f
CCc3s18_0 c3s18_0 c3s19_0 0.1586f
CCc3s18_2 c3s18_2 c3s19_2 0.05705f
CCc3s18_4 c3s18_4 c3s19_4 0.07218f
CCc3s18_6 c3s18_6 c3s19_6 0.05228f
Rc3s19_0 c3s19_0 c3s19_1 2.773
Rc3s19_1 c3s19_1 c3s19_2 2.073
Rc3s19_2 c3s19_2 c3s19_3 2.061
Rc3s19_3 c3s19_3 c3s19_4 0.8586
Rc3s19_4 c3s19_4 c3s19_5 3.356
Rc3s19_5 c3s19_5 c3s19_6 3.532
Cc3s19_0 c3s19_0 0 0.05152f
Cc3s19_1 c3s19_1 0 0.1897f
Cc3s19_2 c3s19_2 0 0.2756f
Cc3s19_3 c3s19_3 0 0.1946f
Cc3s19_4 c3s19_4 0 0.281f
Cc3s19_5 c3s19_5 0 0.4592f
Cc3s19_6 c3s19_6 0 0.2355f
CCc3s19_0 c3s19_0 c3s20_0 0.02956f
CCc3s19_2 c3s19_2 c3s20_2 0.02044f
CCc3s19_4 c3s19_4 c3s20_4 0.02865f
CCc3s19_6 c3s19_6 c3s20_6 0.1224f
Rc3s20_0 c3s20_0 c3s20_1 5.135
Rc3s20_1 c3s20_1 c3s20_2 0.6584
Rc3s20_2 c3s20_2 c3s20_3 0.4782
Rc3s20_3 c3s20_3 c3s20_4 2.145
Rc3s20_4 c3s20_4 c3s20_5 1.498
Rc3s20_5 c3s20_5 c3s20_6 0.509
Cc3s20_0 c3s20_0 0 0.209f
Cc3s20_1 c3s20_1 0 0.2529f
Cc3s20_2 c3s20_2 0 0.07578f
Cc3s20_3 c3s20_3 0 0.1749f
Cc3s20_4 c3s20_4 0 0.2428f
Cc3s20_5 c3s20_5 0 0.1338f
Cc3s20_6 c3s20_6 0 0.03393f
CCc3s20_0 c3s20_0 c3s21_0 0.02123f
CCc3s20_2 c3s20_2 c3s21_2 0.04959f
CCc3s20_4 c3s20_4 c3s21_4 0.04802f
CCc3s20_6 c3s20_6 c3s21_6 0.06135f
Rc3s21_0 c3s21_0 c3s21_1 4.185
Rc3s21_1 c3s21_1 c3s21_2 1.242
Rc3s21_2 c3s21_2 c3s21_3 1.186
Rc3s21_3 c3s21_3 c3s21_4 1.114
Rc3s21_4 c3s21_4 c3s21_5 3.244
Rc3s21_5 c3s21_5 c3s21_6 1.202
Cc3s21_0 c3s21_0 0 0.1456f
Cc3s21_1 c3s21_1 0 0.2284f
Cc3s21_2 c3s21_2 0 0.1618f
Cc3s21_3 c3s21_3 0 0.1533f
Cc3s21_4 c3s21_4 0 0.2905f
Cc3s21_5 c3s21_5 0 0.2964f
Cc3s21_6 c3s21_6 0 0.0801f
CCc3s21_0 c3s21_0 c3s22_0 0.09775f
CCc3s21_2 c3s21_2 c3s22_2 0.08337f
CCc3s21_4 c3s21_4 c3s22_4 0.0664f
CCc3s21_6 c3s21_6 c3s22_6 0.07695f
Rc3s22_0 c3s22_0 c3s22_1 2.5
Rc3s22_1 c3s22_1 c3s22_2 1.033
Rc3s22_2 c3s22_2 c3s22_3 2.466
Rc3s22_3 c3s22_3 c3s22_4 2.849
Rc3s22_4 c3s22_4 c3s22_5 1.138
Rc3s22_5 c3s22_5 c3s22_6 1.006
Cc3s22_0 c3s22_0 0 0.03336f
Cc3s22_1 c3s22_1 0 0.1022f
Cc3s22_2 c3s22_2 0 0.2333f
Cc3s22_3 c3s22_3 0 0.3543f
Cc3s22_4 c3s22_4 0 0.2658f
Cc3s22_5 c3s22_5 0 0.1429f
Cc3s22_6 c3s22_6 0 0.06707f
CCc3s22_0 c3s22_0 c3s23_0 0.1468f
CCc3s22_2 c3s22_2 c3s23_2 0.03369f
CCc3s22_4 c3s22_4 c3s23_4 0.1313f
CCc3s22_6 c3s22_6 c3s23_6 0.1429f
Rc3s23_0 c3s23_0 c3s23_1 2.911
Rc3s23_1 c3s23_1 c3s23_2 3.074
Rc3s23_2 c3s23_2 c3s23_3 0.9227
Rc3s23_3 c3s23_3 c3s23_4 0.5858
Rc3s23_4 c3s23_4 c3s23_5 1.352
Rc3s23_5 c3s23_5 c3s23_6 1.535
Cc3s23_0 c3s23_0 0 0.06072f
Cc3s23_1 c3s23_1 0 0.2656f
Cc3s23_2 c3s23_2 0 0.2664f
Cc3s23_3 c3s23_3 0 0.1006f
Cc3s23_4 c3s23_4 0 0.1292f
Cc3s23_5 c3s23_5 0 0.1924f
Cc3s23_6 c3s23_6 0 0.1023f
CCc3s23_0 c3s23_0 c3s24_0 0.1025f
CCc3s23_2 c3s23_2 c3s24_2 0.08195f
CCc3s23_4 c3s23_4 c3s24_4 0.1311f
CCc3s23_6 c3s23_6 c3s24_6 0.1131f
Rc3s24_0 c3s24_0 c3s24_1 2.825
Rc3s24_1 c3s24_1 c3s24_2 1.087
Rc3s24_2 c3s24_2 c3s24_3 2.8
Rc3s24_3 c3s24_3 c3s24_4 0.8152
Rc3s24_4 c3s24_4 c3s24_5 3.451
Rc3s24_5 c3s24_5 c3s24_6 3.006
Cc3s24_0 c3s24_0 0 0.05503f
Cc3s24_1 c3s24_1 0 0.1275f
Cc3s24_2 c3s24_2 0 0.2592f
Cc3s24_3 c3s24_3 0 0.241f
Cc3s24_4 c3s24_4 0 0.2844f
Cc3s24_5 c3s24_5 0 0.4305f
Cc3s24_6 c3s24_6 0 0.2004f
CCc3s24_0 c3s24_0 c3s25_0 0.05078f
CCc3s24_2 c3s24_2 c3s25_2 0.06006f
CCc3s24_4 c3s24_4 c3s25_4 0.0553f
CCc3s24_6 c3s24_6 c3s25_6 0.0792f
Rc3s25_0 c3s25_0 c3s25_1 3.233
Rc3s25_1 c3s25_1 c3s25_2 0.5516
Rc3s25_2 c3s25_2 c3s25_3 1.243
Rc3s25_3 c3s25_3 c3s25_4 1.064
Rc3s25_4 c3s25_4 c3s25_5 1.552
Rc3s25_5 c3s25_5 c3s25_6 1.881
Cc3s25_0 c3s25_0 0 0.08221f
Cc3s25_1 c3s25_1 0 0.119f
Cc3s25_2 c3s25_2 0 0.1196f
Cc3s25_3 c3s25_3 0 0.1538f
Cc3s25_4 c3s25_4 0 0.1744f
Cc3s25_5 c3s25_5 0 0.2289f
Cc3s25_6 c3s25_6 0 0.1254f
CCc3s25_0 c3s25_0 c3s26_0 0.1424f
CCc3s25_2 c3s25_2 c3s26_2 0.1123f
CCc3s25_4 c3s25_4 c3s26_4 0.1062f
CCc3s25_6 c3s25_6 c3s26_6 0.141f
Rc3s26_0 c3s26_0 c3s26_1 3.668
Rc3s26_1 c3s26_1 c3s26_2 1.792
Rc3s26_2 c3s26_2 c3s26_3 1.22
Rc3s26_3 c3s26_3 c3s26_4 3.065
Rc3s26_4 c3s26_4 c3s26_5 3.214
Rc3s26_5 c3s26_5 c3s26_6 3.319
Cc3s26_0 c3s26_0 0 0.1112f
Cc3s26_1 c3s26_1 0 0.2307f
Cc3s26_2 c3s26_2 0 0.2008f
Cc3s26_3 c3s26_3 0 0.2857f
Cc3s26_4 c3s26_4 0 0.4186f
Cc3s26_5 c3s26_5 0 0.4355f
Cc3s26_6 c3s26_6 0 0.2213f
CCc3s26_0 c3s26_0 c3s27_0 0.1047f
CCc3s26_2 c3s26_2 c3s27_2 0.03594f
CCc3s26_4 c3s26_4 c3s27_4 0.03012f
CCc3s26_6 c3s26_6 c3s27_6 0.1317f
Rc3s27_0 c3s27_0 c3s27_1 5.239
Rc3s27_1 c3s27_1 c3s27_2 2.127
Rc3s27_2 c3s27_2 c3s27_3 3.35
Rc3s27_3 c3s27_3 c3s27_4 3.382
Rc3s27_4 c3s27_4 c3s27_5 2.827
Rc3s27_5 c3s27_5 c3s27_6 1.617
Cc3s27_0 c3s27_0 0 0.2159f
Cc3s27_1 c3s27_1 0 0.3577f
Cc3s27_2 c3s27_2 0 0.3651f
Cc3s27_3 c3s27_3 0 0.4488f
Cc3s27_4 c3s27_4 0 0.414f
Cc3s27_5 c3s27_5 0 0.2963f
Cc3s27_6 c3s27_6 0 0.1078f
CCc3s27_0 c3s27_0 c3s28_0 0.08389f
CCc3s27_2 c3s27_2 c3s28_2 0.06926f
CCc3s27_4 c3s27_4 c3s28_4 0.07545f
CCc3s27_6 c3s27_6 c3s28_6 0.08598f
Rc3s28_0 c3s28_0 c3s28_1 2.504
Rc3s28_1 c3s28_1 c3s28_2 0.8511
Rc3s28_2 c3s28_2 c3s28_3 0.9792
Rc3s28_3 c3s28_3 c3s28_4 2.235
Rc3s28_4 c3s28_4 c3s28_5 3.196
Rc3s28_5 c3s28_5 c3s28_6 2.691
Cc3s28_0 c3s28_0 0 0.03359f
Cc3s28_1 c3s28_1 0 0.09034f
Cc3s28_2 c3s28_2 0 0.122f
Cc3s28_3 c3s28_3 0 0.2143f
Cc3s28_4 c3s28_4 0 0.3621f
Cc3s28_5 c3s28_5 0 0.3924f
Cc3s28_6 c3s28_6 0 0.1794f
CCc3s28_0 c3s28_0 c3s29_0 0.04093f
CCc3s28_2 c3s28_2 c3s29_2 0.08408f
CCc3s28_4 c3s28_4 c3s29_4 0.1078f
CCc3s28_6 c3s28_6 c3s29_6 0.03893f
Rc3s29_0 c3s29_0 c3s29_1 2.701
Rc3s29_1 c3s29_1 c3s29_2 2.378
Rc3s29_2 c3s29_2 c3s29_3 1.192
Rc3s29_3 c3s29_3 c3s29_4 2.482
Rc3s29_4 c3s29_4 c3s29_5 0.9904
Rc3s29_5 c3s29_5 c3s29_6 3.146
Cc3s29_0 c3s29_0 0 0.04673f
Cc3s29_1 c3s29_1 0 0.2053f
Cc3s29_2 c3s29_2 0 0.238f
Cc3s29_3 c3s29_3 0 0.2449f
Cc3s29_4 c3s29_4 0 0.2315f
Cc3s29_5 c3s29_5 0 0.2758f
Cc3s29_6 c3s29_6 0 0.2097f
CCc3s29_0 c3s29_0 c3s30_0 0.06336f
CCc3s29_2 c3s29_2 c3s30_2 0.07997f
CCc3s29_4 c3s29_4 c3s30_4 0.097f
CCc3s29_6 c3s29_6 c3s30_6 0.1441f
Rc3s30_0 c3s30_0 c3s30_1 5.337
Rc3s30_1 c3s30_1 c3s30_2 3.111
Rc3s30_2 c3s30_2 c3s30_3 2.606
Rc3s30_3 c3s30_3 c3s30_4 0.6679
Rc3s30_4 c3s30_4 c3s30_5 1.038
Rc3s30_5 c3s30_5 c3s30_6 2.134
Cc3s30_0 c3s30_0 0 0.2224f
Cc3s30_1 c3s30_1 0 0.4298f
Cc3s30_2 c3s30_2 0 0.3812f
Cc3s30_3 c3s30_3 0 0.2183f
Cc3s30_4 c3s30_4 0 0.1138f
Cc3s30_5 c3s30_5 0 0.2115f
Cc3s30_6 c3s30_6 0 0.1423f
CCc3s30_0 c3s30_0 c3s31_0 0.1579f
CCc3s30_2 c3s30_2 c3s31_2 0.1217f
CCc3s30_4 c3s30_4 c3s31_4 0.04683f
CCc3s30_6 c3s30_6 c3s31_6 0.06984f
Rc3s31_0 c3s31_0 c3s31_1 5.482
Rc3s31_1 c3s31_1 c3s31_2 2.049
Rc3s31_2 c3s31_2 c3s31_3 3.192
Rc3s31_3 c3s31_3 c3s31_4 3.153
Rc3s31_4 c3s31_4 c3s31_5 2.913
Rc3s31_5 c3s31_5 c3s31_6 2.425
Cc3s31_0 c3s31_0 0 0.2321f
Cc3s31_1 c3s31_1 0 0.3687f
Cc3s31_2 c3s31_2 0 0.3494f
Cc3s31_3 c3s31_3 0 0.4229f
Cc3s31_4 c3s31_4 0 0.4043f
Cc3s31_5 c3s31_5 0 0.3558f
Cc3s31_6 c3s31_6 0 0.1617f
CCc3s31_0 c3s31_0 c3s32_0 0.1132f
CCc3s31_2 c3s31_2 c3s32_2 0.06789f
CCc3s31_4 c3s31_4 c3s32_4 0.03686f
CCc3s31_6 c3s31_6 c3s32_6 0.1528f
Rc3s32_0 c3s32_0 c3s32_1 2.553
Rc3s32_1 c3s32_1 c3s32_2 1.303
Rc3s32_2 c3s32_2 c3s32_3 2.384
Rc3s32_3 c3s32_3 c3s32_4 3.49
Rc3s32_4 c3s32_4 c3s32_5 1.112
Rc3s32_5 c3s32_5 c3s32_6 1.228
Cc3s32_0 c3s32_0 0 0.03685f
Cc3s32_1 c3s32_1 0 0.1237f
Cc3s32_2 c3s32_2 0 0.2458f
Cc3s32_3 c3s32_3 0 0.3916f
Cc3s32_4 c3s32_4 0 0.3068f
Cc3s32_5 c3s32_5 0 0.156f
Cc3s32_6 c3s32_6 0 0.08186f
CCc3s32_0 c3s32_0 c3s33_0 0.1387f
CCc3s32_2 c3s32_2 c3s33_2 0.06579f
CCc3s32_4 c3s32_4 c3s33_4 0.07641f
CCc3s32_6 c3s32_6 c3s33_6 0.07036f
Rc3s33_0 c3s33_0 c3s33_1 2.606
Rc3s33_1 c3s33_1 c3s33_2 3.417
Rc3s33_2 c3s33_2 c3s33_3 2.648
Rc3s33_3 c3s33_3 c3s33_4 0.4715
Rc3s33_4 c3s33_4 c3s33_5 0.756
Rc3s33_5 c3s33_5 c3s33_6 0.8767
Cc3s33_0 c3s33_0 0 0.04039f
Cc3s33_1 c3s33_1 0 0.2682f
Cc3s33_2 c3s33_2 0 0.4043f
Cc3s33_3 c3s33_3 0 0.208f
Cc3s33_4 c3s33_4 0 0.08183f
Cc3s33_5 c3s33_5 0 0.1088f
Cc3s33_6 c3s33_6 0 0.05845f
CCc3s33_0 c3s33_0 c3s34_0 0.07164f
CCc3s33_2 c3s33_2 c3s34_2 0.1446f
CCc3s33_4 c3s33_4 c3s34_4 0.03972f
CCc3s33_6 c3s33_6 c3s34_6 0.05193f
Rc3s34_0 c3s34_0 c3s34_1 3.431
Rc3s34_1 c3s34_1 c3s34_2 2.059
Rc3s34_2 c3s34_2 c3s34_3 3.288
Rc3s34_3 c3s34_3 c3s34_4 2.149
Rc3s34_4 c3s34_4 c3s34_5 3.296
Rc3s34_5 c3s34_5 c3s34_6 2.157
Cc3s34_0 c3s34_0 0 0.0954f
Cc3s34_1 c3s34_1 0 0.2326f
Cc3s34_2 c3s34_2 0 0.3565f
Cc3s34_3 c3s34_3 0 0.3625f
Cc3s34_4 c3s34_4 0 0.363f
Cc3s34_5 c3s34_5 0 0.3636f
Cc3s34_6 c3s34_6 0 0.1438f
CCc3s34_0 c3s34_0 c3s35_0 0.0805f
CCc3s34_2 c3s34_2 c3s35_2 0.142f
CCc3s34_4 c3s34_4 c3s35_4 0.1013f
CCc3s34_6 c3s34_6 c3s35_6 0.0865f
Rc3s35_0 c3s35_0 c3s35_1 4.064
Rc3s35_1 c3s35_1 c3s35_2 1.57
Rc3s35_2 c3s35_2 c3s35_3 1.814
Rc3s35_3 c3s35_3 c3s35_4 0.6836
Rc3s35_4 c3s35_4 c3s35_5 1.096
Rc3s35_5 c3s35_5 c3s35_6 2.853
Cc3s35_0 c3s35_0 0 0.1376f
Cc3s35_1 c3s35_1 0 0.2423f
Cc3s35_2 c3s35_2 0 0.2256f
Cc3s35_3 c3s35_3 0 0.1665f
Cc3s35_4 c3s35_4 0 0.1187f
Cc3s35_5 c3s35_5 0 0.2633f
Cc3s35_6 c3s35_6 0 0.1902f
CCc3s35_0 c3s35_0 c3s36_0 0.0387f
CCc3s35_2 c3s35_2 c3s36_2 0.04915f
CCc3s35_4 c3s35_4 c3s36_4 0.0429f
CCc3s35_6 c3s35_6 c3s36_6 0.0708f
Rc3s36_0 c3s36_0 c3s36_1 2.605
Rc3s36_1 c3s36_1 c3s36_2 1.585
Rc3s36_2 c3s36_2 c3s36_3 2.371
Rc3s36_3 c3s36_3 c3s36_4 2.586
Rc3s36_4 c3s36_4 c3s36_5 3.182
Rc3s36_5 c3s36_5 c3s36_6 0.7243
Cc3s36_0 c3s36_0 0 0.04035f
Cc3s36_1 c3s36_1 0 0.146f
Cc3s36_2 c3s36_2 0 0.2637f
Cc3s36_3 c3s36_3 0 0.3304f
Cc3s36_4 c3s36_4 0 0.3845f
Cc3s36_5 c3s36_5 0 0.2604f
Cc3s36_6 c3s36_6 0 0.04829f
CCc3s36_0 c3s36_0 c3s37_0 0.1101f
CCc3s36_2 c3s36_2 c3s37_2 0.04748f
CCc3s36_4 c3s36_4 c3s37_4 0.06794f
CCc3s36_6 c3s36_6 c3s37_6 0.1005f
Rc3s37_0 c3s37_0 c3s37_1 5.09
Rc3s37_1 c3s37_1 c3s37_2 2.562
Rc3s37_2 c3s37_2 c3s37_3 3.554
Rc3s37_3 c3s37_3 c3s37_4 0.5065
Rc3s37_4 c3s37_4 c3s37_5 1.446
Rc3s37_5 c3s37_5 c3s37_6 1.963
Cc3s37_0 c3s37_0 0 0.206f
Cc3s37_1 c3s37_1 0 0.3768f
Cc3s37_2 c3s37_2 0 0.4077f
Cc3s37_3 c3s37_3 0 0.2707f
Cc3s37_4 c3s37_4 0 0.1301f
Cc3s37_5 c3s37_5 0 0.2273f
Cc3s37_6 c3s37_6 0 0.1309f
CCc3s37_0 c3s37_0 c3s38_0 0.02507f
CCc3s37_2 c3s37_2 c3s38_2 0.02733f
CCc3s37_4 c3s37_4 c3s38_4 0.07135f
CCc3s37_6 c3s37_6 c3s38_6 0.09828f
Rc3s38_0 c3s38_0 c3s38_1 2.877
Rc3s38_1 c3s38_1 c3s38_2 0.6652
Rc3s38_2 c3s38_2 c3s38_3 1.454
Rc3s38_3 c3s38_3 c3s38_4 2.786
Rc3s38_4 c3s38_4 c3s38_5 2.237
Rc3s38_5 c3s38_5 c3s38_6 3.59
Cc3s38_0 c3s38_0 0 0.05846f
Cc3s38_1 c3s38_1 0 0.1028f
Cc3s38_2 c3s38_2 0 0.1413f
Cc3s38_3 c3s38_3 0 0.2827f
Cc3s38_4 c3s38_4 0 0.3348f
Cc3s38_5 c3s38_5 0 0.3884f
Cc3s38_6 c3s38_6 0 0.2393f
CCc3s38_0 c3s38_0 c3s39_0 0.1047f
CCc3s38_2 c3s38_2 c3s39_2 0.1447f
CCc3s38_4 c3s38_4 c3s39_4 0.1002f
CCc3s38_6 c3s38_6 c3s39_6 0.08733f
Rc3s39_0 c3s39_0 c3s39_1 3.759
Rc3s39_1 c3s39_1 c3s39_2 0.6752
Rc3s39_2 c3s39_2 c3s39_3 0.6482
Rc3s39_3 c3s39_3 c3s39_4 2.524
Rc3s39_4 c3s39_4 c3s39_5 3.156
Rc3s39_5 c3s39_5 c3s39_6 0.51
Cc3s39_0 c3s39_0 0 0.1173f
Cc3s39_1 c3s39_1 0 0.1623f
Cc3s39_2 c3s39_2 0 0.08823f
Cc3s39_3 c3s39_3 0 0.2115f
Cc3s39_4 c3s39_4 0 0.3787f
Cc3s39_5 c3s39_5 0 0.2444f
Cc3s39_6 c3s39_6 0 0.034f
CCc3s39_0 c3s39_0 c3s40_0 0.04523f
CCc3s39_2 c3s39_2 c3s40_2 0.06585f
CCc3s39_4 c3s39_4 c3s40_4 0.06383f
CCc3s39_6 c3s39_6 c3s40_6 0.1368f
Rc3s40_0 c3s40_0 c3s40_1 3.245
Rc3s40_1 c3s40_1 c3s40_2 1.415
Rc3s40_2 c3s40_2 c3s40_3 1.986
Rc3s40_3 c3s40_3 c3s40_4 3.445
Rc3s40_4 c3s40_4 c3s40_5 1.378
Rc3s40_5 c3s40_5 c3s40_6 2.446
Cc3s40_0 c3s40_0 0 0.083f
Cc3s40_1 c3s40_1 0 0.1773f
Cc3s40_2 c3s40_2 0 0.2267f
Cc3s40_3 c3s40_3 0 0.3621f
Cc3s40_4 c3s40_4 0 0.3215f
Cc3s40_5 c3s40_5 0 0.2549f
Cc3s40_6 c3s40_6 0 0.1631f
CCc3s40_0 c3s40_0 c3s41_0 0.0268f
CCc3s40_2 c3s40_2 c3s41_2 0.0804f
CCc3s40_4 c3s40_4 c3s41_4 0.1498f
CCc3s40_6 c3s40_6 c3s41_6 0.05044f
Rc3s41_0 c3s41_0 c3s41_1 3.573
Rc3s41_1 c3s41_1 c3s41_2 2.511
Rc3s41_2 c3s41_2 c3s41_3 2.231
Rc3s41_3 c3s41_3 c3s41_4 2.264
Rc3s41_4 c3s41_4 c3s41_5 2.367
Rc3s41_5 c3s41_5 c3s41_6 2.577
Cc3s41_0 c3s41_0 0 0.1049f
Cc3s41_1 c3s41_1 0 0.2722f
Cc3s41_2 c3s41_2 0 0.3161f
Cc3s41_3 c3s41_3 0 0.2997f
Cc3s41_4 c3s41_4 0 0.3088f
Cc3s41_5 c3s41_5 0 0.3296f
Cc3s41_6 c3s41_6 0 0.1718f
CCc3s41_0 c3s41_0 c3s42_0 0.06517f
CCc3s41_2 c3s41_2 c3s42_2 0.06924f
CCc3s41_4 c3s41_4 c3s42_4 0.07558f
CCc3s41_6 c3s41_6 c3s42_6 0.09313f
Rc3s42_0 c3s42_0 c3s42_1 4.236
Rc3s42_1 c3s42_1 c3s42_2 3.203
Rc3s42_2 c3s42_2 c3s42_3 1.697
Rc3s42_3 c3s42_3 c3s42_4 1.865
Rc3s42_4 c3s42_4 c3s42_5 3.073
Rc3s42_5 c3s42_5 c3s42_6 3.509
Cc3s42_0 c3s42_0 0 0.1491f
Cc3s42_1 c3s42_1 0 0.3626f
Cc3s42_2 c3s42_2 0 0.3267f
Cc3s42_3 c3s42_3 0 0.2375f
Cc3s42_4 c3s42_4 0 0.3292f
Cc3s42_5 c3s42_5 0 0.4388f
Cc3s42_6 c3s42_6 0 0.2339f
CCc3s42_0 c3s42_0 c3s43_0 0.05401f
CCc3s42_2 c3s42_2 c3s43_2 0.1223f
CCc3s42_4 c3s42_4 c3s43_4 0.05467f
CCc3s42_6 c3s42_6 c3s43_6 0.1238f
Rc3s43_0 c3s43_0 c3s43_1 2.571
Rc3s43_1 c3s43_1 c3s43_2 2.047
Rc3s43_2 c3s43_2 c3s43_3 2.245
Rc3s43_3 c3s43_3 c3s43_4 2.654
Rc3s43_4 c3s43_4 c3s43_5 3.339
Rc3s43_5 c3s43_5 c3s43_6 2.955
Cc3s43_0 c3s43_0 0 0.03809f
Cc3s43_1 c3s43_1 0 0.1746f
Cc3s43_2 c3s43_2 0 0.2862f
Cc3s43_3 c3s43_3 0 0.3266f
Cc3s43_4 c3s43_4 0 0.3995f
Cc3s43_5 c3s43_5 0 0.4195f
Cc3s43_6 c3s43_6 0 0.197f
CCc3s43_0 c3s43_0 c3s44_0 0.09883f
CCc3s43_2 c3s43_2 c3s44_2 0.0896f
CCc3s43_4 c3s43_4 c3s44_4 0.02185f
CCc3s43_6 c3s43_6 c3s44_6 0.09737f
Rc3s44_0 c3s44_0 c3s44_1 4.221
Rc3s44_1 c3s44_1 c3s44_2 2.788
Rc3s44_2 c3s44_2 c3s44_3 0.971
Rc3s44_3 c3s44_3 c3s44_4 2.304
Rc3s44_4 c3s44_4 c3s44_5 0.6125
Rc3s44_5 c3s44_5 c3s44_6 2.737
Cc3s44_0 c3s44_0 0 0.1481f
Cc3s44_1 c3s44_1 0 0.3339f
Cc3s44_2 c3s44_2 0 0.2506f
Cc3s44_3 c3s44_3 0 0.2184f
Cc3s44_4 c3s44_4 0 0.1945f
Cc3s44_5 c3s44_5 0 0.2233f
Cc3s44_6 c3s44_6 0 0.1824f
CCc3s44_0 c3s44_0 c3s45_0 0.135f
CCc3s44_2 c3s44_2 c3s45_2 0.08129f
CCc3s44_4 c3s44_4 c3s45_4 0.1163f
CCc3s44_6 c3s44_6 c3s45_6 0.1127f
Rc3s45_0 c3s45_0 c3s45_1 3.406
Rc3s45_1 c3s45_1 c3s45_2 0.728
Rc3s45_2 c3s45_2 c3s45_3 2.838
Rc3s45_3 c3s45_3 c3s45_4 1.575
Rc3s45_4 c3s45_4 c3s45_5 0.9583
Rc3s45_5 c3s45_5 c3s45_6 1.843
Cc3s45_0 c3s45_0 0 0.09376f
Cc3s45_1 c3s45_1 0 0.1423f
Cc3s45_2 c3s45_2 0 0.2377f
Cc3s45_3 c3s45_3 0 0.2942f
Cc3s45_4 c3s45_4 0 0.1689f
Cc3s45_5 c3s45_5 0 0.1868f
Cc3s45_6 c3s45_6 0 0.1229f
CCc3s45_0 c3s45_0 c3s46_0 0.1366f
CCc3s45_2 c3s45_2 c3s46_2 0.1536f
CCc3s45_4 c3s45_4 c3s46_4 0.09943f
CCc3s45_6 c3s45_6 c3s46_6 0.1558f
Rc3s46_0 c3s46_0 c3s46_1 2.996
Rc3s46_1 c3s46_1 c3s46_2 1.995
Rc3s46_2 c3s46_2 c3s46_3 0.4764
Rc3s46_3 c3s46_3 c3s46_4 1.187
Rc3s46_4 c3s46_4 c3s46_5 3.211
Rc3s46_5 c3s46_5 c3s46_6 0.6371
Cc3s46_0 c3s46_0 0 0.06642f
Cc3s46_1 c3s46_1 0 0.1994f
Cc3s46_2 c3s46_2 0 0.1647f
Cc3s46_3 c3s46_3 0 0.1109f
Cc3s46_4 c3s46_4 0 0.2932f
Cc3s46_5 c3s46_5 0 0.2566f
Cc3s46_6 c3s46_6 0 0.04247f
CCc3s46_0 c3s46_0 c3s47_0 0.1116f
CCc3s46_2 c3s46_2 c3s47_2 0.09134f
CCc3s46_4 c3s46_4 c3s47_4 0.1583f
CCc3s46_6 c3s46_6 c3s47_6 0.1591f
Rc3s47_0 c3s47_0 c3s47_1 2.839
Rc3s47_1 c3s47_1 c3s47_2 1.276
Rc3s47_2 c3s47_2 c3s47_3 3.573
Rc3s47_3 c3s47_3 c3s47_4 1.489
Rc3s47_4 c3s47_4 c3s47_5 1.019
Rc3s47_5 c3s47_5 c3s47_6 3.322
Cc3s47_0 c3s47_0 0 0.0559f
Cc3s47_1 c3s47_1 0 0.1409f
Cc3s47_2 c3s47_2 0 0.3232f
Cc3s47_3 c3s47_3 0 0.3375f
Cc3s47_4 c3s47_4 0 0.1672f
Cc3s47_5 c3s47_5 0 0.2894f
Cc3s47_6 c3s47_6 0 0.2215f
CCc3s47_0 c3s47_0 c3s48_0 0.1064f
CCc3s47_2 c3s47_2 c3s48_2 0.06314f
CCc3s47_4 c3s47_4 c3s48_4 0.09761f
CCc3s47_6 c3s47_6 c3s48_6 0.07984f
Rc3s48_0 c3s48_0 c3s48_1 3.893
Rc3s48_1 c3s48_1 c3s48_2 2.189
Rc3s48_2 c3s48_2 c3s48_3 0.9848
Rc3s48_3 c3s48_3 c3s48_4 2.389
Rc3s48_4 c3s48_4 c3s48_5 3.459
Rc3s48_5 c3s48_5 c3s48_6 2.315
Cc3s48_0 c3s48_0 0 0.1262f
Cc3s48_1 c3s48_1 0 0.2721f
Cc3s48_2 c3s48_2 0 0.2116f
Cc3s48_3 c3s48_3 0 0.2249f
Cc3s48_4 c3s48_4 0 0.3899f
Cc3s48_5 c3s48_5 0 0.3849f
Cc3s48_6 c3s48_6 0 0.1543f
CCc3s48_0 c3s48_0 c3s49_0 0.1302f
Cc3s49_0 c3s49_0 0 0f
CCc3s49_0 c3s49_0 c4s0_0 0.05956f
Rc4s0_0 c4s0_0 c4s0_1 2.937
Rc4s0_1 c4s0_1 c4s0_2 0.4703
Rc4s0_2 c4s0_2 c4s0_3 3.541
Rc4s0_3 c4s0_3 c4s0_4 0.825
Rc4s0_4 c4s0_4 c4s0_5 1.647
Rc4s0_5 c4s0_5 c4s0_6 2.512
Cc4s0_0 c4s0_0 0 0.06247f
Cc4s0_1 c4s0_1 0 0.09382f
Cc4s0_2 c4s0_2 0 0.2674f
Cc4s0_3 c4s0_3 0 0.2911f
Cc4s0_4 c4s0_4 0 0.1648f
Cc4s0_5 c4s0_5 0 0.2773f
Cc4s0_6 c4s0_6 0 0.1675f
CCc4s0_0 c4s0_0 c4s1_0 0.1228f
CCc4s0_2 c4s0_2 c4s1_2 0.1065f
CCc4s0_4 c4s0_4 c4s1_4 0.08154f
CCc4s0_6 c4s0_6 c4s1_6 0.1341f
Rc4s1_0 c4s1_0 c4s1_1 3.843
Rc4s1_1 c4s1_1 c4s1_2 3.081
Rc4s1_2 c4s1_2 c4s1_3 0.6202
Rc4s1_3 c4s1_3 c4s1_4 2.724
Rc4s1_4 c4s1_4 c4s1_5 0.7565
Rc4s1_5 c4s1_5 c4s1_6 1.671
Cc4s1_0 c4s1_0 0 0.1229f
Cc4s1_1 c4s1_1 0 0.3283f
Cc4s1_2 c4s1_2 0 0.2468f
Cc4s1_3 c4s1_3 0 0.223f
Cc4s1_4 c4s1_4 0 0.2321f
Cc4s1_5 c4s1_5 0 0.1618f
Cc4s1_6 c4s1_6 0 0.1114f
CCc4s1_0 c4s1_0 c4s2_0 0.08207f
CCc4s1_2 c4s1_2 c4s2_2 0.04548f
CCc4s1_4 c4s1_4 c4s2_4 0.08285f
CCc4s1_6 c4s1_6 c4s2_6 0.1394f
Rc4s2_0 c4s2_0 c4s2_1 2.565
Rc4s2_1 c4s2_1 c4s2_2 1.061
Rc4s2_2 c4s2_2 c4s2_3 3.523
Rc4s2_3 c4s2_3 c4s2_4 1.867
Rc4s2_4 c4s2_4 c4s2_5 1.678
Rc4s2_5 c4s2_5 c4s2_6 3.325
Cc4s2_0 c4s2_0 0 0.03765f
Cc4s2_1 c4s2_1 0 0.1084f
Cc4s2_2 c4s2_2 0 0.3056f
Cc4s2_3 c4s2_3 0 0.3594f
Cc4s2_4 c4s2_4 0 0.2363f
Cc4s2_5 c4s2_5 0 0.3335f
Cc4s2_6 c4s2_6 0 0.2217f
CCc4s2_0 c4s2_0 c4s3_0 0.1286f
CCc4s2_2 c4s2_2 c4s3_2 0.04429f
CCc4s2_4 c4s2_4 c4s3_4 0.1037f
CCc4s2_6 c4s2_6 c4s3_6 0.04526f
Rc4s3_0 c4s3_0 c4s3_1 4.894
Rc4s3_1 c4s3_1 c4s3_2 2.203
Rc4s3_2 c4s3_2 c4s3_3 2.966
Rc4s3_3 c4s3_3 c4s3_4 0.6545
Rc4s3_4 c4s3_4 c4s3_5 3.373
Rc4s3_5 c4s3_5 c4s3_6 1.174
Cc4s3_0 c4s3_0 0 0.1929f
Cc4s3_1 c4s3_1 0 0.3398f
Cc4s3_2 c4s3_2 0 0.3446f
Cc4s3_3 c4s3_3 0 0.2413f
Cc4s3_4 c4s3_4 0 0.2685f
Cc4s3_5 c4s3_5 0 0.3031f
Cc4s3_6 c4s3_6 0 0.07826f
CCc4s3_0 c4s3_0 c4s4_0 0.139f
CCc4s3_2 c4s3_2 c4s4_2 0.08182f
CCc4s3_4 c4s3_4 c4s4_4 0.1444f
CCc4s3_6 c4s3_6 c4s4_6 0.03423f
Rc4s4_0 c4s4_0 c4s4_1 2.619
Rc4s4_1 c4s4_1 c4s4_2 1.925
Rc4s4_2 c4s4_2 c4s4_3 3.381
Rc4s4_3 c4s4_3 c4s4_4 1.916
Rc4s4_4 c4s4_4 c4s4_5 2.049
Rc4s4_5 c4s4_5 c4s4_6 0.9672
Cc4s4_0 c4s4_0 0 0.0413f
Cc4s4_1 c4s4_1 0 0.1696f
Cc4s4_2 c4s4_2 0 0.3537f
Cc4s4_3 c4s4_3 0 0.3531f
Cc4s4_4 c4s4_4 0 0.2643f
Cc4s4_5 c4s4_5 0 0.201f
Cc4s4_6 c4s4_6 0 0.06448f
CCc4s4_0 c4s4_0 c4s5_0 0.09574f
CCc4s4_2 c4s4_2 c4s5_2 0.07981f
CCc4s4_4 c4s4_4 c4s5_4 0.1443f
CCc4s4_6 c4s4_6 c4s5_6 0.1237f
Rc4s5_0 c4s5_0 c4s5_1 3.955
Rc4s5_1 c4s5_1 c4s5_2 0.9192
Rc4s5_2 c4s5_2 c4s5_3 0.9098
Rc4s5_3 c4s5_3 c4s5_4 3.509
Rc4s5_4 c4s5_4 c4s5_5 2.375
Rc4s5_5 c4s5_5 c4s5_6 1.159
Cc4s5_0 c4s5_0 0 0.1303f
Cc4s5_1 c4s5_1 0 0.1916f
Cc4s5_2 c4s5_2 0 0.1219f
Cc4s5_3 c4s5_3 0 0.2946f
Cc4s5_4 c4s5_4 0 0.3923f
Cc4s5_5 c4s5_5 0 0.2356f
Cc4s5_6 c4s5_6 0 0.07724f
CCc4s5_0 c4s5_0 c4s6_0 0.1335f
CCc4s5_2 c4s5_2 c4s6_2 0.05026f
CCc4s5_4 c4s5_4 c4s6_4 0.08356f
CCc4s5_6 c4s5_6 c4s6_6 0.1428f
Rc4s6_0 c4s6_0 c4s6_1 2.776
Rc4s6_1 c4s6_1 c4s6_2 0.7743
Rc4s6_2 c4s6_2 c4s6_3 0.6156
Rc4s6_3 c4s6_3 c4s6_4 0.9279
Rc4s6_4 c4s6_4 c4s6_5 1.63
Rc4s6_5 c4s6_5 c4s6_6 1.463
Cc4s6_0 c4s6_0 0 0.05171f
Cc4s6_1 c4s6_1 0 0.1033f
Cc4s6_2 c4s6_2 0 0.09266f
Cc4s6_3 c4s6_3 0 0.1029f
Cc4s6_4 c4s6_4 0 0.1705f
Cc4s6_5 c4s6_5 0 0.2062f
Cc4s6_6 c4s6_6 0 0.09755f
CCc4s6_0 c4s6_0 c4s7_0 0.05922f
CCc4s6_2 c4s6_2 c4s7_2 0.02198f
CCc4s6_4 c4s6_4 c4s7_4 0.0882f
CCc4s6_6 c4s6_6 c4s7_6 0.08235f
Rc4s7_0 c4s7_0 c4s7_1 4.784
Rc4s7_1 c4s7_1 c4s7_2 1.405
Rc4s7_2 c4s7_2 c4s7_3 2.281
Rc4s7_3 c4s7_3 c4s7_4 1.436
Rc4s7_4 c4s7_4 c4s7_5 2.822
Rc4s7_5 c4s7_5 c4s7_6 0.9986
Cc4s7_0 c4s7_0 0 0.1856f
Cc4s7_1 c4s7_1 0 0.2792f
Cc4s7_2 c4s7_2 0 0.2457f
Cc4s7_3 c4s7_3 0 0.2478f
Cc4s7_4 c4s7_4 0 0.2839f
Cc4s7_5 c4s7_5 0 0.2547f
Cc4s7_6 c4s7_6 0 0.06657f
CCc4s7_0 c4s7_0 c4s8_0 0.08851f
CCc4s7_2 c4s7_2 c4s8_2 0.08241f
CCc4s7_4 c4s7_4 c4s8_4 0.08422f
CCc4s7_6 c4s7_6 c4s8_6 0.09534f
Rc4s8_0 c4s8_0 c4s8_1 4.139
Rc4s8_1 c4s8_1 c4s8_2 1.446
Rc4s8_2 c4s8_2 c4s8_3 3.046
Rc4s8_3 c4s8_3 c4s8_4 3.447
Rc4s8_4 c4s8_4 c4s8_5 2.211
Rc4s8_5 c4s8_5 c4s8_6 2.452
Cc4s8_0 c4s8_0 0 0.1426f
Cc4s8_1 c4s8_1 0 0.239f
Cc4s8_2 c4s8_2 0 0.2995f
Cc4s8_3 c4s8_3 0 0.4329f
Cc4s8_4 c4s8_4 0 0.3772f
Cc4s8_5 c4s8_5 0 0.3108f
Cc4s8_6 c4s8_6 0 0.1635f
CCc4s8_0 c4s8_0 c4s9_0 0.1213f
CCc4s8_2 c4s8_2 c4s9_2 0.06477f
CCc4s8_4 c4s8_4 c4s9_4 0.1029f
CCc4s8_6 c4s8_6 c4s9_6 0.08476f
Rc4s9_0 c4s9_0 c4s9_1 3.976
Rc4s9_1 c4s9_1 c4s9_2 1.692
Rc4s9_2 c4s9_2 c4s9_3 2.139
Rc4s9_3 c4s9_3 c4s9_4 1.137
Rc4s9_4 c4s9_4 c4s9_5 1.209
Rc4s9_5 c4s9_5 c4s9_6 1.081
Cc4s9_0 c4s9_0 0 0.1317f
Cc4s9_1 c4s9_1 0 0.2445f
Cc4s9_2 c4s9_2 0 0.2554f
Cc4s9_3 c4s9_3 0 0.2184f
Cc4s9_4 c4s9_4 0 0.1564f
Cc4s9_5 c4s9_5 0 0.1526f
Cc4s9_6 c4s9_6 0 0.07203f
CCc4s9_0 c4s9_0 c4s10_0 0.1032f
CCc4s9_2 c4s9_2 c4s10_2 0.05435f
CCc4s9_4 c4s9_4 c4s10_4 0.1293f
CCc4s9_6 c4s9_6 c4s10_6 0.1467f
Rc4s10_0 c4s10_0 c4s10_1 4.843
Rc4s10_1 c4s10_1 c4s10_2 1.484
Rc4s10_2 c4s10_2 c4s10_3 3.419
Rc4s10_3 c4s10_3 c4s10_4 1.534
Rc4s10_4 c4s10_4 c4s10_5 1.589
Rc4s10_5 c4s10_5 c4s10_6 2.325
Cc4s10_0 c4s10_0 0 0.1895f
Cc4s10_1 c4s10_1 0 0.2885f
Cc4s10_2 c4s10_2 0 0.3269f
Cc4s10_3 c4s10_3 0 0.3303f
Cc4s10_4 c4s10_4 0 0.2082f
Cc4s10_5 c4s10_5 0 0.2609f
Cc4s10_6 c4s10_6 0 0.155f
CCc4s10_0 c4s10_0 c4s11_0 0.1125f
CCc4s10_2 c4s10_2 c4s11_2 0.07724f
CCc4s10_4 c4s10_4 c4s11_4 0.1301f
CCc4s10_6 c4s10_6 c4s11_6 0.1395f
Rc4s11_0 c4s11_0 c4s11_1 3.359
Rc4s11_1 c4s11_1 c4s11_2 1.157
Rc4s11_2 c4s11_2 c4s11_3 1.702
Rc4s11_3 c4s11_3 c4s11_4 2.651
Rc4s11_4 c4s11_4 c4s11_5 2.56
Rc4s11_5 c4s11_5 c4s11_6 1.003
Cc4s11_0 c4s11_0 0 0.09061f
Cc4s11_1 c4s11_1 0 0.1678f
Cc4s11_2 c4s11_2 0 0.1906f
Cc4s11_3 c4s11_3 0 0.2902f
Cc4s11_4 c4s11_4 0 0.3474f
Cc4s11_5 c4s11_5 0 0.2375f
Cc4s11_6 c4s11_6 0 0.06688f
CCc4s11_0 c4s11_0 c4s12_0 0.07442f
CCc4s11_2 c4s11_2 c4s12_2 0.1463f
CCc4s11_4 c4s11_4 c4s12_4 0.1544f
CCc4s11_6 c4s11_6 c4s12_6 0.1046f
Rc4s12_0 c4s12_0 c4s12_1 4.907
Rc4s12_1 c4s12_1 c4s12_2 3.095
Rc4s12_2 c4s12_2 c4s12_3 1.15
Rc4s12_3 c4s12_3 c4s12_4 0.6575
Rc4s12_4 c4s12_4 c4s12_5 2.376
Rc4s12_5 c4s12_5 c4s12_6 1.662
Cc4s12_0 c4s12_0 0 0.1938f
Cc4s12_1 c4s12_1 0 0.4002f
Cc4s12_2 c4s12_2 0 0.283f
Cc4s12_3 c4s12_3 0 0.1205f
Cc4s12_4 c4s12_4 0 0.2022f
Cc4s12_5 c4s12_5 0 0.2692f
Cc4s12_6 c4s12_6 0 0.1108f
CCc4s12_0 c4s12_0 c4s13_0 0.1195f
CCc4s12_2 c4s12_2 c4s13_2 0.06112f
CCc4s12_4 c4s12_4 c4s13_4 0.08075f
CCc4s12_6 c4s12_6 c4s13_6 0.1332f
Rc4s13_0 c4s13_0 c4s13_1 2.744
Rc4s13_1 c4s13_1 c4s13_2 1.735
Rc4s13_2 c4s13_2 c4s13_3 0.9327
Rc4s13_3 c4s13_3 c4s13_4 2.131
Rc4s13_4 c4s13_4 c4s13_5 2.758
Rc4s13_5 c4s13_5 c4s13_6 3.56
Cc4s13_0 c4s13_0 0 0.04958f
Cc4s13_1 c4s13_1 0 0.1652f
Cc4s13_2 c4s13_2 0 0.1778f
Cc4s13_3 c4s13_3 0 0.2042f
Cc4s13_4 c4s13_4 0 0.3259f
Cc4s13_5 c4s13_5 0 0.4212f
Cc4s13_6 c4s13_6 0 0.2373f
CCc4s13_0 c4s13_0 c4s14_0 0.1255f
CCc4s13_2 c4s13_2 c4s14_2 0.0402f
CCc4s13_4 c4s13_4 c4s14_4 0.08118f
CCc4s13_6 c4s13_6 c4s14_6 0.09591f
Rc4s14_0 c4s14_0 c4s14_1 4.459
Rc4s14_1 c4s14_1 c4s14_2 2.658
Rc4s14_2 c4s14_2 c4s14_3 3.516
Rc4s14_3 c4s14_3 c4s14_4 3.418
Rc4s14_4 c4s14_4 c4s14_5 1.107
Rc4s14_5 c4s14_5 c4s14_6 0.9489
Cc4s14_0 c4s14_0 0 0.1639f
Cc4s14_1 c4s14_1 0 0.3411f
Cc4s14_2 c4s14_2 0 0.4116f
Cc4s14_3 c4s14_3 0 0.4623f
Cc4s14_4 c4s14_4 0 0.3017f
Cc4s14_5 c4s14_5 0 0.1371f
Cc4s14_6 c4s14_6 0 0.06326f
CCc4s14_0 c4s14_0 c4s15_0 0.1558f
CCc4s14_2 c4s14_2 c4s15_2 0.04247f
CCc4s14_4 c4s14_4 c4s15_4 0.1556f
CCc4s14_6 c4s14_6 c4s15_6 0.03678f
Rc4s15_0 c4s15_0 c4s15_1 4.293
Rc4s15_1 c4s15_1 c4s15_2 0.8591
Rc4s15_2 c4s15_2 c4s15_3 0.8715
Rc4s15_3 c4s15_3 c4s15_4 1.502
Rc4s15_4 c4s15_4 c4s15_5 2.95
Rc4s15_5 c4s15_5 c4s15_6 2.662
Cc4s15_0 c4s15_0 0 0.1528f
Cc4s15_1 c4s15_1 0 0.2101f
Cc4s15_2 c4s15_2 0 0.1154f
Cc4s15_3 c4s15_3 0 0.1582f
Cc4s15_4 c4s15_4 0 0.2968f
Cc4s15_5 c4s15_5 0 0.3742f
Cc4s15_6 c4s15_6 0 0.1775f
CCc4s15_0 c4s15_0 c4s16_0 0.06442f
CCc4s15_2 c4s15_2 c4s16_2 0.03919f
CCc4s15_4 c4s15_4 c4s16_4 0.07021f
CCc4s15_6 c4s15_6 c4s16_6 0.04438f
Rc4s16_0 c4s16_0 c4s16_1 3.19
Rc4s16_1 c4s16_1 c4s16_2 2.015
Rc4s16_2 c4s16_2 c4s16_3 1.989
Rc4s16_3 c4s16_3 c4s16_4 3.356
Rc4s16_4 c4s16_4 c4s16_5 0.7327
Rc4s16_5 c4s16_5 c4s16_6 2.129
Cc4s16_0 c4s16_0 0 0.07935f
Cc4s16_1 c4s16_1 0 0.2137f
Cc4s16_2 c4s16_2 0 0.267f
Cc4s16_3 c4s16_3 0 0.3564f
Cc4s16_4 c4s16_4 0 0.2726f
Cc4s16_5 c4s16_5 0 0.1908f
Cc4s16_6 c4s16_6 0 0.1419f
CCc4s16_0 c4s16_0 c4s17_0 0.09907f
CCc4s16_2 c4s16_2 c4s17_2 0.03999f
CCc4s16_4 c4s16_4 c4s17_4 0.07047f
CCc4s16_6 c4s16_6 c4s17_6 0.0393f
Rc4s17_0 c4s17_0 c4s17_1 5.265
Rc4s17_1 c4s17_1 c4s17_2 1.548
Rc4s17_2 c4s17_2 c4s17_3 0.6543
Rc4s17_3 c4s17_3 c4s17_4 1.947
Rc4s17_4 c4s17_4 c4s17_5 2.116
Rc4s17_5 c4s17_5 c4s17_6 3.245
Cc4s17_0 c4s17_0 0 0.2177f
Cc4s17_1 c4s17_1 0 0.3209f
Cc4s17_2 c4s17_2 0 0.1468f
Cc4s17_3 c4s17_3 0 0.1734f
Cc4s17_4 c4s17_4 0 0.2709f
Cc4s17_5 c4s17_5 0 0.3574f
Cc4s17_6 c4s17_6 0 0.2163f
CCc4s17_0 c4s17_0 c4s18_0 0.1207f
CCc4s17_2 c4s17_2 c4s18_2 0.04886f
CCc4s17_4 c4s17_4 c4s18_4 0.1472f
CCc4s17_6 c4s17_6 c4s18_6 0.02071f
Rc4s18_0 c4s18_0 c4s18_1 4.646
Rc4s18_1 c4s18_1 c4s18_2 0.5828
Rc4s18_2 c4s18_2 c4s18_3 3.032
Rc4s18_3 c4s18_3 c4s18_4 1.047
Rc4s18_4 c4s18_4 c4s18_5 2.961
Rc4s18_5 c4s18_5 c4s18_6 3.012
Cc4s18_0 c4s18_0 0 0.1764f
Cc4s18_1 c4s18_1 0 0.2153f
Cc4s18_2 c4s18_2 0 0.241f
Cc4s18_3 c4s18_3 0 0.2719f
Cc4s18_4 c4s18_4 0 0.2672f
Cc4s18_5 c4s18_5 0 0.3982f
Cc4s18_6 c4s18_6 0 0.2008f
CCc4s18_0 c4s18_0 c4s19_0 0.128f
CCc4s18_2 c4s18_2 c4s19_2 0.03542f
CCc4s18_4 c4s18_4 c4s19_4 0.07604f
CCc4s18_6 c4s18_6 c4s19_6 0.03467f
Rc4s19_0 c4s19_0 c4s19_1 4.714
Rc4s19_1 c4s19_1 c4s19_2 3.581
Rc4s19_2 c4s19_2 c4s19_3 2.097
Rc4s19_3 c4s19_3 c4s19_4 2.504
Rc4s19_4 c4s19_4 c4s19_5 2.551
Rc4s19_5 c4s19_5 c4s19_6 0.8996
Cc4s19_0 c4s19_0 0 0.1809f
Cc4s19_1 c4s19_1 0 0.4197f
Cc4s19_2 c4s19_2 0 0.3785f
Cc4s19_3 c4s19_3 0 0.3067f
Cc4s19_4 c4s19_4 0 0.337f
Cc4s19_5 c4s19_5 0 0.2301f
Cc4s19_6 c4s19_6 0 0.05997f
CCc4s19_0 c4s19_0 c4s20_0 0.072f
CCc4s19_2 c4s19_2 c4s20_2 0.06885f
CCc4s19_4 c4s19_4 c4s20_4 0.1251f
CCc4s19_6 c4s19_6 c4s20_6 0.07759f
Rc4s20_0 c4s20_0 c4s20_1 3.609
Rc4s20_1 c4s20_1 c4s20_2 2.179
Rc4s20_2 c4s20_2 c4s20_3 1.099
Rc4s20_3 c4s20_3 c4s20_4 0.6557
Rc4s20_4 c4s20_4 c4s20_5 1.2
Rc4s20_5 c4s20_5 c4s20_6 0.5157
Cc4s20_0 c4s20_0 0 0.1073f
Cc4s20_1 c4s20_1 0 0.2526f
Cc4s20_2 c4s20_2 0 0.2185f
Cc4s20_3 c4s20_3 0 0.117f
Cc4s20_4 c4s20_4 0 0.1237f
Cc4s20_5 c4s20_5 0 0.1144f
Cc4s20_6 c4s20_6 0 0.03438f
CCc4s20_0 c4s20_0 c4s21_0 0.1137f
CCc4s20_2 c4s20_2 c4s21_2 0.08395f
CCc4s20_4 c4s20_4 c4s21_4 0.1063f
CCc4s20_6 c4s20_6 c4s21_6 0.09949f
Rc4s21_0 c4s21_0 c4s21_1 2.621
Rc4s21_1 c4s21_1 c4s21_2 3.017
Rc4s21_2 c4s21_2 c4s21_3 3.029
Rc4s21_3 c4s21_3 c4s21_4 0.4739
Rc4s21_4 c4s21_4 c4s21_5 1.805
Rc4s21_5 c4s21_5 c4s21_6 2.925
Cc4s21_0 c4s21_0 0 0.04138f
Cc4s21_1 c4s21_1 0 0.2425f
Cc4s21_2 c4s21_2 0 0.4031f
Cc4s21_3 c4s21_3 0 0.2336f
Cc4s21_4 c4s21_4 0 0.1519f
Cc4s21_5 c4s21_5 0 0.3153f
Cc4s21_6 c4s21_6 0 0.195f
CCc4s21_0 c4s21_0 c4s22_0 0.07816f
CCc4s21_2 c4s21_2 c4s22_2 0.1404f
CCc4s21_4 c4s21_4 c4s22_4 0.1173f
CCc4s21_6 c4s21_6 c4s22_6 0.1125f
Rc4s22_0 c4s22_0 c4s22_1 5.303
Rc4s22_1 c4s22_1 c4s22_2 2.904
Rc4s22_2 c4s22_2 c4s22_3 2.293
Rc4s22_3 c4s22_3 c4s22_4 0.599
Rc4s22_4 c4s22_4 c4s22_5 1.882
Rc4s22_5 c4s22_5 c4s22_6 2.62
Cc4s22_0 c4s22_0 0 0.2202f
Cc4s22_1 c4s22_1 0 0.4138f
Cc4s22_2 c4s22_2 0 0.3464f
Cc4s22_3 c4s22_3 0 0.1928f
Cc4s22_4 c4s22_4 0 0.1654f
Cc4s22_5 c4s22_5 0 0.3001f
Cc4s22_6 c4s22_6 0 0.1746f
CCc4s22_0 c4s22_0 c4s23_0 0.09324f
CCc4s22_2 c4s22_2 c4s23_2 0.1019f
CCc4s22_4 c4s22_4 c4s23_4 0.06891f
CCc4s22_6 c4s22_6 c4s23_6 0.1378f
Rc4s23_0 c4s23_0 c4s23_1 3.223
Rc4s23_1 c4s23_1 c4s23_2 2.465
Rc4s23_2 c4s23_2 c4s23_3 1.826
Rc4s23_3 c4s23_3 c4s23_4 0.9185
Rc4s23_4 c4s23_4 c4s23_5 0.5101
Rc4s23_5 c4s23_5 c4s23_6 0.8592
Cc4s23_0 c4s23_0 0 0.08154f
Cc4s23_1 c4s23_1 0 0.2458f
Cc4s23_2 c4s23_2 0 0.286f
Cc4s23_3 c4s23_3 0 0.183f
Cc4s23_4 c4s23_4 0 0.09524f
Cc4s23_5 c4s23_5 0 0.09129f
Cc4s23_6 c4s23_6 0 0.05728f
CCc4s23_0 c4s23_0 c4s24_0 0.06035f
CCc4s23_2 c4s23_2 c4s24_2 0.08613f
CCc4s23_4 c4s23_4 c4s24_4 0.02375f
CCc4s23_6 c4s23_6 c4s24_6 0.0294f
Rc4s24_0 c4s24_0 c4s24_1 4.959
Rc4s24_1 c4s24_1 c4s24_2 3.538
Rc4s24_2 c4s24_2 c4s24_3 1.808
Rc4s24_3 c4s24_3 c4s24_4 1.93
Rc4s24_4 c4s24_4 c4s24_5 2.348
Rc4s24_5 c4s24_5 c4s24_6 0.7551
Cc4s24_0 c4s24_0 0 0.1972f
Cc4s24_1 c4s24_1 0 0.4331f
Cc4s24_2 c4s24_2 0 0.3564f
Cc4s24_3 c4s24_3 0 0.2492f
Cc4s24_4 c4s24_4 0 0.2852f
Cc4s24_5 c4s24_5 0 0.2069f
Cc4s24_6 c4s24_6 0 0.05034f
CCc4s24_0 c4s24_0 c4s25_0 0.09542f
CCc4s24_2 c4s24_2 c4s25_2 0.1144f
CCc4s24_4 c4s24_4 c4s25_4 0.1522f
CCc4s24_6 c4s24_6 c4s25_6 0.11f
Rc4s25_0 c4s25_0 c4s25_1 4.166
Rc4s25_1 c4s25_1 c4s25_2 1.742
Rc4s25_2 c4s25_2 c4s25_3 3.322
Rc4s25_3 c4s25_3 c4s25_4 2.099
Rc4s25_4 c4s25_4 c4s25_5 1.954
Rc4s25_5 c4s25_5 c4s25_6 2.761
Cc4s25_0 c4s25_0 0 0.1444f
Cc4s25_1 c4s25_1 0 0.2606f
Cc4s25_2 c4s25_2 0 0.3376f
Cc4s25_3 c4s25_3 0 0.3614f
Cc4s25_4 c4s25_4 0 0.2702f
Cc4s25_5 c4s25_5 0 0.3144f
Cc4s25_6 c4s25_6 0 0.1841f
CCc4s25_0 c4s25_0 c4s26_0 0.0813f
CCc4s25_2 c4s25_2 c4s26_2 0.02942f
CCc4s25_4 c4s25_4 c4s26_4 0.1029f
CCc4s25_6 c4s25_6 c4s26_6 0.1412f
Rc4s26_0 c4s26_0 c4s26_1 3.613
Rc4s26_1 c4s26_1 c4s26_2 0.753
Rc4s26_2 c4s26_2 c4s26_3 0.783
Rc4s26_3 c4s26_3 c4s26_4 3.305
Rc4s26_4 c4s26_4 c4s26_5 0.7999
Rc4s26_5 c4s26_5 c4s26_6 2.511
Cc4s26_0 c4s26_0 0 0.1076f
Cc4s26_1 c4s26_1 0 0.1578f
Cc4s26_2 c4s26_2 0 0.1024f
Cc4s26_3 c4s26_3 0 0.2725f
Cc4s26_4 c4s26_4 0 0.2737f
Cc4s26_5 c4s26_5 0 0.2207f
Cc4s26_6 c4s26_6 0 0.1674f
CCc4s26_0 c4s26_0 c4s27_0 0.03225f
CCc4s26_2 c4s26_2 c4s27_2 0.09173f
CCc4s26_4 c4s26_4 c4s27_4 0.1476f
CCc4s26_6 c4s26_6 c4s27_6 0.05283f
Rc4s27_0 c4s27_0 c4s27_1 3.418
Rc4s27_1 c4s27_1 c4s27_2 2.376
Rc4s27_2 c4s27_2 c4s27_3 2.256
Rc4s27_3 c4s27_3 c4s27_4 2.216
Rc4s27_4 c4s27_4 c4s27_5 1.685
Rc4s27_5 c4s27_5 c4s27_6 0.5788
Cc4s27_0 c4s27_0 0 0.09455f
Cc4s27_1 c4s27_1 0 0.2529f
Cc4s27_2 c4s27_2 0 0.3088f
Cc4s27_3 c4s27_3 0 0.2981f
Cc4s27_4 c4s27_4 0 0.26f
Cc4s27_5 c4s27_5 0 0.1509f
Cc4s27_6 c4s27_6 0 0.03859f
CCc4s27_0 c4s27_0 c4s28_0 0.1033f
CCc4s27_2 c4s27_2 c4s28_2 0.05875f
CCc4s27_4 c4s27_4 c4s28_4 0.1069f
CCc4s27_6 c4s27_6 c4s28_6 0.0813f
Rc4s28_0 c4s28_0 c4s28_1 3.296
Rc4s28_1 c4s28_1 c4s28_2 3.587
Rc4s28_2 c4s28_2 c4s28_3 1.463
Rc4s28_3 c4s28_3 c4s28_4 3.509
Rc4s28_4 c4s28_4 c4s28_5 1.955
Rc4s28_5 c4s28_5 c4s28_6 2.132
Cc4s28_0 c4s28_0 0 0.08641f
Cc4s28_1 c4s28_1 0 0.3255f
Cc4s28_2 c4s28_2 0 0.3367f
Cc4s28_3 c4s28_3 0 0.3315f
Cc4s28_4 c4s28_4 0 0.3642f
Cc4s28_5 c4s28_5 0 0.2725f
Cc4s28_6 c4s28_6 0 0.1421f
CCc4s28_0 c4s28_0 c4s29_0 0.05764f
CCc4s28_2 c4s28_2 c4s29_2 0.04433f
CCc4s28_4 c4s28_4 c4s29_4 0.1189f
CCc4s28_6 c4s28_6 c4s29_6 0.08378f
Rc4s29_0 c4s29_0 c4s29_1 4.293
Rc4s29_1 c4s29_1 c4s29_2 1.025
Rc4s29_2 c4s29_2 c4s29_3 2.056
Rc4s29_3 c4s29_3 c4s29_4 2.525
Rc4s29_4 c4s29_4 c4s29_5 2.843
Rc4s29_5 c4s29_5 c4s29_6 2.55
Cc4s29_0 c4s29_0 0 0.1529f
Cc4s29_1 c4s29_1 0 0.2212f
Cc4s29_2 c4s29_2 0 0.2054f
Cc4s29_3 c4s29_3 0 0.3054f
Cc4s29_4 c4s29_4 0 0.3579f
Cc4s29_5 c4s29_5 0 0.3595f
Cc4s29_6 c4s29_6 0 0.17f
CCc4s29_0 c4s29_0 c4s30_0 0.07793f
CCc4s29_2 c4s29_2 c4s30_2 0.1159f
CCc4s29_4 c4s29_4 c4s30_4 0.1036f
CCc4s29_6 c4s29_6 c4s30_6 0.08684f
Rc4s30_0 c4s30_0 c4s30_1 4.435
Rc4s30_1 c4s30_1 c4s30_2 1.415
Rc4s30_2 c4s30_2 c4s30_3 0.649
Rc4s30_3 c4s30_3 c4s30_4 0.9157
Rc4s30_4 c4s30_4 c4s30_5 3.514
Rc4s30_5 c4s30_5 c4s30_6 3.262
Cc4s30_0 c4s30_0 0 0.1624f
Cc4s30_1 c4s30_1 0 0.2567f
Cc4s30_2 c4s30_2 0 0.1376f
Cc4s30_3 c4s30_3 0 0.1043f
Cc4s30_4 c4s30_4 0 0.2953f
Cc4s30_5 c4s30_5 0 0.4517f
Cc4s30_6 c4s30_6 0 0.2175f
CCc4s30_0 c4s30_0 c4s31_0 0.1358f
CCc4s30_2 c4s30_2 c4s31_2 0.05628f
CCc4s30_4 c4s30_4 c4s31_4 0.1374f
CCc4s30_6 c4s30_6 c4s31_6 0.1305f
Rc4s31_0 c4s31_0 c4s31_1 4.155
Rc4s31_1 c4s31_1 c4s31_2 1.404
Rc4s31_2 c4s31_2 c4s31_3 0.7865
Rc4s31_3 c4s31_3 c4s31_4 3.593
Rc4s31_4 c4s31_4 c4s31_5 3.596
Rc4s31_5 c4s31_5 c4s31_6 3.13
Cc4s31_0 c4s31_0 0 0.1437f
Cc4s31_1 c4s31_1 0 0.2373f
Cc4s31_2 c4s31_2 0 0.1461f
Cc4s31_3 c4s31_3 0 0.292f
Cc4s31_4 c4s31_4 0 0.4793f
Cc4s31_5 c4s31_5 0 0.4484f
Cc4s31_6 c4s31_6 0 0.2087f
CCc4s31_0 c4s31_0 c4s32_0 0.08241f
CCc4s31_2 c4s31_2 c4s32_2 0.1221f
CCc4s31_4 c4s31_4 c4s32_4 0.1475f
CCc4s31_6 c4s31_6 c4s32_6 0.09588f
Rc4s32_0 c4s32_0 c4s32_1 2.844
Rc4s32_1 c4s32_1 c4s32_2 3.525
Rc4s32_2 c4s32_2 c4s32_3 2.144
Rc4s32_3 c4s32_3 c4s32_4 2.874
Rc4s32_4 c4s32_4 c4s32_5 2.411
Rc4s32_5 c4s32_5 c4s32_6 0.654
Cc4s32_0 c4s32_0 0 0.05628f
Cc4s32_1 c4s32_1 0 0.2913f
Cc4s32_2 c4s32_2 0 0.3779f
Cc4s32_3 c4s32_3 0 0.3345f
Cc4s32_4 c4s32_4 0 0.3523f
Cc4s32_5 c4s32_5 0 0.2043f
Cc4s32_6 c4s32_6 0 0.0436f
CCc4s32_0 c4s32_0 c4s33_0 0.08468f
CCc4s32_2 c4s32_2 c4s33_2 0.02168f
CCc4s32_4 c4s32_4 c4s33_4 0.05723f
CCc4s32_6 c4s32_6 c4s33_6 0.1546f
Rc4s33_0 c4s33_0 c4s33_1 4.628
Rc4s33_1 c4s33_1 c4s33_2 2.232
Rc4s33_2 c4s33_2 c4s33_3 0.8029
Rc4s33_3 c4s33_3 c4s33_4 2.609
Rc4s33_4 c4s33_4 c4s33_5 2.357
Rc4s33_5 c4s33_5 c4s33_6 2.458
Cc4s33_0 c4s33_0 0 0.1752f
Cc4s33_1 c4s33_1 0 0.324f
Cc4s33_2 c4s33_2 0 0.2023f
Cc4s33_3 c4s33_3 0 0.2274f
Cc4s33_4 c4s33_4 0 0.331f
Cc4s33_5 c4s33_5 0 0.321f
Cc4s33_6 c4s33_6 0 0.1639f
CCc4s33_0 c4s33_0 c4s34_0 0.1164f
CCc4s33_2 c4s33_2 c4s34_2 0.1499f
CCc4s33_4 c4s33_4 c4s34_4 0.08263f
CCc4s33_6 c4s33_6 c4s34_6 0.1055f
Rc4s34_0 c4s34_0 c4s34_1 4.119
Rc4s34_1 c4s34_1 c4s34_2 2.305
Rc4s34_2 c4s34_2 c4s34_3 2.59
Rc4s34_3 c4s34_3 c4s34_4 1.042
Rc4s34_4 c4s34_4 c4s34_5 0.625
Rc4s34_5 c4s34_5 c4s34_6 0.8164
Cc4s34_0 c4s34_0 0 0.1412f
Cc4s34_1 c4s34_1 0 0.2949f
Cc4s34_2 c4s34_2 0 0.3264f
Cc4s34_3 c4s34_3 0 0.2421f
Cc4s34_4 c4s34_4 0 0.1111f
Cc4s34_5 c4s34_5 0 0.09609f
Cc4s34_6 c4s34_6 0 0.05443f
CCc4s34_0 c4s34_0 c4s35_0 0.02598f
CCc4s34_2 c4s34_2 c4s35_2 0.09771f
CCc4s34_4 c4s34_4 c4s35_4 0.06272f
CCc4s34_6 c4s34_6 c4s35_6 0.1299f
Rc4s35_0 c4s35_0 c4s35_1 2.96
Rc4s35_1 c4s35_1 c4s35_2 0.9231
Rc4s35_2 c4s35_2 c4s35_3 3.177
Rc4s35_3 c4s35_3 c4s35_4 0.7325
Rc4s35_4 c4s35_4 c4s35_5 1.562
Rc4s35_5 c4s35_5 c4s35_6 2.624
Cc4s35_0 c4s35_0 0 0.064f
Cc4s35_1 c4s35_1 0 0.1255f
Cc4s35_2 c4s35_2 0 0.2733f
Cc4s35_3 c4s35_3 0 0.2606f
Cc4s35_4 c4s35_4 0 0.1529f
Cc4s35_5 c4s35_5 0 0.279f
Cc4s35_6 c4s35_6 0 0.1749f
CCc4s35_0 c4s35_0 c4s36_0 0.09878f
CCc4s35_2 c4s35_2 c4s36_2 0.05735f
CCc4s35_4 c4s35_4 c4s36_4 0.03886f
CCc4s35_6 c4s35_6 c4s36_6 0.1009f
Rc4s36_0 c4s36_0 c4s36_1 3.232
Rc4s36_1 c4s36_1 c4s36_2 3.147
Rc4s36_2 c4s36_2 c4s36_3 1.284
Rc4s36_3 c4s36_3 c4s36_4 3.389
Rc4s36_4 c4s36_4 c4s36_5 0.5185
Rc4s36_5 c4s36_5 c4s36_6 2.374
Cc4s36_0 c4s36_0 0 0.08211f
Cc4s36_1 c4s36_1 0 0.2919f
Cc4s36_2 c4s36_2 0 0.2954f
Cc4s36_3 c4s36_3 0 0.3116f
Cc4s36_4 c4s36_4 0 0.2605f
Cc4s36_5 c4s36_5 0 0.1929f
Cc4s36_6 c4s36_6 0 0.1583f
CCc4s36_0 c4s36_0 c4s37_0 0.05953f
CCc4s36_2 c4s36_2 c4s37_2 0.08645f
CCc4s36_4 c4s36_4 c4s37_4 0.08111f
CCc4s36_6 c4s36_6 c4s37_6 0.1333f
Rc4s37_0 c4s37_0 c4s37_1 3.034
Rc4s37_1 c4s37_1 c4s37_2 2.869
Rc4s37_2 c4s37_2 c4s37_3 0.5572
Rc4s37_3 c4s37_3 c4s37_4 2.456
Rc4s37_4 c4s37_4 c4s37_5 3.045
Rc4s37_5 c4s37_5 c4s37_6 1.803
Cc4s37_0 c4s37_0 0 0.06891f
Cc4s37_1 c4s37_1 0 0.2601f
Cc4s37_2 c4s37_2 0 0.2284f
Cc4s37_3 c4s37_3 0 0.2009f
Cc4s37_4 c4s37_4 0 0.3667f
Cc4s37_5 c4s37_5 0 0.3231f
Cc4s37_6 c4s37_6 0 0.1202f
CCc4s37_0 c4s37_0 c4s38_0 0.1389f
CCc4s37_2 c4s37_2 c4s38_2 0.06967f
CCc4s37_4 c4s37_4 c4s38_4 0.0697f
CCc4s37_6 c4s37_6 c4s38_6 0.1475f
Rc4s38_0 c4s38_0 c4s38_1 5.57
Rc4s38_1 c4s38_1 c4s38_2 2.936
Rc4s38_2 c4s38_2 c4s38_3 1.173
Rc4s38_3 c4s38_3 c4s38_4 3.418
Rc4s38_4 c4s38_4 c4s38_5 1.601
Rc4s38_5 c4s38_5 c4s38_6 3.183
Cc4s38_0 c4s38_0 0 0.238f
Cc4s38_1 c4s38_1 0 0.4337f
Cc4s38_2 c4s38_2 0 0.2739f
Cc4s38_3 c4s38_3 0 0.3061f
Cc4s38_4 c4s38_4 0 0.3347f
Cc4s38_5 c4s38_5 0 0.319f
Cc4s38_6 c4s38_6 0 0.2122f
CCc4s38_0 c4s38_0 c4s39_0 0.06506f
CCc4s38_2 c4s38_2 c4s39_2 0.05047f
CCc4s38_4 c4s38_4 c4s39_4 0.05608f
CCc4s38_6 c4s38_6 c4s39_6 0.1167f
Rc4s39_0 c4s39_0 c4s39_1 5.536
Rc4s39_1 c4s39_1 c4s39_2 2.091
Rc4s39_2 c4s39_2 c4s39_3 0.7877
Rc4s39_3 c4s39_3 c4s39_4 2.607
Rc4s39_4 c4s39_4 c4s39_5 3.28
Rc4s39_5 c4s39_5 c4s39_6 2.912
Cc4s39_0 c4s39_0 0 0.2357f
Cc4s39_1 c4s39_1 0 0.3751f
Cc4s39_2 c4s39_2 0 0.1919f
Cc4s39_3 c4s39_3 0 0.2263f
Cc4s39_4 c4s39_4 0 0.3925f
Cc4s39_5 c4s39_5 0 0.4128f
Cc4s39_6 c4s39_6 0 0.1941f
CCc4s39_0 c4s39_0 c4s40_0 0.02026f
CCc4s39_2 c4s39_2 c4s40_2 0.06371f
CCc4s39_4 c4s39_4 c4s40_4 0.1287f
CCc4s39_6 c4s39_6 c4s40_6 0.1182f
Rc4s40_0 c4s40_0 c4s40_1 5.588
Rc4s40_1 c4s40_1 c4s40_2 3.279
Rc4s40_2 c4s40_2 c4s40_3 2.964
Rc4s40_3 c4s40_3 c4s40_4 2.622
Rc4s40_4 c4s40_4 c4s40_5 1.649
Rc4s40_5 c4s40_5 c4s40_6 0.5603
Cc4s40_0 c4s40_0 0 0.2392f
Cc4s40_1 c4s40_1 0 0.4578f
Cc4s40_2 c4s40_2 0 0.4162f
Cc4s40_3 c4s40_3 0 0.3724f
Cc4s40_4 c4s40_4 0 0.2847f
Cc4s40_5 c4s40_5 0 0.1473f
Cc4s40_6 c4s40_6 0 0.03735f
CCc4s40_0 c4s40_0 c4s41_0 0.1275f
CCc4s40_2 c4s40_2 c4s41_2 0.08399f
CCc4s40_4 c4s40_4 c4s41_4 0.1411f
CCc4s40_6 c4s40_6 c4s41_6 0.03845f
Rc4s41_0 c4s41_0 c4s41_1 5.15
Rc4s41_1 c4s41_1 c4s41_2 2.483
Rc4s41_2 c4s41_2 c4s41_3 3.241
Rc4s41_3 c4s41_3 c4s41_4 2.659
Rc4s41_4 c4s41_4 c4s41_5 1.824
Rc4s41_5 c4s41_5 c4s41_6 2.075
Cc4s41_0 c4s41_0 0 0.21f
Cc4s41_1 c4s41_1 0 0.3755f
Cc4s41_2 c4s41_2 0 0.3816f
Cc4s41_3 c4s41_3 0 0.3934f
Cc4s41_4 c4s41_4 0 0.2989f
Cc4s41_5 c4s41_5 0 0.26f
Cc4s41_6 c4s41_6 0 0.1384f
CCc4s41_0 c4s41_0 c4s42_0 0.03377f
CCc4s41_2 c4s41_2 c4s42_2 0.05395f
CCc4s41_4 c4s41_4 c4s42_4 0.1005f
CCc4s41_6 c4s41_6 c4s42_6 0.04489f
Rc4s42_0 c4s42_0 c4s42_1 3.579
Rc4s42_1 c4s42_1 c4s42_2 2.476
Rc4s42_2 c4s42_2 c4s42_3 2.323
Rc4s42_3 c4s42_3 c4s42_4 3.266
Rc4s42_4 c4s42_4 c4s42_5 1.815
Rc4s42_5 c4s42_5 c4s42_6 2.194
Cc4s42_0 c4s42_0 0 0.1053f
Cc4s42_1 c4s42_1 0 0.2703f
Cc4s42_2 c4s42_2 0 0.32f
Cc4s42_3 c4s42_3 0 0.3726f
Cc4s42_4 c4s42_4 0 0.3387f
Cc4s42_5 c4s42_5 0 0.2672f
Cc4s42_6 c4s42_6 0 0.1463f
CCc4s42_0 c4s42_0 c4s43_0 0.07906f
CCc4s42_2 c4s42_2 c4s43_2 0.1257f
CCc4s42_4 c4s42_4 c4s43_4 0.1076f
CCc4s42_6 c4s42_6 c4s43_6 0.1523f
Rc4s43_0 c4s43_0 c4s43_1 2.896
Rc4s43_1 c4s43_1 c4s43_2 0.8507
Rc4s43_2 c4s43_2 c4s43_3 1.371
Rc4s43_3 c4s43_3 c4s43_4 2.391
Rc4s43_4 c4s43_4 c4s43_5 2.461
Rc4s43_5 c4s43_5 c4s43_6 1.085
Cc4s43_0 c4s43_0 0 0.05971f
Cc4s43_1 c4s43_1 0 0.1164f
Cc4s43_2 c4s43_2 0 0.1481f
Cc4s43_3 c4s43_3 0 0.2508f
Cc4s43_4 c4s43_4 0 0.3235f
Cc4s43_5 c4s43_5 0 0.2364f
Cc4s43_6 c4s43_6 0 0.07233f
CCc4s43_0 c4s43_0 c4s44_0 0.058f
CCc4s43_2 c4s43_2 c4s44_2 0.1034f
CCc4s43_4 c4s43_4 c4s44_4 0.05701f
CCc4s43_6 c4s43_6 c4s44_6 0.1362f
Rc4s44_0 c4s44_0 c4s44_1 2.786
Rc4s44_1 c4s44_1 c4s44_2 2.915
Rc4s44_2 c4s44_2 c4s44_3 0.932
Rc4s44_3 c4s44_3 c4s44_4 2.7
Rc4s44_4 c4s44_4 c4s44_5 2.914
Rc4s44_5 c4s44_5 c4s44_6 3.422
Cc4s44_0 c4s44_0 0 0.05238f
Cc4s44_1 c4s44_1 0 0.2467f
Cc4s44_2 c4s44_2 0 0.2565f
Cc4s44_3 c4s44_3 0 0.2421f
Cc4s44_4 c4s44_4 0 0.3742f
Cc4s44_5 c4s44_5 0 0.4224f
Cc4s44_6 c4s44_6 0 0.2281f
CCc4s44_0 c4s44_0 c4s45_0 0.1463f
CCc4s44_2 c4s44_2 c4s45_2 0.02343f
CCc4s44_4 c4s44_4 c4s45_4 0.1125f
CCc4s44_6 c4s44_6 c4s45_6 0.1475f
Rc4s45_0 c4s45_0 c4s45_1 4.876
Rc4s45_1 c4s45_1 c4s45_2 1.881
Rc4s45_2 c4s45_2 c4s45_3 2.813
Rc4s45_3 c4s45_3 c4s45_4 1.345
Rc4s45_4 c4s45_4 c4s45_5 2.98
Rc4s45_5 c4s45_5 c4s45_6 1.73
Cc4s45_0 c4s45_0 0 0.1918f
Cc4s45_1 c4s45_1 0 0.3171f
Cc4s45_2 c4s45_2 0 0.3129f
Cc4s45_3 c4s45_3 0 0.2772f
Cc4s45_4 c4s45_4 0 0.2883f
Cc4s45_5 c4s45_5 0 0.314f
Cc4s45_6 c4s45_6 0 0.1153f
CCc4s45_0 c4s45_0 c4s46_0 0.1559f
CCc4s45_2 c4s45_2 c4s46_2 0.0239f
CCc4s45_4 c4s45_4 c4s46_4 0.1016f
CCc4s45_6 c4s45_6 c4s46_6 0.03819f
Rc4s46_0 c4s46_0 c4s46_1 4.863
Rc4s46_1 c4s46_1 c4s46_2 3.507
Rc4s46_2 c4s46_2 c4s46_3 2
Rc4s46_3 c4s46_3 c4s46_4 3.1
Rc4s46_4 c4s46_4 c4s46_5 1.184
Rc4s46_5 c4s46_5 c4s46_6 0.5387
Cc4s46_0 c4s46_0 0 0.1909f
Cc4s46_1 c4s46_1 0 0.4247f
Cc4s46_2 c4s46_2 0 0.3671f
Cc4s46_3 c4s46_3 0 0.34f
Cc4s46_4 c4s46_4 0 0.2856f
Cc4s46_5 c4s46_5 0 0.1148f
Cc4s46_6 c4s46_6 0 0.03591f
CCc4s46_0 c4s46_0 c4s47_0 0.1325f
CCc4s46_2 c4s46_2 c4s47_2 0.07748f
CCc4s46_4 c4s46_4 c4s47_4 0.03177f
CCc4s46_6 c4s46_6 c4s47_6 0.1142f
Rc4s47_0 c4s47_0 c4s47_1 5.289
Rc4s47_1 c4s47_1 c4s47_2 0.7139
Rc4s47_2 c4s47_2 c4s47_3 2.374
Rc4s47_3 c4s47_3 c4s47_4 1.545
Rc4s47_4 c4s47_4 c4s47_5 0.5837
Rc4s47_5 c4s47_5 c4s47_6 0.6806
Cc4s47_0 c4s47_0 0 0.2192f
Cc4s47_1 c4s47_1 0 0.2668f
Cc4s47_2 c4s47_2 0 0.2059f
Cc4s47_3 c4s47_3 0 0.2613f
Cc4s47_4 c4s47_4 0 0.1419f
Cc4s47_5 c4s47_5 0 0.08429f
Cc4s47_6 c4s47_6 0 0.04538f
CCc4s47_0 c4s47_0 c4s48_0 0.02635f
CCc4s47_2 c4s47_2 c4s48_2 0.06294f
CCc4s47_4 c4s47_4 c4s48_4 0.0631f
CCc4s47_6 c4s47_6 c4s48_6 0.09524f
Rc4s48_0 c4s48_0 c4s48_1 4.405
Rc4s48_1 c4s48_1 c4s48_2 3.129
Rc4s48_2 c4s48_2 c4s48_3 3.147
Rc4s48_3 c4s48_3 c4s48_4 0.9891
Rc4s48_4 c4s48_4 c4s48_5 2.427
Rc4s48_5 c4s48_5 c4s48_6 3.211
Cc4s48_0 c4s48_0 0 0.1604f
Cc4s48_1 c4s48_1 0 0.3689f
Cc4s48_2 c4s48_2 0 0.4184f
Cc4s48_3 c4s48_3 0 0.2757f
Cc4s48_4 c4s48_4 0 0.2277f
Cc4s48_5 c4s48_5 0 0.3759f
Cc4s48_6 c4s48_6 0 0.2141f
CCc4s48_0 c4s48_0 c4s49_0 0.05499f
Cc4s49_0 c4s49_0 0 0f
CCc4s49_0 c4s49_0 c5s0_0 0.1044f
Rc5s0_0 c5s0_0 c5s0_1 5.563
Rc5s0_1 c5s0_1 c5s0_2 2.448
Rc5s0_2 c5s0_2 c5s0_3 2.66
Rc5s0_3 c5s0_3 c5s0_4 1.429
Rc5s0_4 c5s0_4 c5s0_5 3.576
Rc5s0_5 c5s0_5 c5s0_6 3.069
Cc5s0_0 c5s0_0 0 0.2375f
Cc5s0_1 c5s0_1 0 0.4008f
Cc5s0_2 c5s0_2 0 0.3405f
Cc5s0_3 c5s0_3 0 0.2726f
Cc5s0_4 c5s0_4 0 0.3337f
Cc5s0_5 c5s0_5 0 0.443f
Cc5s0_6 c5s0_6 0 0.2046f
CCc5s0_0 c5s0_0 c5s1_0 0.06519f
CCc5s0_2 c5s0_2 c5s1_2 0.06225f
CCc5s0_4 c5s0_4 c5s1_4 0.02067f
CCc5s0_6 c5s0_6 c5s1_6 0.08736f
Rc5s1_0 c5s1_0 c5s1_1 5.201
Rc5s1_1 c5s1_1 c5s1_2 2.922
Rc5s1_2 c5s1_2 c5s1_3 0.9148
Rc5s1_3 c5s1_3 c5s1_4 1.211
Rc5s1_4 c5s1_4 c5s1_5 0.9579
Rc5s1_5 c5s1_5 c5s1_6 1.268
Cc5s1_0 c5s1_0 0 0.2134f
Cc5s1_1 c5s1_1 0 0.4082f
Cc5s1_2 c5s1_2 0 0.2558f
Cc5s1_3 c5s1_3 0 0.1417f
Cc5s1_4 c5s1_4 0 0.1446f
Cc5s1_5 c5s1_5 0 0.1484f
Cc5s1_6 c5s1_6 0 0.08452f
CCc5s1_0 c5s1_0 c5s2_0 0.04836f
CCc5s1_2 c5s1_2 c5s2_2 0.0431f
CCc5s1_4 c5s1_4 c5s2_4 0.09745f
CCc5s1_6 c5s1_6 c5s2_6 0.148f
Rc5s2_0 c5s2_0 c5s2_1 5.142
Rc5s2_1 c5s2_1 c5s2_2 2.407
Rc5s2_2 c5s2_2 c5s2_3 1.446
Rc5s2_3 c5s2_3 c5s2_4 3.311
Rc5s2_4 c5s2_4 c5s2_5 1.115
Rc5s2_5 c5s2_5 c5s2_6 0.5718
Cc5s2_0 c5s2_0 0 0.2095f
Cc5s2_1 c5s2_1 0 0.3699f
Cc5s2_2 c5s2_2 0 0.2569f
Cc5s2_3 c5s2_3 0 0.3172f
Cc5s2_4 c5s2_4 0 0.2951f
Cc5s2_5 c5s2_5 0 0.1124f
Cc5s2_6 c5s2_6 0 0.03812f
CCc5s2_0 c5s2_0 c5s3_0 0.05024f
CCc5s2_2 c5s2_2 c5s3_2 0.1306f
CCc5s2_4 c5s2_4 c5s3_4 0.1181f
CCc5s2_6 c5s2_6 c5s3_6 0.06351f
Rc5s3_0 c5s3_0 c5s3_1 3.142
Rc5s3_1 c5s3_1 c5s3_2 2.457
Rc5s3_2 c5s3_2 c5s3_3 2.061
Rc5s3_3 c5s3_3 c5s3_4 2.951
Rc5s3_4 c5s3_4 c5s3_5 1.854
Rc5s3_5 c5s3_5 c5s3_6 0.7128
Cc5s3_0 c5s3_0 0 0.07616f
Cc5s3_1 c5s3_1 0 0.24f
Cc5s3_2 c5s3_2 0 0.3012f
Cc5s3_3 c5s3_3 0 0.3342f
Cc5s3_4 c5s3_4 0 0.3204f
Cc5s3_5 c5s3_5 0 0.1711f
Cc5s3_6 c5s3_6 0 0.04752f
CCc5s3_0 c5s3_0 c5s4_0 0.02986f
CCc5s3_2 c5s3_2 c5s4_2 0.05233f
CCc5s3_4 c5s3_4 c5s4_4 0.0933f
CCc5s3_6 c5s3_6 c5s4_6 0.1201f
Rc5s4_0 c5s4_0 c5s4_1 4.202
Rc5s4_1 c5s4_1 c5s4_2 0.4808
Rc5s4_2 c5s4_2 c5s4_3 3.452
Rc5s4_3 c5s4_3 c5s4_4 1.893
Rc5s4_4 c5s4_4 c5s4_5 2.152
Rc5s4_5 c5s4_5 c5s4_6 1.055
Cc5s4_0 c5s4_0 0 0.1468f
Cc5s4_1 c5s4_1 0 0.1788f
Cc5s4_2 c5s4_2 0 0.2622f
Cc5s4_3 c5s4_3 0 0.3563f
Cc5s4_4 c5s4_4 0 0.2697f
Cc5s4_5 c5s4_5 0 0.2138f
Cc5s4_6 c5s4_6 0 0.07036f
CCc5s4_0 c5s4_0 c5s5_0 0.05407f
CCc5s4_2 c5s4_2 c5s5_2 0.04999f
CCc5s4_4 c5s4_4 c5s5_4 0.1049f
CCc5s4_6 c5s4_6 c5s5_6 0.1472f
Rc5s5_0 c5s5_0 c5s5_1 3.282
Rc5s5_1 c5s5_1 c5s5_2 1.551
Rc5s5_2 c5s5_2 c5s5_3 1.356
Rc5s5_3 c5s5_3 c5s5_4 0.5416
Rc5s5_4 c5s5_4 c5s5_5 0.4831
Rc5s5_5 c5s5_5 c5s5_6 2.91
Cc5s5_0 c5s5_0 0 0.08546f
Cc5s5_1 c5s5_1 0 0.1888f
Cc5s5_2 c5s5_2 0 0.1938f
Cc5s5_3 c5s5_3 0 0.1265f
Cc5s5_4 c5s5_4 0 0.06831f
Cc5s5_5 c5s5_5 0 0.2262f
Cc5s5_6 c5s5_6 0 0.194f
CCc5s5_0 c5s5_0 c5s6_0 0.1569f
CCc5s5_2 c5s5_2 c5s6_2 0.02593f
CCc5s5_4 c5s5_4 c5s6_4 0.03077f
CCc5s5_6 c5s5_6 c5s6_6 0.0833f
Rc5s6_0 c5s6_0 c5s6_1 3.408
Rc5s6_1 c5s6_1 c5s6_2 1.227
Rc5s6_2 c5s6_2 c5s6_3 3.19
Rc5s6_3 c5s6_3 c5s6_4 1.058
Rc5s6_4 c5s6_4 c5s6_5 1.063
Rc5s6_5 c5s6_5 c5s6_6 3.304
Cc5s6_0 c5s6_0 0 0.09389f
Cc5s6_1 c5s6_1 0 0.1757f
Cc5s6_2 c5s6_2 0 0.2944f
Cc5s6_3 c5s6_3 0 0.2832f
Cc5s6_4 c5s6_4 0 0.1414f
Cc5s6_5 c5s6_5 0 0.2911f
Cc5s6_6 c5s6_6 0 0.2203f
CCc5s6_0 c5s6_0 c5s7_0 0.1072f
CCc5s6_2 c5s6_2 c5s7_2 0.116f
CCc5s6_4 c5s6_4 c5s7_4 0.1136f
CCc5s6_6 c5s6_6 c5s7_6 0.02361f
Rc5s7_0 c5s7_0 c5s7_1 5.531
Rc5s7_1 c5s7_1 c5s7_2 0.5406
Rc5s7_2 c5s7_2 c5s7_3 1.166
Rc5s7_3 c5s7_3 c5s7_4 1.947
Rc5s7_4 c5s7_4 c5s7_5 3.088
Rc5s7_5 c5s7_5 c5s7_6 3.441
Cc5s7_0 c5s7_0 0 0.2354f
Cc5s7_1 c5s7_1 0 0.2714f
Cc5s7_2 c5s7_2 0 0.1138f
Cc5s7_3 c5s7_3 0 0.2076f
Cc5s7_4 c5s7_4 0 0.3357f
Cc5s7_5 c5s7_5 0 0.4353f
Cc5s7_6 c5s7_6 0 0.2294f
CCc5s7_0 c5s7_0 c5s8_0 0.02124f
CCc5s7_2 c5s7_2 c5s8_2 0.03937f
CCc5s7_4 c5s7_4 c5s8_4 0.02224f
CCc5s7_6 c5s7_6 c5s8_6 0.0392f
Rc5s8_0 c5s8_0 c5s8_1 5.328
Rc5s8_1 c5s8_1 c5s8_2 0.7168
Rc5s8_2 c5s8_2 c5s8_3 2.148
Rc5s8_3 c5s8_3 c5s8_4 1.064
Rc5s8_4 c5s8_4 c5s8_5 0.4749
Rc5s8_5 c5s8_5 c5s8_6 1.331
Cc5s8_0 c5s8_0 0 0.2219f
Cc5s8_1 c5s8_1 0 0.2697f
Cc5s8_2 c5s8_2 0 0.191f
Cc5s8_3 c5s8_3 0 0.2141f
Cc5s8_4 c5s8_4 0 0.1026f
Cc5s8_5 c5s8_5 0 0.1204f
Cc5s8_6 c5s8_6 0 0.08874f
CCc5s8_0 c5s8_0 c5s9_0 0.05625f
CCc5s8_2 c5s8_2 c5s9_2 0.09599f
CCc5s8_4 c5s8_4 c5s9_4 0.1423f
CCc5s8_6 c5s8_6 c5s9_6 0.09421f
Rc5s9_0 c5s9_0 c5s9_1 4.13
Rc5s9_1 c5s9_1 c5s9_2 1.329
Rc5s9_2 c5s9_2 c5s9_3 1.017
Rc5s9_3 c5s9_3 c5s9_4 1.96
Rc5s9_4 c5s9_4 c5s9_5 1.691
Rc5s9_5 c5s9_5 c5s9_6 3.29
Cc5s9_0 c5s9_0 0 0.142f
Cc5s9_1 c5s9_1 0 0.2306f
Cc5s9_2 c5s9_2 0 0.1564f
Cc5s9_3 c5s9_3 0 0.1984f
Cc5s9_4 c5s9_4 0 0.2434f
Cc5s9_5 c5s9_5 0 0.3321f
Cc5s9_6 c5s9_6 0 0.2194f
CCc5s9_0 c5s9_0 c5s10_0 0.04916f
CCc5s9_2 c5s9_2 c5s10_2 0.02359f
CCc5s9_4 c5s9_4 c5s10_4 0.02723f
CCc5s9_6 c5s9_6 c5s10_6 0.0644f
Rc5s10_0 c5s10_0 c5s10_1 3.139
Rc5s10_1 c5s10_1 c5s10_2 1.7
Rc5s10_2 c5s10_2 c5s10_3 3.223
Rc5s10_3 c5s10_3 c5s10_4 2.744
Rc5s10_4 c5s10_4 c5s10_5 2.319
Rc5s10_5 c5s10_5 c5s10_6 3.071
Cc5s10_0 c5s10_0 0 0.07596f
Cc5s10_1 c5s10_1 0 0.1893f
Cc5s10_2 c5s10_2 0 0.3282f
Cc5s10_3 c5s10_3 0 0.3978f
Cc5s10_4 c5s10_4 0 0.3375f
Cc5s10_5 c5s10_5 0 0.3593f
Cc5s10_6 c5s10_6 0 0.2047f
CCc5s10_0 c5s10_0 c5s11_0 0.1431f
CCc5s10_2 c5s10_2 c5s11_2 0.02909f
CCc5s10_4 c5s10_4 c5s11_4 0.1165f
CCc5s10_6 c5s10_6 c5s11_6 0.03836f
Rc5s11_0 c5s11_0 c5s11_1 3.744
Rc5s11_1 c5s11_1 c5s11_2 1.677
Rc5s11_2 c5s11_2 c5s11_3 1.306
Rc5s11_3 c5s11_3 c5s11_4 0.5898
Rc5s11_4 c5s11_4 c5s11_5 1.062
Rc5s11_5 c5s11_5 c5s11_6 2.675
Cc5s11_0 c5s11_0 0 0.1163f
Cc5s11_1 c5s11_1 0 0.2281f
Cc5s11_2 c5s11_2 0 0.1989f
Cc5s11_3 c5s11_3 0 0.1264f
Cc5s11_4 c5s11_4 0 0.1101f
Cc5s11_5 c5s11_5 0 0.2491f
Cc5s11_6 c5s11_6 0 0.1783f
CCc5s11_0 c5s11_0 c5s12_0 0.154f
CCc5s11_2 c5s11_2 c5s12_2 0.1473f
CCc5s11_4 c5s11_4 c5s12_4 0.0232f
CCc5s11_6 c5s11_6 c5s12_6 0.09974f
Rc5s12_0 c5s12_0 c5s12_1 3.051
Rc5s12_1 c5s12_1 c5s12_2 2.091
Rc5s12_2 c5s12_2 c5s12_3 2.131
Rc5s12_3 c5s12_3 c5s12_4 0.9615
Rc5s12_4 c5s12_4 c5s12_5 0.727
Rc5s12_5 c5s12_5 c5s12_6 1.963
Cc5s12_0 c5s12_0 0 0.07005f
Cc5s12_1 c5s12_1 0 0.2094f
Cc5s12_2 c5s12_2 0 0.2814f
Cc5s12_3 c5s12_3 0 0.2062f
Cc5s12_4 c5s12_4 0 0.1126f
Cc5s12_5 c5s12_5 0 0.1794f
Cc5s12_6 c5s12_6 0 0.1309f
CCc5s12_0 c5s12_0 c5s13_0 0.02737f
CCc5s12_2 c5s12_2 c5s13_2 0.1377f
CCc5s12_4 c5s12_4 c5s13_4 0.1444f
CCc5s12_6 c5s12_6 c5s13_6 0.02208f
Rc5s13_0 c5s13_0 c5s13_1 4.973
Rc5s13_1 c5s13_1 c5s13_2 3.092
Rc5s13_2 c5s13_2 c5s13_3 0.5752
Rc5s13_3 c5s13_3 c5s13_4 2.3
Rc5s13_4 c5s13_4 c5s13_5 1.946
Rc5s13_5 c5s13_5 c5s13_6 1.002
Cc5s13_0 c5s13_0 0 0.1982f
Cc5s13_1 c5s13_1 0 0.4043f
Cc5s13_2 c5s13_2 0 0.2445f
Cc5s13_3 c5s13_3 0 0.1916f
Cc5s13_4 c5s13_4 0 0.283f
Cc5s13_5 c5s13_5 0 0.1965f
Cc5s13_6 c5s13_6 0 0.0668f
CCc5s13_0 c5s13_0 c5s14_0 0.1346f
CCc5s13_2 c5s13_2 c5s14_2 0.09928f
CCc5s13_4 c5s13_4 c5s14_4 0.1337f
CCc5s13_6 c5s13_6 c5s14_6 0.1509f
Rc5s14_0 c5s14_0 c5s14_1 5.505
Rc5s14_1 c5s14_1 c5s14_2 2.537
Rc5s14_2 c5s14_2 c5s14_3 3.2
Rc5s14_3 c5s14_3 c5s14_4 0.6499
Rc5s14_4 c5s14_4 c5s14_5 1.514
Rc5s14_5 c5s14_5 c5s14_6 1.946
Cc5s14_0 c5s14_0 0 0.2337f
Cc5s14_1 c5s14_1 0 0.4028f
Cc5s14_2 c5s14_2 0 0.3825f
Cc5s14_3 c5s14_3 0 0.2566f
Cc5s14_4 c5s14_4 0 0.1443f
Cc5s14_5 c5s14_5 0 0.2307f
Cc5s14_6 c5s14_6 0 0.1297f
CCc5s14_0 c5s14_0 c5s15_0 0.09171f
CCc5s14_2 c5s14_2 c5s15_2 0.07146f
CCc5s14_4 c5s14_4 c5s15_4 0.1344f
CCc5s14_6 c5s14_6 c5s15_6 0.1015f
Rc5s15_0 c5s15_0 c5s15_1 5.117
Rc5s15_1 c5s15_1 c5s15_2 1.846
Rc5s15_2 c5s15_2 c5s15_3 3.417
Rc5s15_3 c5s15_3 c5s15_4 1.571
Rc5s15_4 c5s15_4 c5s15_5 3.579
Rc5s15_5 c5s15_5 c5s15_6 2.234
Cc5s15_0 c5s15_0 0 0.2078f
Cc5s15_1 c5s15_1 0 0.3308f
Cc5s15_2 c5s15_2 0 0.3508f
Cc5s15_3 c5s15_3 0 0.3325f
Cc5s15_4 c5s15_4 0 0.3433f
Cc5s15_5 c5s15_5 0 0.3875f
Cc5s15_6 c5s15_6 0 0.1489f
CCc5s15_0 c5s15_0 c5s16_0 0.07281f
CCc5s15_2 c5s15_2 c5s16_2 0.1069f
CCc5s15_4 c5s15_4 c5s16_4 0.03488f
CCc5s15_6 c5s15_6 c5s16_6 0.1162f
Rc5s16_0 c5s16_0 c5s16_1 4.339
Rc5s16_1 c5s16_1 c5s16_2 2.986
Rc5s16_2 c5s16_2 c5s16_3 0.6884
Rc5s16_3 c5s16_3 c5s16_4 1.771
Rc5s16_4 c5s16_4 c5s16_5 2.297
Rc5s16_5 c5s16_5 c5s16_6 0.6416
Cc5s16_0 c5s16_0 0 0.156f
Cc5s16_1 c5s16_1 0 0.3551f
Cc5s16_2 c5s16_2 0 0.245f
Cc5s16_3 c5s16_3 0 0.164f
Cc5s16_4 c5s16_4 0 0.2712f
Cc5s16_5 c5s16_5 0 0.1959f
Cc5s16_6 c5s16_6 0 0.04277f
CCc5s16_0 c5s16_0 c5s17_0 0.1268f
CCc5s16_2 c5s16_2 c5s17_2 0.1461f
CCc5s16_4 c5s16_4 c5s17_4 0.1076f
CCc5s16_6 c5s16_6 c5s17_6 0.127f
Rc5s17_0 c5s17_0 c5s17_1 5.425
Rc5s17_1 c5s17_1 c5s17_2 1.882
Rc5s17_2 c5s17_2 c5s17_3 2.062
Rc5s17_3 c5s17_3 c5s17_4 3.248
Rc5s17_4 c5s17_4 c5s17_5 2.582
Rc5s17_5 c5s17_5 c5s17_6 1.322
Cc5s17_0 c5s17_0 0 0.2283f
Cc5s17_1 c5s17_1 0 0.3538f
Cc5s17_2 c5s17_2 0 0.263f
Cc5s17_3 c5s17_3 0 0.354f
Cc5s17_4 c5s17_4 0 0.3886f
Cc5s17_5 c5s17_5 0 0.2602f
Cc5s17_6 c5s17_6 0 0.08811f
CCc5s17_0 c5s17_0 c5s18_0 0.1025f
CCc5s17_2 c5s17_2 c5s18_2 0.1274f
CCc5s17_4 c5s17_4 c5s18_4 0.1382f
CCc5s17_6 c5s17_6 c5s18_6 0.03817f
Rc5s18_0 c5s18_0 c5s18_1 2.976
Rc5s18_1 c5s18_1 c5s18_2 2.616
Rc5s18_2 c5s18_2 c5s18_3 2.705
Rc5s18_3 c5s18_3 c5s18_4 2.748
Rc5s18_4 c5s18_4 c5s18_5 1.991
Rc5s18_5 c5s18_5 c5s18_6 1.659
Cc5s18_0 c5s18_0 0 0.06509f
Cc5s18_1 c5s18_1 0 0.2395f
Cc5s18_2 c5s18_2 0 0.3547f
Cc5s18_3 c5s18_3 0 0.3636f
Cc5s18_4 c5s18_4 0 0.3159f
Cc5s18_5 c5s18_5 0 0.2433f
Cc5s18_6 c5s18_6 0 0.1106f
CCc5s18_0 c5s18_0 c5s19_0 0.1545f
CCc5s18_2 c5s18_2 c5s19_2 0.05566f
CCc5s18_4 c5s18_4 c5s19_4 0.06015f
CCc5s18_6 c5s18_6 c5s19_6 0.02347f
Rc5s19_0 c5s19_0 c5s19_1 2.716
Rc5s19_1 c5s19_1 c5s19_2 2.42
Rc5s19_2 c5s19_2 c5s19_3 2.538
Rc5s19_3 c5s19_3 c5s19_4 1.14
Rc5s19_4 c5s19_4 c5s19_5 2.781
Rc5s19_5 c5s19_5 c5s19_6 0.9869
Cc5s19_0 c5s19_0 0 0.04774f
Cc5s19_1 c5s19_1 0 0.209f
Cc5s19_2 c5s19_2 0 0.3305f
Cc5s19_3 c5s19_3 0 0.2451f
Cc5s19_4 c5s19_4 0 0.2614f
Cc5s19_5 c5s19_5 0 0.2512f
Cc5s19_6 c5s19_6 0 0.06579f
CCc5s19_0 c5s19_0 c5s20_0 0.07208f
CCc5s19_2 c5s19_2 c5s20_2 0.1091f
CCc5s19_4 c5s19_4 c5s20_4 0.1288f
CCc5s19_6 c5s19_6 c5s20_6 0.0834f
Rc5s20_0 c5s20_0 c5s20_1 4.996
Rc5s20_1 c5s20_1 c5s20_2 1.937
Rc5s20_2 c5s20_2 c5s20_3 2.541
Rc5s20_3 c5s20_3 c5s20_4 3.076
Rc5s20_4 c5s20_4 c5s20_5 2.222
Rc5s20_5 c5s20_5 c5s20_6 2.222
Cc5s20_0 c5s20_0 0 0.1998f
Cc5s20_1 c5s20_1 0 0.3289f
Cc5s20_2 c5s20_2 0 0.2986f
Cc5s20_3 c5s20_3 0 0.3745f
Cc5s20_4 c5s20_4 0 0.3532f
Cc5s20_5 c5s20_5 0 0.2963f
Cc5s20_6 c5s20_6 0 0.1481f
CCc5s20_0 c5s20_0 c5s21_0 0.1506f
CCc5s20_2 c5s20_2 c5s21_2 0.02476f
CCc5s20_4 c5s20_4 c5s21_4 0.02262f
CCc5s20_6 c5s20_6 c5s21_6 0.0251f
Rc5s21_0 c5s21_0 c5s21_1 3.429
Rc5s21_1 c5s21_1 c5s21_2 2.143
Rc5s21_2 c5s21_2 c5s21_3 2.396
Rc5s21_3 c5s21_3 c5s21_4 2.596
Rc5s21_4 c5s21_4 c5s21_5 0.5037
Rc5s21_5 c5s21_5 c5s21_6 3.203
Cc5s21_0 c5s21_0 0 0.0953f
Cc5s21_1 c5s21_1 0 0.2382f
Cc5s21_2 c5s21_2 0 0.3027f
Cc5s21_3 c5s21_3 0 0.3328f
Cc5s21_4 c5s21_4 0 0.2067f
Cc5s21_5 c5s21_5 0 0.2471f
Cc5s21_6 c5s21_6 0 0.2135f
CCc5s21_0 c5s21_0 c5s22_0 0.05325f
CCc5s21_2 c5s21_2 c5s22_2 0.1554f
CCc5s21_4 c5s21_4 c5s22_4 0.06842f
CCc5s21_6 c5s21_6 c5s22_6 0.1383f
Rc5s22_0 c5s22_0 c5s22_1 4.695
Rc5s22_1 c5s22_1 c5s22_2 0.5222
Rc5s22_2 c5s22_2 c5s22_3 2.063
Rc5s22_3 c5s22_3 c5s22_4 1.69
Rc5s22_4 c5s22_4 c5s22_5 3.579
Rc5s22_5 c5s22_5 c5s22_6 1.181
Cc5s22_0 c5s22_0 0 0.1797f
Cc5s22_1 c5s22_1 0 0.2145f
Cc5s22_2 c5s22_2 0 0.1723f
Cc5s22_3 c5s22_3 0 0.2502f
Cc5s22_4 c5s22_4 0 0.3513f
Cc5s22_5 c5s22_5 0 0.3173f
Cc5s22_6 c5s22_6 0 0.07872f
CCc5s22_0 c5s22_0 c5s23_0 0.0753f
CCc5s22_2 c5s22_2 c5s23_2 0.04439f
CCc5s22_4 c5s22_4 c5s23_4 0.02066f
CCc5s22_6 c5s22_6 c5s23_6 0.09538f
Rc5s23_0 c5s23_0 c5s23_1 4.403
Rc5s23_1 c5s23_1 c5s23_2 0.9621
Rc5s23_2 c5s23_2 c5s23_3 3.088
Rc5s23_3 c5s23_3 c5s23_4 1.15
Rc5s23_4 c5s23_4 c5s23_5 3.403
Rc5s23_5 c5s23_5 c5s23_6 2.571
Cc5s23_0 c5s23_0 0 0.1602f
Cc5s23_1 c5s23_1 0 0.2244f
Cc5s23_2 c5s23_2 0 0.27f
Cc5s23_3 c5s23_3 0 0.2825f
Cc5s23_4 c5s23_4 0 0.3035f
Cc5s23_5 c5s23_5 0 0.3983f
Cc5s23_6 c5s23_6 0 0.1714f
CCc5s23_0 c5s23_0 c5s24_0 0.156f
CCc5s23_2 c5s23_2 c5s24_2 0.0813f
CCc5s23_4 c5s23_4 c5s24_4 0.1374f
CCc5s23_6 c5s23_6 c5s24_6 0.1047f
Rc5s24_0 c5s24_0 c5s24_1 4.702
Rc5s24_1 c5s24_1 c5s24_2 1.743
Rc5s24_2 c5s24_2 c5s24_3 2.061
Rc5s24_3 c5s24_3 c5s24_4 1.306
Rc5s24_4 c5s24_4 c5s24_5 1.512
Rc5s24_5 c5s24_5 c5s24_6 3.365
Cc5s24_0 c5s24_0 0 0.1801f
Cc5s24_1 c5s24_1 0 0.2964f
Cc5s24_2 c5s24_2 0 0.2536f
Cc5s24_3 c5s24_3 0 0.2245f
Cc5s24_4 c5s24_4 0 0.1879f
Cc5s24_5 c5s24_5 0 0.3251f
Cc5s24_6 c5s24_6 0 0.2244f
CCc5s24_0 c5s24_0 c5s25_0 0.03096f
CCc5s24_2 c5s24_2 c5s25_2 0.1365f
CCc5s24_4 c5s24_4 c5s25_4 0.125f
CCc5s24_6 c5s24_6 c5s25_6 0.04268f
Rc5s25_0 c5s25_0 c5s25_1 3.806
Rc5s25_1 c5s25_1 c5s25_2 3.081
Rc5s25_2 c5s25_2 c5s25_3 2.053
Rc5s25_3 c5s25_3 c5s25_4 2.05
Rc5s25_4 c5s25_4 c5s25_5 2.037
Rc5s25_5 c5s25_5 c5s25_6 0.9915
Cc5s25_0 c5s25_0 0 0.1204f
Cc5s25_1 c5s25_1 0 0.3258f
Cc5s25_2 c5s25_2 0 0.3423f
Cc5s25_3 c5s25_3 0 0.2735f
Cc5s25_4 c5s25_4 0 0.2724f
Cc5s25_5 c5s25_5 0 0.2019f
Cc5s25_6 c5s25_6 0 0.0661f
CCc5s25_0 c5s25_0 c5s26_0 0.1587f
CCc5s25_2 c5s25_2 c5s26_2 0.1248f
CCc5s25_4 c5s25_4 c5s26_4 0.05998f
CCc5s25_6 c5s25_6 c5s26_6 0.06862f
Rc5s26_0 c5s26_0 c5s26_1 4.679
Rc5s26_1 c5s26_1 c5s26_2 3.191
Rc5s26_2 c5s26_2 c5s26_3 2.187
Rc5s26_3 c5s26_3 c5s26_4 1.352
Rc5s26_4 c5s26_4 c5s26_5 1.58
Rc5s26_5 c5s26_5 c5s26_6 2.166
Cc5s26_0 c5s26_0 0 0.1786f
Cc5s26_1 c5s26_1 0 0.3913f
Cc5s26_2 c5s26_2 0 0.3585f
Cc5s26_3 c5s26_3 0 0.2359f
Cc5s26_4 c5s26_4 0 0.1955f
Cc5s26_5 c5s26_5 0 0.2497f
Cc5s26_6 c5s26_6 0 0.1444f
CCc5s26_0 c5s26_0 c5s27_0 0.1441f
CCc5s26_2 c5s26_2 c5s27_2 0.1185f
CCc5s26_4 c5s26_4 c5s27_4 0.05158f
CCc5s26_6 c5s26_6 c5s27_6 0.02281f
Rc5s27_0 c5s27_0 c5s27_1 4.521
Rc5s27_1 c5s27_1 c5s27_2 1.279
Rc5s27_2 c5s27_2 c5s27_3 3.211
Rc5s27_3 c5s27_3 c5s27_4 0.9554
Rc5s27_4 c5s27_4 c5s27_5 3.588
Rc5s27_5 c5s27_5 c5s27_6 2.972
Cc5s27_0 c5s27_0 0 0.1681f
Cc5s27_1 c5s27_1 0 0.2534f
Cc5s27_2 c5s27_2 0 0.2994f
Cc5s27_3 c5s27_3 0 0.2778f
Cc5s27_4 c5s27_4 0 0.3029f
Cc5s27_5 c5s27_5 0 0.4374f
Cc5s27_6 c5s27_6 0 0.1982f
CCc5s27_0 c5s27_0 c5s28_0 0.05533f
CCc5s27_2 c5s27_2 c5s28_2 0.0222f
CCc5s27_4 c5s27_4 c5s28_4 0.1349f
CCc5s27_6 c5s27_6 c5s28_6 0.03547f
Rc5s28_0 c5s28_0 c5s28_1 2.929
Rc5s28_1 c5s28_1 c5s28_2 1.661
Rc5s28_2 c5s28_2 c5s28_3 0.9936
Rc5s28_3 c5s28_3 c5s28_4 0.7487
Rc5s28_4 c5s28_4 c5s28_5 2.18
Rc5s28_5 c5s28_5 c5s28_6 2.513
Cc5s28_0 c5s28_0 0 0.06193f
Cc5s28_1 c5s28_1 0 0.1726f
Cc5s28_2 c5s28_2 0 0.177f
Cc5s28_3 c5s28_3 0 0.1162f
Cc5s28_4 c5s28_4 0 0.1952f
Cc5s28_5 c5s28_5 0 0.3128f
Cc5s28_6 c5s28_6 0 0.1675f
CCc5s28_0 c5s28_0 c5s29_0 0.1299f
CCc5s28_2 c5s28_2 c5s29_2 0.02811f
CCc5s28_4 c5s28_4 c5s29_4 0.02718f
CCc5s28_6 c5s28_6 c5s29_6 0.08613f
Rc5s29_0 c5s29_0 c5s29_1 4.786
Rc5s29_1 c5s29_1 c5s29_2 1.105
Rc5s29_2 c5s29_2 c5s29_3 2.326
Rc5s29_3 c5s29_3 c5s29_4 0.7982
Rc5s29_4 c5s29_4 c5s29_5 3.281
Rc5s29_5 c5s29_5 c5s29_6 3.202
Cc5s29_0 c5s29_0 0 0.1858f
Cc5s29_1 c5s29_1 0 0.2594f
Cc5s29_2 c5s29_2 0 0.2287f
Cc5s29_3 c5s29_3 0 0.2083f
Cc5s29_4 c5s29_4 0 0.2719f
Cc5s29_5 c5s29_5 0 0.4322f
Cc5s29_6 c5s29_6 0 0.2134f
CCc5s29_0 c5s29_0 c5s30_0 0.1511f
CCc5s29_2 c5s29_2 c5s30_2 0.07447f
CCc5s29_4 c5s29_4 c5s30_4 0.03157f
CCc5s29_6 c5s29_6 c5s30_6 0.1345f
Rc5s30_0 c5s30_0 c5s30_1 3.84
Rc5s30_1 c5s30_1 c5s30_2 1.551
Rc5s30_2 c5s30_2 c5s30_3 1.796
Rc5s30_3 c5s30_3 c5s30_4 2.684
Rc5s30_4 c5s30_4 c5s30_5 2.743
Rc5s30_5 c5s30_5 c5s30_6 1.823
Cc5s30_0 c5s30_0 0 0.1227f
Cc5s30_1 c5s30_1 0 0.2261f
Cc5s30_2 c5s30_2 0 0.2231f
Cc5s30_3 c5s30_3 0 0.2987f
Cc5s30_4 c5s30_4 0 0.3618f
Cc5s30_5 c5s30_5 0 0.3044f
Cc5s30_6 c5s30_6 0 0.1215f
CCc5s30_0 c5s30_0 c5s31_0 0.05731f
CCc5s30_2 c5s30_2 c5s31_2 0.04112f
CCc5s30_4 c5s30_4 c5s31_4 0.0274f
CCc5s30_6 c5s30_6 c5s31_6 0.1547f
Rc5s31_0 c5s31_0 c5s31_1 5.497
Rc5s31_1 c5s31_1 c5s31_2 0.6619
Rc5s31_2 c5s31_2 c5s31_3 2.318
Rc5s31_3 c5s31_3 c5s31_4 3.515
Rc5s31_4 c5s31_4 c5s31_5 2.264
Rc5s31_5 c5s31_5 c5s31_6 3.508
Cc5s31_0 c5s31_0 0 0.2331f
Cc5s31_1 c5s31_1 0 0.2773f
Cc5s31_2 c5s31_2 0 0.1987f
Cc5s31_3 c5s31_3 0 0.3889f
Cc5s31_4 c5s31_4 0 0.3853f
Cc5s31_5 c5s31_5 0 0.3848f
Cc5s31_6 c5s31_6 0 0.2338f
CCc5s31_0 c5s31_0 c5s32_0 0.04034f
CCc5s31_2 c5s31_2 c5s32_2 0.1207f
CCc5s31_4 c5s31_4 c5s32_4 0.1378f
CCc5s31_6 c5s31_6 c5s32_6 0.03604f
Rc5s32_0 c5s32_0 c5s32_1 3.094
Rc5s32_1 c5s32_1 c5s32_2 3.432
Rc5s32_2 c5s32_2 c5s32_3 1.184
Rc5s32_3 c5s32_3 c5s32_4 2.392
Rc5s32_4 c5s32_4 c5s32_5 3.322
Rc5s32_5 c5s32_5 c5s32_6 2.691
Cc5s32_0 c5s32_0 0 0.07291f
Cc5s32_1 c5s32_1 0 0.3017f
Cc5s32_2 c5s32_2 0 0.3078f
Cc5s32_3 c5s32_3 0 0.2384f
Cc5s32_4 c5s32_4 0 0.3809f
Cc5s32_5 c5s32_5 0 0.4008f
Cc5s32_6 c5s32_6 0 0.1794f
CCc5s32_0 c5s32_0 c5s33_0 0.1282f
CCc5s32_2 c5s32_2 c5s33_2 0.06187f
CCc5s32_4 c5s32_4 c5s33_4 0.1389f
CCc5s32_6 c5s32_6 c5s33_6 0.03936f
Rc5s33_0 c5s33_0 c5s33_1 3.71
Rc5s33_1 c5s33_1 c5s33_2 1.991
Rc5s33_2 c5s33_2 c5s33_3 2.667
Rc5s33_3 c5s33_3 c5s33_4 0.5574
Rc5s33_4 c5s33_4 c5s33_5 0.6869
Rc5s33_5 c5s33_5 c5s33_6 1.61
Cc5s33_0 c5s33_0 0 0.114f
Cc5s33_1 c5s33_1 0 0.2467f
Cc5s33_2 c5s33_2 0 0.3105f
Cc5s33_3 c5s33_3 0 0.215f
Cc5s33_4 c5s33_4 0 0.08295f
Cc5s33_5 c5s33_5 0 0.1531f
Cc5s33_6 c5s33_6 0 0.1073f
CCc5s33_0 c5s33_0 c5s34_0 0.04179f
CCc5s33_2 c5s33_2 c5s34_2 0.1474f
CCc5s33_4 c5s33_4 c5s34_4 0.08211f
CCc5s33_6 c5s33_6 c5s34_6 0.1025f
Rc5s34_0 c5s34_0 c5s34_1 3.792
Rc5s34_1 c5s34_1 c5s34_2 3.157
Rc5s34_2 c5s34_2 c5s34_3 3.366
Rc5s34_3 c5s34_3 c5s34_4 3.286
Rc5s34_4 c5s34_4 c5s34_5 0.7056
Rc5s34_5 c5s34_5 c5s34_6 2.374
Cc5s34_0 c5s34_0 0 0.1195f
Cc5s34_1 c5s34_1 0 0.3299f
Cc5s34_2 c5s34_2 0 0.4348f
Cc5s34_3 c5s34_3 0 0.4434f
Cc5s34_4 c5s34_4 0 0.2661f
Cc5s34_5 c5s34_5 0 0.2053f
Cc5s34_6 c5s34_6 0 0.1583f
CCc5s34_0 c5s34_0 c5s35_0 0.1288f
CCc5s34_2 c5s34_2 c5s35_2 0.1485f
CCc5s34_4 c5s34_4 c5s35_4 0.09786f
CCc5s34_6 c5s34_6 c5s35_6 0.08579f
Rc5s35_0 c5s35_0 c5s35_1 3.005
Rc5s35_1 c5s35_1 c5s35_2 0.4757
Rc5s35_2 c5s35_2 c5s35_3 0.5258
Rc5s35_3 c5s35_3 c5s35_4 1.328
Rc5s35_4 c5s35_4 c5s35_5 2.719
Rc5s35_5 c5s35_5 c5s35_6 1.717
Cc5s35_0 c5s35_0 0 0.067f
Cc5s35_1 c5s35_1 0 0.09871f
Cc5s35_2 c5s35_2 0 0.06677f
Cc5s35_3 c5s35_3 0 0.1236f
Cc5s35_4 c5s35_4 0 0.2698f
Cc5s35_5 c5s35_5 0 0.2957f
Cc5s35_6 c5s35_6 0 0.1145f
CCc5s35_0 c5s35_0 c5s36_0 0.09586f
CCc5s35_2 c5s35_2 c5s36_2 0.05799f
CCc5s35_4 c5s35_4 c5s36_4 0.1563f
CCc5s35_6 c5s35_6 c5s36_6 0.1488f
Rc5s36_0 c5s36_0 c5s36_1 3.282
Rc5s36_1 c5s36_1 c5s36_2 1.661
Rc5s36_2 c5s36_2 c5s36_3 0.782
Rc5s36_3 c5s36_3 c5s36_4 1.695
Rc5s36_4 c5s36_4 c5s36_5 1.21
Rc5s36_5 c5s36_5 c5s36_6 2.739
Cc5s36_0 c5s36_0 0 0.08544f
Cc5s36_1 c5s36_1 0 0.1961f
Cc5s36_2 c5s36_2 0 0.1628f
Cc5s36_3 c5s36_3 0 0.1651f
Cc5s36_4 c5s36_4 0 0.1937f
Cc5s36_5 c5s36_5 0 0.2633f
Cc5s36_6 c5s36_6 0 0.1826f
CCc5s36_0 c5s36_0 c5s37_0 0.06378f
CCc5s36_2 c5s36_2 c5s37_2 0.116f
CCc5s36_4 c5s36_4 c5s37_4 0.02372f
CCc5s36_6 c5s36_6 c5s37_6 0.1189f
Rc5s37_0 c5s37_0 c5s37_1 4.458
Rc5s37_1 c5s37_1 c5s37_2 1.365
Rc5s37_2 c5s37_2 c5s37_3 2.879
Rc5s37_3 c5s37_3 c5s37_4 3.172
Rc5s37_4 c5s37_4 c5s37_5 3.303
Rc5s37_5 c5s37_5 c5s37_6 2.638
Cc5s37_0 c5s37_0 0 0.1638f
Cc5s37_1 c5s37_1 0 0.2548f
Cc5s37_2 c5s37_2 0 0.2829f
Cc5s37_3 c5s37_3 0 0.4034f
Cc5s37_4 c5s37_4 0 0.4317f
Cc5s37_5 c5s37_5 0 0.3961f
Cc5s37_6 c5s37_6 0 0.1758f
CCc5s37_0 c5s37_0 c5s38_0 0.08148f
CCc5s37_2 c5s37_2 c5s38_2 0.1019f
CCc5s37_4 c5s37_4 c5s38_4 0.1267f
CCc5s37_6 c5s37_6 c5s38_6 0.06421f
Rc5s38_0 c5s38_0 c5s38_1 5.233
Rc5s38_1 c5s38_1 c5s38_2 2.928
Rc5s38_2 c5s38_2 c5s38_3 2.637
Rc5s38_3 c5s38_3 c5s38_4 2.841
Rc5s38_4 c5s38_4 c5s38_5 0.6113
Rc5s38_5 c5s38_5 c5s38_6 3.011
Cc5s38_0 c5s38_0 0 0.2155f
Cc5s38_1 c5s38_1 0 0.4107f
Cc5s38_2 c5s38_2 0 0.371f
Cc5s38_3 c5s38_3 0 0.3652f
Cc5s38_4 c5s38_4 0 0.2301f
Cc5s38_5 c5s38_5 0 0.2415f
Cc5s38_6 c5s38_6 0 0.2007f
CCc5s38_0 c5s38_0 c5s39_0 0.08253f
CCc5s38_2 c5s38_2 c5s39_2 0.1161f
CCc5s38_4 c5s38_4 c5s39_4 0.1111f
CCc5s38_6 c5s38_6 c5s39_6 0.0793f
Rc5s39_0 c5s39_0 c5s39_1 4.768
Rc5s39_1 c5s39_1 c5s39_2 3.152
Rc5s39_2 c5s39_2 c5s39_3 3.582
Rc5s39_3 c5s39_3 c5s39_4 0.5051
Rc5s39_4 c5s39_4 c5s39_5 3.332
Rc5s39_5 c5s39_5 c5s39_6 2.891
Cc5s39_0 c5s39_0 0 0.1845f
Cc5s39_1 c5s39_1 0 0.3946f
Cc5s39_2 c5s39_2 0 0.449f
Cc5s39_3 c5s39_3 0 0.2725f
Cc5s39_4 c5s39_4 0 0.2558f
Cc5s39_5 c5s39_5 0 0.4149f
Cc5s39_6 c5s39_6 0 0.1928f
CCc5s39_0 c5s39_0 c5s40_0 0.1034f
CCc5s39_2 c5s39_2 c5s40_2 0.1267f
CCc5s39_4 c5s39_4 c5s40_4 0.06875f
CCc5s39_6 c5s39_6 c5s40_6 0.07663f
Rc5s40_0 c5s40_0 c5s40_1 2.578
Rc5s40_1 c5s40_1 c5s40_2 3.374
Rc5s40_2 c5s40_2 c5s40_3 2.993
Rc5s40_3 c5s40_3 c5s40_4 2.077
Rc5s40_4 c5s40_4 c5s40_5 2.38
Rc5s40_5 c5s40_5 c5s40_6 3.045
Cc5s40_0 c5s40_0 0 0.03853f
Cc5s40_1 c5s40_1 0 0.2635f
Cc5s40_2 c5s40_2 0 0.4245f
Cc5s40_3 c5s40_3 0 0.338f
Cc5s40_4 c5s40_4 0 0.2971f
Cc5s40_5 c5s40_5 0 0.3617f
Cc5s40_6 c5s40_6 0 0.203f
CCc5s40_0 c5s40_0 c5s41_0 0.04327f
CCc5s40_2 c5s40_2 c5s41_2 0.09984f
CCc5s40_4 c5s40_4 c5s41_4 0.1212f
CCc5s40_6 c5s40_6 c5s41_6 0.1016f
Rc5s41_0 c5s41_0 c5s41_1 5.527
Rc5s41_1 c5s41_1 c5s41_2 1.257
Rc5s41_2 c5s41_2 c5s41_3 2.59
Rc5s41_3 c5s41_3 c5s41_4 2.904
Rc5s41_4 c5s41_4 c5s41_5 1.681
Rc5s41_5 c5s41_5 c5s41_6 3.412
Cc5s41_0 c5s41_0 0 0.2351f
Cc5s41_1 c5s41_1 0 0.3189f
Cc5s41_2 c5s41_2 0 0.2565f
Cc5s41_3 c5s41_3 0 0.3663f
Cc5s41_4 c5s41_4 0 0.3057f
Cc5s41_5 c5s41_5 0 0.3395f
Cc5s41_6 c5s41_6 0 0.2275f
CCc5s41_0 c5s41_0 c5s42_0 0.07768f
CCc5s41_2 c5s41_2 c5s42_2 0.0405f
CCc5s41_4 c5s41_4 c5s42_4 0.04385f
CCc5s41_6 c5s41_6 c5s42_6 0.07504f
Rc5s42_0 c5s42_0 c5s42_1 5.559
Rc5s42_1 c5s42_1 c5s42_2 3.332
Rc5s42_2 c5s42_2 c5s42_3 3.284
Rc5s42_3 c5s42_3 c5s42_4 2.539
Rc5s42_4 c5s42_4 c5s42_5 2.035
Rc5s42_5 c5s42_5 c5s42_6 2.473
Cc5s42_0 c5s42_0 0 0.2373f
Cc5s42_1 c5s42_1 0 0.4594f
Cc5s42_2 c5s42_2 0 0.441f
Cc5s42_3 c5s42_3 0 0.3882f
Cc5s42_4 c5s42_4 0 0.305f
Cc5s42_5 c5s42_5 0 0.3006f
Cc5s42_6 c5s42_6 0 0.1649f
CCc5s42_0 c5s42_0 c5s43_0 0.1047f
CCc5s42_2 c5s42_2 c5s43_2 0.1537f
CCc5s42_4 c5s42_4 c5s43_4 0.07501f
CCc5s42_6 c5s42_6 c5s43_6 0.07486f
Rc5s43_0 c5s43_0 c5s43_1 4.747
Rc5s43_1 c5s43_1 c5s43_2 2.982
Rc5s43_2 c5s43_2 c5s43_3 2.779
Rc5s43_3 c5s43_3 c5s43_4 0.9527
Rc5s43_4 c5s43_4 c5s43_5 2.446
Rc5s43_5 c5s43_5 c5s43_6 1.297
Cc5s43_0 c5s43_0 0 0.1831f
Cc5s43_1 c5s43_1 0 0.3819f
Cc5s43_2 c5s43_2 0 0.3841f
Cc5s43_3 c5s43_3 0 0.2488f
Cc5s43_4 c5s43_4 0 0.2266f
Cc5s43_5 c5s43_5 0 0.2495f
Cc5s43_6 c5s43_6 0 0.08646f
CCc5s43_0 c5s43_0 c5s44_0 0.05838f
CCc5s43_2 c5s43_2 c5s44_2 0.05576f
CCc5s43_4 c5s43_4 c5s44_4 0.02123f
CCc5s43_6 c5s43_6 c5s44_6 0.03674f
Rc5s44_0 c5s44_0 c5s44_1 4.566
Rc5s44_1 c5s44_1 c5s44_2 2.957
Rc5s44_2 c5s44_2 c5s44_3 0.7866
Rc5s44_3 c5s44_3 c5s44_4 3.432
Rc5s44_4 c5s44_4 c5s44_5 1.917
Rc5s44_5 c5s44_5 c5s44_6 2.915
Cc5s44_0 c5s44_0 0 0.1711f
Cc5s44_1 c5s44_1 0 0.3682f
Cc5s44_2 c5s44_2 0 0.2496f
Cc5s44_3 c5s44_3 0 0.2812f
Cc5s44_4 c5s44_4 0 0.3566f
Cc5s44_5 c5s44_5 0 0.3221f
Cc5s44_6 c5s44_6 0 0.1943f
CCc5s44_0 c5s44_0 c5s45_0 0.02581f
CCc5s44_2 c5s44_2 c5s45_2 0.03119f
CCc5s44_4 c5s44_4 c5s45_4 0.134f
CCc5s44_6 c5s44_6 c5s45_6 0.03351f
Rc5s45_0 c5s45_0 c5s45_1 2.568
Rc5s45_1 c5s45_1 c5s45_2 2.521
Rc5s45_2 c5s45_2 c5s45_3 0.588
Rc5s45_3 c5s45_3 c5s45_4 1.757
Rc5s45_4 c5s45_4 c5s45_5 3.018
Rc5s45_5 c5s45_5 c5s45_6 0.8092
Cc5s45_0 c5s45_0 0 0.03786f
Cc5s45_1 c5s45_1 0 0.206f
Cc5s45_2 c5s45_2 0 0.2073f
Cc5s45_3 c5s45_3 0 0.1563f
Cc5s45_4 c5s45_4 0 0.3183f
Cc5s45_5 c5s45_5 0 0.2551f
Cc5s45_6 c5s45_6 0 0.05395f
CCc5s45_0 c5s45_0 c5s46_0 0.138f
CCc5s45_2 c5s45_2 c5s46_2 0.1474f
CCc5s45_4 c5s45_4 c5s46_4 0.1565f
CCc5s45_6 c5s45_6 c5s46_6 0.106f
Rc5s46_0 c5s46_0 c5s46_1 5.037
Rc5s46_1 c5s46_1 c5s46_2 0.9516
Rc5s46_2 c5s46_2 c5s46_3 2.258
Rc5s46_3 c5s46_3 c5s46_4 3.207
Rc5s46_4 c5s46_4 c5s46_5 3.176
Rc5s46_5 c5s46_5 c5s46_6 0.9905
Cc5s46_0 c5s46_0 0 0.2025f
Cc5s46_1 c5s46_1 0 0.2659f
Cc5s46_2 c5s46_2 0 0.214f
Cc5s46_3 c5s46_3 0 0.3644f
Cc5s46_4 c5s46_4 0 0.4256f
Cc5s46_5 c5s46_5 0 0.2778f
Cc5s46_6 c5s46_6 0 0.06604f
CCc5s46_0 c5s46_0 c5s47_0 0.136f
CCc5s46_2 c5s46_2 c5s47_2 0.07573f
CCc5s46_4 c5s46_4 c5s47_4 0.09175f
CCc5s46_6 c5s46_6 c5s47_6 0.1316f
Rc5s47_0 c5s47_0 c5s47_1 4.555
Rc5s47_1 c5s47_1 c5s47_2 1.477
Rc5s47_2 c5s47_2 c5s47_3 3.146
Rc5s47_3 c5s47_3 c5s47_4 3.382
Rc5s47_4 c5s47_4 c5s47_5 2.997
Rc5s47_5 c5s47_5 c5s47_6 0.6069
Cc5s47_0 c5s47_0 0 0.1703f
Cc5s47_1 c5s47_1 0 0.2688f
Cc5s47_2 c5s47_2 0 0.3082f
Cc5s47_3 c5s47_3 0 0.4352f
Cc5s47_4 c5s47_4 0 0.4253f
Cc5s47_5 c5s47_5 0 0.2403f
Cc5s47_6 c5s47_6 0 0.04046f
CCc5s47_0 c5s47_0 c5s48_0 0.02212f
CCc5s47_2 c5s47_2 c5s48_2 0.1006f
CCc5s47_4 c5s47_4 c5s48_4 0.03392f
CCc5s47_6 c5s47_6 c5s48_6 0.0322f
Rc5s48_0 c5s48_0 c5s48_1 5.194
Rc5s48_1 c5s48_1 c5s48_2 0.5999
Rc5s48_2 c5s48_2 c5s48_3 1.336
Rc5s48_3 c5s48_3 c5s48_4 1.411
Rc5s48_4 c5s48_4 c5s48_5 3.388
Rc5s48_5 c5s48_5 c5s48_6 3.432
Cc5s48_0 c5s48_0 0 0.213f
Cc5s48_1 c5s48_1 0 0.2529f
Cc5s48_2 c5s48_2 0 0.129f
Cc5s48_3 c5s48_3 0 0.1831f
Cc5s48_4 c5s48_4 0 0.3199f
Cc5s48_5 c5s48_5 0 0.4546f
Cc5s48_6 c5s48_6 0 0.2288f
CCc5s48_0 c5s48_0 c5s49_0 0.1298f
Cc5s49_0 c5s49_0 0 0f
CCc5s49_0 c5s49_0 c6s0_0 0.08421f
Rc6s0_0 c6s0_0 c6s0_1 2.819
Rc6s0_1 c6s0_1 c6s0_2 3.486
Rc6s0_2 c6s0_2 c6s0_3 1.154
Rc6s0_3 c6s0_3 c6s0_4 2.47
Rc6s0_4 c6s0_4 c6s0_5 2.902
Rc6s0_5 c6s0_5 c6s0_6 2.056
Cc6s0_0 c6s0_0 0 0.05462f
Cc6s0_1 c6s0_1 0 0.287f
Cc6s0_2 c6s0_2 0 0.3093f
Cc6s0_3 c6s0_3 0 0.2416f
Cc6s0_4 c6s0_4 0 0.3581f
Cc6s0_5 c6s0_5 0 0.3305f
Cc6s0_6 c6s0_6 0 0.137f
CCc6s0_0 c6s0_0 c6s1_0 0.144f
CCc6s0_2 c6s0_2 c6s1_2 0.1514f
CCc6s0_4 c6s0_4 c6s1_4 0.07125f
CCc6s0_6 c6s0_6 c6s1_6 0.1193f
Rc6s1_0 c6s1_0 c6s1_1 2.747
Rc6s1_1 c6s1_1 c6s1_2 1.807
Rc6s1_2 c6s1_2 c6s1_3 2.567
Rc6s1_3 c6s1_3 c6s1_4 1.316
Rc6s1_4 c6s1_4 c6s1_5 1.626
Rc6s1_5 c6s1_5 c6s1_6 2.842
Cc6s1_0 c6s1_0 0 0.04982f
Cc6s1_1 c6s1_1 0 0.1703f
Cc6s1_2 c6s1_2 0 0.2916f
Cc6s1_3 c6s1_3 0 0.2589f
Cc6s1_4 c6s1_4 0 0.1961f
Cc6s1_5 c6s1_5 0 0.2979f
Cc6s1_6 c6s1_6 0 0.1895f
CCc6s1_0 c6s1_0 c6s2_0 0.04954f
CCc6s1_2 c6s1_2 c6s2_2 0.1491f
CCc6s1_4 c6s1_4 c6s2_4 0.03972f
CCc6s1_6 c6s1_6 c6s2_6 0.05122f
Rc6s2_0 c6s2_0 c6s2_1 4.385
Rc6s2_1 c6s2_1 c6s2_2 1.175
Rc6s2_2 c6s2_2 c6s2_3 3.096
Rc6s2_3 c6s2_3 c6s2_4 1.58
Rc6s2_4 c6s2_4 c6s2_5 0.8508
Rc6s2_5 c6s2_5 c6s2_6 2.557
Cc6s2_0 c6s2_0 0 0.159f
Cc6s2_1 c6s2_1 0 0.2373f
Cc6s2_2 c6s2_2 0 0.2847f
Cc6s2_3 c6s2_3 0 0.3117f
Cc6s2_4 c6s2_4 0 0.1621f
Cc6s2_5 c6s2_5 0 0.2272f
Cc6s2_6 c6s2_6 0 0.1705f
CCc6s2_0 c6s2_0 c6s3_0 0.07984f
CCc6s2_2 c6s2_2 c6s3_2 0.1073f
CCc6s2_4 c6s2_4 c6s3_4 0.03567f
CCc6s2_6 c6s2_6 c6s3_6 0.02742f
Rc6s3_0 c6s3_0 c6s3_1 3.38
Rc6s3_1 c6s3_1 c6s3_2 2.073
Rc6s3_2 c6s3_2 c6s3_3 1.077
Rc6s3_3 c6s3_3 c6s3_4 1.106
Rc6s3_4 c6s3_4 c6s3_5 3.084
Rc6s3_5 c6s3_5 c6s3_6 1.212
Cc6s3_0 c6s3_0 0 0.09202f
Cc6s3_1 c6s3_1 0 0.2302f
Cc6s3_2 c6s3_2 0 0.21f
Cc6s3_3 c6s3_3 0 0.1455f
Cc6s3_4 c6s3_4 0 0.2793f
Cc6s3_5 c6s3_5 0 0.2864f
Cc6s3_6 c6s3_6 0 0.08083f
CCc6s3_0 c6s3_0 c6s4_0 0.06858f
CCc6s3_2 c6s3_2 c6s4_2 0.142f
CCc6s3_4 c6s3_4 c6s4_4 0.1597f
CCc6s3_6 c6s3_6 c6s4_6 0.1281f
Rc6s4_0 c6s4_0 c6s4_1 2.893
Rc6s4_1 c6s4_1 c6s4_2 2.859
Rc6s4_2 c6s4_2 c6s4_3 0.7349
Rc6s4_3 c6s4_3 c6s4_4 2.968
Rc6s4_4 c6s4_4 c6s4_5 1.319
Rc6s4_5 c6s4_5 c6s4_6 1.141
Cc6s4_0 c6s4_0 0 0.05951f
Cc6s4_1 c6s4_1 0 0.2501f
Cc6s4_2 c6s4_2 0 0.2396f
Cc6s4_3 c6s4_3 0 0.2469f
Cc6s4_4 c6s4_4 0 0.2859f
Cc6s4_5 c6s4_5 0 0.164f
Cc6s4_6 c6s4_6 0 0.07604f
CCc6s4_0 c6s4_0 c6s5_0 0.07966f
CCc6s4_2 c6s4_2 c6s5_2 0.03991f
CCc6s4_4 c6s4_4 c6s5_4 0.1134f
CCc6s4_6 c6s4_6 c6s5_6 0.1352f
Rc6s5_0 c6s5_0 c6s5_1 4.549
Rc6s5_1 c6s5_1 c6s5_2 2.962
Rc6s5_2 c6s5_2 c6s5_3 0.958
Rc6s5_3 c6s5_3 c6s5_4 1.309
Rc6s5_4 c6s5_4 c6s5_5 3.088
Rc6s5_5 c6s5_5 c6s5_6 1.479
Cc6s5_0 c6s5_0 0 0.1699f
Cc6s5_1 c6s5_1 0 0.3674f
Cc6s5_2 c6s5_2 0 0.2613f
Cc6s5_3 c6s5_3 0 0.1511f
Cc6s5_4 c6s5_4 0 0.2931f
Cc6s5_5 c6s5_5 0 0.3044f
Cc6s5_6 c6s5_6 0 0.09857f
CCc6s5_0 c6s5_0 c6s6_0 0.1246f
CCc6s5_2 c6s5_2 c6s6_2 0.09936f
CCc6s5_4 c6s5_4 c6s6_4 0.04091f
CCc6s5_6 c6s5_6 c6s6_6 0.05099f
Rc6s6_0 c6s6_0 c6s6_1 5.358
Rc6s6_1 c6s6_1 c6s6_2 3.291
Rc6s6_2 c6s6_2 c6s6_3 2.327
Rc6s6_3 c6s6_3 c6s6_4 0.5002
Rc6s6_4 c6s6_4 c6s6_5 0.5029
Rc6s6_5 c6s6_5 c6s6_6 3.404
Cc6s6_0 c6s6_0 0 0.2239f
Cc6s6_1 c6s6_1 0 0.4433f
Cc6s6_2 c6s6_2 0 0.3746f
Cc6s6_3 c6s6_3 0 0.1885f
Cc6s6_4 c6s6_4 0 0.06687f
Cc6s6_5 c6s6_5 0 0.2604f
Cc6s6_6 c6s6_6 0 0.2269f
CCc6s6_0 c6s6_0 c6s7_0 0.1318f
CCc6s6_2 c6s6_2 c6s7_2 0.1177f
CCc6s6_4 c6s6_4 c6s7_4 0.05634f
CCc6s6_6 c6s6_6 c6s7_6 0.1472f
Rc6s7_0 c6s7_0 c6s7_1 2.68
Rc6s7_1 c6s7_1 c6s7_2 2.617
Rc6s7_2 c6s7_2 c6s7_3 2.618
Rc6s7_3 c6s7_3 c6s7_4 1.616
Rc6s7_4 c6s7_4 c6s7_5 3.01
Rc6s7_5 c6s7_5 c6s7_6 1.047
Cc6s7_0 c6s7_0 0 0.04534f
Cc6s7_1 c6s7_1 0 0.2198f
Cc6s7_2 c6s7_2 0 0.349f
Cc6s7_3 c6s7_3 0 0.2823f
Cc6s7_4 c6s7_4 0 0.3084f
Cc6s7_5 c6s7_5 0 0.2705f
Cc6s7_6 c6s7_6 0 0.06981f
CCc6s7_0 c6s7_0 c6s8_0 0.1547f
CCc6s7_2 c6s7_2 c6s8_2 0.1506f
CCc6s7_4 c6s7_4 c6s8_4 0.06747f
CCc6s7_6 c6s7_6 c6s8_6 0.06617f
Rc6s8_0 c6s8_0 c6s8_1 4.954
Rc6s8_1 c6s8_1 c6s8_2 1.531
Rc6s8_2 c6s8_2 c6s8_3 2.304
Rc6s8_3 c6s8_3 c6s8_4 2.627
Rc6s8_4 c6s8_4 c6s8_5 3.428
Rc6s8_5 c6s8_5 c6s8_6 2.825
Cc6s8_0 c6s8_0 0 0.1969f
Cc6s8_1 c6s8_1 0 0.299f
Cc6s8_2 c6s8_2 0 0.2556f
Cc6s8_3 c6s8_3 0 0.3287f
Cc6s8_4 c6s8_4 0 0.4036f
Cc6s8_5 c6s8_5 0 0.4168f
Cc6s8_6 c6s8_6 0 0.1883f
CCc6s8_0 c6s8_0 c6s9_0 0.05862f
CCc6s8_2 c6s8_2 c6s9_2 0.06946f
CCc6s8_4 c6s8_4 c6s9_4 0.03051f
CCc6s8_6 c6s8_6 c6s9_6 0.1326f
Rc6s9_0 c6s9_0 c6s9_1 5.111
Rc6s9_1 c6s9_1 c6s9_2 1.153
Rc6s9_2 c6s9_2 c6s9_3 1.937
Rc6s9_3 c6s9_3 c6s9_4 1.54
Rc6s9_4 c6s9_4 c6s9_5 1.341
Rc6s9_5 c6s9_5 c6s9_6 0.5422
Cc6s9_0 c6s9_0 0 0.2074f
Cc6s9_1 c6s9_1 0 0.2842f
Cc6s9_2 c6s9_2 0 0.206f
Cc6s9_3 c6s9_3 0 0.2318f
Cc6s9_4 c6s9_4 0 0.1921f
Cc6s9_5 c6s9_5 0 0.1255f
Cc6s9_6 c6s9_6 0 0.03615f
CCc6s9_0 c6s9_0 c6s10_0 0.1033f
CCc6s9_2 c6s9_2 c6s10_2 0.1531f
CCc6s9_4 c6s9_4 c6s10_4 0.04395f
CCc6s9_6 c6s9_6 c6s10_6 0.1256f
Rc6s10_0 c6s10_0 c6s10_1 4.885
Rc6s10_1 c6s10_1 c6s10_2 2.137
Rc6s10_2 c6s10_2 c6s10_3 3.121
Rc6s10_3 c6s10_3 c6s10_4 1.783
Rc6s10_4 c6s10_4 c6s10_5 2.407
Rc6s10_5 c6s10_5 c6s10_6 0.6643
Cc6s10_0 c6s10_0 0 0.1923f
Cc6s10_1 c6s10_1 0 0.3348f
Cc6s10_2 c6s10_2 0 0.3505f
Cc6s10_3 c6s10_3 0 0.327f
Cc6s10_4 c6s10_4 0 0.2793f
Cc6s10_5 c6s10_5 0 0.2047f
Cc6s10_6 c6s10_6 0 0.04428f
CCc6s10_0 c6s10_0 c6s11_0 0.04138f
CCc6s10_2 c6s10_2 c6s11_2 0.1022f
CCc6s10_4 c6s10_4 c6s11_4 0.1379f
CCc6s10_6 c6s10_6 c6s11_6 0.08638f
Rc6s11_0 c6s11_0 c6s11_1 5.391
Rc6s11_1 c6s11_1 c6s11_2 2.005
Rc6s11_2 c6s11_2 c6s11_3 1.742
Rc6s11_3 c6s11_3 c6s11_4 2.918
Rc6s11_4 c6s11_4 c6s11_5 3.35
Rc6s11_5 c6s11_5 c6s11_6 3.288
Cc6s11_0 c6s11_0 0 0.2261f
Cc6s11_1 c6s11_1 0 0.3597f
Cc6s11_2 c6s11_2 0 0.2498f
Cc6s11_3 c6s11_3 0 0.3107f
Cc6s11_4 c6s11_4 0 0.4179f
Cc6s11_5 c6s11_5 0 0.4425f
Cc6s11_6 c6s11_6 0 0.2192f
CCc6s11_0 c6s11_0 c6s12_0 0.1123f
CCc6s11_2 c6s11_2 c6s12_2 0.05009f
CCc6s11_4 c6s11_4 c6s12_4 0.06323f
CCc6s11_6 c6s11_6 c6s12_6 0.09805f
Rc6s12_0 c6s12_0 c6s12_1 2.564
Rc6s12_1 c6s12_1 c6s12_2 1.391
Rc6s12_2 c6s12_2 c6s12_3 2.932
Rc6s12_3 c6s12_3 c6s12_4 1.241
Rc6s12_4 c6s12_4 c6s12_5 2.492
Rc6s12_5 c6s12_5 c6s12_6 1.407
Cc6s12_0 c6s12_0 0 0.0376f
Cc6s12_1 c6s12_1 0 0.1303f
Cc6s12_2 c6s12_2 0 0.2882f
Cc6s12_3 c6s12_3 0 0.2782f
Cc6s12_4 c6s12_4 0 0.2489f
Cc6s12_5 c6s12_5 0 0.2599f
Cc6s12_6 c6s12_6 0 0.09381f
CCc6s12_0 c6s12_0 c6s13_0 0.03867f
CCc6s12_2 c6s12_2 c6s13_2 0.06668f
CCc6s12_4 c6s12_4 c6s13_4 0.06496f
CCc6s12_6 c6s12_6 c6s13_6 0.05891f
Rc6s13_0 c6s13_0 c6s13_1 3.428
Rc6s13_1 c6s13_1 c6s13_2 3.344
Rc6s13_2 c6s13_2 c6s13_3 2.26
Rc6s13_3 c6s13_3 c6s13_4 2.016
Rc6s13_4 c6s13_4 c6s13_5 1.282
Rc6s13_5 c6s13_5 c6s13_6 1.363
Cc6s13_0 c6s13_0 0 0.09522f
Cc6s13_1 c6s13_1 0 0.3181f
Cc6s13_2 c6s13_2 0 0.3736f
Cc6s13_3 c6s13_3 0 0.2851f
Cc6s13_4 c6s13_4 0 0.2199f
Cc6s13_5 c6s13_5 0 0.1763f
Cc6s13_6 c6s13_6 0 0.09085f
CCc6s13_0 c6s13_0 c6s14_0 0.1319f
CCc6s13_2 c6s13_2 c6s14_2 0.06676f
CCc6s13_4 c6s13_4 c6s14_4 0.04087f
CCc6s13_6 c6s13_6 c6s14_6 0.07422f
Rc6s14_0 c6s14_0 c6s14_1 4.571
Rc6s14_1 c6s14_1 c6s14_2 3.413
Rc6s14_2 c6s14_2 c6s14_3 3.074
Rc6s14_3 c6s14_3 c6s14_4 2.009
Rc6s14_4 c6s14_4 c6s14_5 0.9808
Rc6s14_5 c6s14_5 c6s14_6 3.241
Cc6s14_0 c6s14_0 0 0.1714f
Cc6s14_1 c6s14_1 0 0.399f
Cc6s14_2 c6s14_2 0 0.4325f
Cc6s14_3 c6s14_3 0 0.3388f
Cc6s14_4 c6s14_4 0 0.1993f
Cc6s14_5 c6s14_5 0 0.2815f
Cc6s14_6 c6s14_6 0 0.2161f
CCc6s14_0 c6s14_0 c6s15_0 0.02554f
CCc6s14_2 c6s14_2 c6s15_2 0.1016f
CCc6s14_4 c6s14_4 c6s15_4 0.156f
CCc6s14_6 c6s14_6 c6s15_6 0.06438f
Rc6s15_0 c6s15_0 c6s15_1 4.097
Rc6s15_1 c6s15_1 c6s15_2 1.412
Rc6s15_2 c6s15_2 c6s15_3 1.759
Rc6s15_3 c6s15_3 c6s15_4 0.7928
Rc6s15_4 c6s15_4 c6s15_5 2.395
Rc6s15_5 c6s15_5 c6s15_6 2.659
Cc6s15_0 c6s15_0 0 0.1398f
Cc6s15_1 c6s15_1 0 0.234f
Cc6s15_2 c6s15_2 0 0.2114f
Cc6s15_3 c6s15_3 0 0.1701f
Cc6s15_4 c6s15_4 0 0.2125f
Cc6s15_5 c6s15_5 0 0.337f
Cc6s15_6 c6s15_6 0 0.1773f
CCc6s15_0 c6s15_0 c6s16_0 0.03809f
CCc6s15_2 c6s15_2 c6s16_2 0.02146f
CCc6s15_4 c6s15_4 c6s16_4 0.0538f
CCc6s15_6 c6s15_6 c6s16_6 0.06961f
Rc6s16_0 c6s16_0 c6s16_1 3.819
Rc6s16_1 c6s16_1 c6s16_2 2.694
Rc6s16_2 c6s16_2 c6s16_3 2.089
Rc6s16_3 c6s16_3 c6s16_4 0.5529
Rc6s16_4 c6s16_4 c6s16_5 0.5099
Rc6s16_5 c6s16_5 c6s16_6 1.847
Cc6s16_0 c6s16_0 0 0.1213f
Cc6s16_1 c6s16_1 0 0.3009f
Cc6s16_2 c6s16_2 0 0.3189f
Cc6s16_3 c6s16_3 0 0.1761f
Cc6s16_4 c6s16_4 0 0.07086f
Cc6s16_5 c6s16_5 0 0.1571f
Cc6s16_6 c6s16_6 0 0.1232f
CCc6s16_0 c6s16_0 c6s17_0 0.04359f
CCc6s16_2 c6s16_2 c6s17_2 0.1331f
CCc6s16_4 c6s16_4 c6s17_4 0.1244f
CCc6s16_6 c6s16_6 c6s17_6 0.1326f
Rc6s17_0 c6s17_0 c6s17_1 4.393
Rc6s17_1 c6s17_1 c6s17_2 1.11
Rc6s17_2 c6s17_2 c6s17_3 2.945
Rc6s17_3 c6s17_3 c6s17_4 1.361
Rc6s17_4 c6s17_4 c6s17_5 0.9696
Rc6s17_5 c6s17_5 c6s17_6 0.5725
Cc6s17_0 c6s17_0 0 0.1595f
Cc6s17_1 c6s17_1 0 0.2335f
Cc6s17_2 c6s17_2 0 0.2703f
Cc6s17_3 c6s17_3 0 0.2871f
Cc6s17_4 c6s17_4 0 0.1554f
Cc6s17_5 c6s17_5 0 0.1028f
Cc6s17_6 c6s17_6 0 0.03817f
CCc6s17_0 c6s17_0 c6s18_0 0.07465f
CCc6s17_2 c6s17_2 c6s18_2 0.1537f
CCc6s17_4 c6s17_4 c6s18_4 0.1158f
CCc6s17_6 c6s17_6 c6s18_6 0.1124f
Rc6s18_0 c6s18_0 c6s18_1 3.647
Rc6s18_1 c6s18_1 c6s18_2 1.824
Rc6s18_2 c6s18_2 c6s18_3 3.315
Rc6s18_3 c6s18_3 c6s18_4 3.597
Rc6s18_4 c6s18_4 c6s18_5 1.501
Rc6s18_5 c6s18_5 c6s18_6 2.302
Cc6s18_0 c6s18_0 0 0.1098f
Cc6s18_1 c6s18_1 0 0.2314f
Cc6s18_2 c6s18_2 0 0.3426f
Cc6s18_3 c6s18_3 0 0.4608f
Cc6s18_4 c6s18_4 0 0.3398f
Cc6s18_5 c6s18_5 0 0.2535f
Cc6s18_6 c6s18_6 0 0.1535f
CCc6s18_0 c6s18_0 c6s19_0 0.08817f
CCc6s18_2 c6s18_2 c6s19_2 0.04844f
CCc6s18_4 c6s18_4 c6s19_4 0.09159f
CCc6s18_6 c6s18_6 c6s19_6 0.03245f
Rc6s19_0 c6s19_0 c6s19_1 4.958
Rc6s19_1 c6s19_1 c6s19_2 1.725
Rc6s19_2 c6s19_2 c6s19_3 2.511
Rc6s19_3 c6s19_3 c6s19_4 2.908
Rc6s19_4 c6s19_4 c6s19_5 1.192
Rc6s19_5 c6s19_5 c6s19_6 3.435
Cc6s19_0 c6s19_0 0 0.1972f
Cc6s19_1 c6s19_1 0 0.3122f
Cc6s19_2 c6s19_2 0 0.2824f
Cc6s19_3 c6s19_3 0 0.3613f
Cc6s19_4 c6s19_4 0 0.2733f
Cc6s19_5 c6s19_5 0 0.3085f
Cc6s19_6 c6s19_6 0 0.229f
CCc6s19_0 c6s19_0 c6s20_0 0.1582f
CCc6s19_2 c6s19_2 c6s20_2 0.08795f
CCc6s19_4 c6s19_4 c6s20_4 0.03011f
CCc6s19_6 c6s19_6 c6s20_6 0.1095f
Rc6s20_0 c6s20_0 c6s20_1 4.587
Rc6s20_1 c6s20_1 c6s20_2 1.137
Rc6s20_2 c6s20_2 c6s20_3 2.901
Rc6s20_3 c6s20_3 c6s20_4 1.338
Rc6s20_4 c6s20_4 c6s20_5 1.269
Rc6s20_5 c6s20_5 c6s20_6 0.7187
Cc6s20_0 c6s20_0 0 0.1725f
Cc6s20_1 c6s20_1 0 0.2483f
Cc6s20_2 c6s20_2 0 0.2692f
Cc6s20_3 c6s20_3 0 0.2826f
Cc6s20_4 c6s20_4 0 0.1738f
Cc6s20_5 c6s20_5 0 0.1325f
Cc6s20_6 c6s20_6 0 0.04791f
CCc6s20_0 c6s20_0 c6s21_0 0.1067f
CCc6s20_2 c6s20_2 c6s21_2 0.1258f
CCc6s20_4 c6s20_4 c6s21_4 0.1172f
CCc6s20_6 c6s20_6 c6s21_6 0.06277f
Rc6s21_0 c6s21_0 c6s21_1 3.386
Rc6s21_1 c6s21_1 c6s21_2 0.6198
Rc6s21_2 c6s21_2 c6s21_3 1.003
Rc6s21_3 c6s21_3 c6s21_4 1.251
Rc6s21_4 c6s21_4 c6s21_5 1.108
Rc6s21_5 c6s21_5 c6s21_6 0.5828
Cc6s21_0 c6s21_0 0 0.09243f
Cc6s21_1 c6s21_1 0 0.1338f
Cc6s21_2 c6s21_2 0 0.1082f
Cc6s21_3 c6s21_3 0 0.1503f
Cc6s21_4 c6s21_4 0 0.1573f
Cc6s21_5 c6s21_5 0 0.1127f
Cc6s21_6 c6s21_6 0 0.03885f
CCc6s21_0 c6s21_0 c6s22_0 0.07589f
CCc6s21_2 c6s21_2 c6s22_2 0.02139f
CCc6s21_4 c6s21_4 c6s22_4 0.09046f
CCc6s21_6 c6s21_6 c6s22_6 0.02038f
Rc6s22_0 c6s22_0 c6s22_1 3.652
Rc6s22_1 c6s22_1 c6s22_2 0.7549
Rc6s22_2 c6s22_2 c6s22_3 0.9601
Rc6s22_3 c6s22_3 c6s22_4 2.645
Rc6s22_4 c6s22_4 c6s22_5 0.6788
Rc6s22_5 c6s22_5 c6s22_6 2.908
Cc6s22_0 c6s22_0 0 0.1101f
Cc6s22_1 c6s22_1 0 0.1605f
Cc6s22_2 c6s22_2 0 0.1143f
Cc6s22_3 c6s22_3 0 0.2403f
Cc6s22_4 c6s22_4 0 0.2216f
Cc6s22_5 c6s22_5 0 0.2391f
Cc6s22_6 c6s22_6 0 0.1939f
CCc6s22_0 c6s22_0 c6s23_0 0.1153f
CCc6s22_2 c6s22_2 c6s23_2 0.1097f
CCc6s22_4 c6s22_4 c6s23_4 0.09431f
CCc6s22_6 c6s22_6 c6s23_6 0.1211f
Rc6s23_0 c6s23_0 c6s23_1 3.144
Rc6s23_1 c6s23_1 c6s23_2 1.729
Rc6s23_2 c6s23_2 c6s23_3 0.5063
Rc6s23_3 c6s23_3 c6s23_4 0.4633
Rc6s23_4 c6s23_4 c6s23_5 1.759
Rc6s23_5 c6s23_5 c6s23_6 2.393
Cc6s23_0 c6s23_0 0 0.07627f
Cc6s23_1 c6s23_1 0 0.1916f
Cc6s23_2 c6s23_2 0 0.149f
Cc6s23_3 c6s23_3 0 0.06464f
Cc6s23_4 c6s23_4 0 0.1482f
Cc6s23_5 c6s23_5 0 0.2768f
Cc6s23_6 c6s23_6 0 0.1595f
CCc6s23_0 c6s23_0 c6s24_0 0.1552f
CCc6s23_2 c6s23_2 c6s24_2 0.1374f
CCc6s23_4 c6s23_4 c6s24_4 0.02747f
CCc6s23_6 c6s23_6 c6s24_6 0.1484f
Rc6s24_0 c6s24_0 c6s24_1 3.697
Rc6s24_1 c6s24_1 c6s24_2 1.755
Rc6s24_2 c6s24_2 c6s24_3 0.9514
Rc6s24_3 c6s24_3 c6s24_4 0.7385
Rc6s24_4 c6s24_4 c6s24_5 1.874
Rc6s24_5 c6s24_5 c6s24_6 2.165
Cc6s24_0 c6s24_0 0 0.1131f
Cc6s24_1 c6s24_1 0 0.2301f
Cc6s24_2 c6s24_2 0 0.1805f
Cc6s24_3 c6s24_3 0 0.1127f
Cc6s24_4 c6s24_4 0 0.1741f
Cc6s24_5 c6s24_5 0 0.2692f
Cc6s24_6 c6s24_6 0 0.1443f
CCc6s24_0 c6s24_0 c6s25_0 0.1393f
CCc6s24_2 c6s24_2 c6s25_2 0.113f
CCc6s24_4 c6s24_4 c6s25_4 0.04685f
CCc6s24_6 c6s24_6 c6s25_6 0.1034f
Rc6s25_0 c6s25_0 c6s25_1 5.035
Rc6s25_1 c6s25_1 c6s25_2 1.229
Rc6s25_2 c6s25_2 c6s25_3 1.371
Rc6s25_3 c6s25_3 c6s25_4 1.262
Rc6s25_4 c6s25_4 c6s25_5 3.512
Rc6s25_5 c6s25_5 c6s25_6 0.9134
Cc6s25_0 c6s25_0 0 0.2024f
Cc6s25_1 c6s25_1 0 0.2843f
Cc6s25_2 c6s25_2 0 0.1734f
Cc6s25_3 c6s25_3 0 0.1756f
Cc6s25_4 c6s25_4 0 0.3183f
Cc6s25_5 c6s25_5 0 0.295f
Cc6s25_6 c6s25_6 0 0.0609f
CCc6s25_0 c6s25_0 c6s26_0 0.1085f
CCc6s25_2 c6s25_2 c6s26_2 0.07063f
CCc6s25_4 c6s25_4 c6s26_4 0.1215f
CCc6s25_6 c6s25_6 c6s26_6 0.09004f
Rc6s26_0 c6s26_0 c6s26_1 3.14
Rc6s26_1 c6s26_1 c6s26_2 3.158
Rc6s26_2 c6s26_2 c6s26_3 2.142
Rc6s26_3 c6s26_3 c6s26_4 0.5192
Rc6s26_4 c6s26_4 c6s26_5 1.139
Rc6s26_5 c6s26_5 c6s26_6 0.9815
Cc6s26_0 c6s26_0 0 0.07597f
Cc6s26_1 c6s26_1 0 0.2865f
Cc6s26_2 c6s26_2 0 0.3533f
Cc6s26_3 c6s26_3 0 0.1774f
Cc6s26_4 c6s26_4 0 0.1105f
Cc6s26_5 c6s26_5 0 0.1413f
Cc6s26_6 c6s26_6 0 0.06543f
CCc6s26_0 c6s26_0 c6s27_0 0.06509f
CCc6s26_2 c6s26_2 c6s27_2 0.04279f
CCc6s26_4 c6s26_4 c6s27_4 0.1103f
CCc6s26_6 c6s26_6 c6s27_6 0.1052f
Rc6s27_0 c6s27_0 c6s27_1 3.672
Rc6s27_1 c6s27_1 c6s27_2 1.261
Rc6s27_2 c6s27_2 c6s27_3 2.451
Rc6s27_3 c6s27_3 c6s27_4 1.633
Rc6s27_4 c6s27_4 c6s27_5 2.869
Rc6s27_5 c6s27_5 c6s27_6 3.171
Cc6s27_0 c6s27_0 0 0.1115f
Cc6s27_1 c6s27_1 0 0.1955f
Cc6s27_2 c6s27_2 0 0.2475f
Cc6s27_3 c6s27_3 0 0.2723f
Cc6s27_4 c6s27_4 0 0.3001f
Cc6s27_5 c6s27_5 0 0.4027f
Cc6s27_6 c6s27_6 0 0.2114f
CCc6s27_0 c6s27_0 c6s28_0 0.1207f
CCc6s27_2 c6s27_2 c6s28_2 0.1515f
CCc6s27_4 c6s27_4 c6s28_4 0.06219f
CCc6s27_6 c6s27_6 c6s28_6 0.1392f
Rc6s28_0 c6s28_0 c6s28_1 3.728
Rc6s28_1 c6s28_1 c6s28_2 3.152
Rc6s28_2 c6s28_2 c6s28_3 2.395
Rc6s28_3 c6s28_3 c6s28_4 1.353
Rc6s28_4 c6s28_4 c6s28_5 1.333
Rc6s28_5 c6s28_5 c6s28_6 3.15
Cc6s28_0 c6s28_0 0 0.1152f
Cc6s28_1 c6s28_1 0 0.3254f
Cc6s28_2 c6s28_2 0 0.3698f
Cc6s28_3 c6s28_3 0 0.2498f
Cc6s28_4 c6s28_4 0 0.179f
Cc6s28_5 c6s28_5 0 0.2988f
Cc6s28_6 c6s28_6 0 0.21f
CCc6s28_0 c6s28_0 c6s29_0 0.08766f
CCc6s28_2 c6s28_2 c6s29_2 0.04137f
CCc6s28_4 c6s28_4 c6s29_4 0.1012f
CCc6s28_6 c6s28_6 c6s29_6 0.03981f
Rc6s29_0 c6s29_0 c6s29_1 2.643
Rc6s29_1 c6s29_1 c6s29_2 1.27
Rc6s29_2 c6s29_2 c6s29_3 2.891
Rc6s29_3 c6s29_3 c6s29_4 1.106
Rc6s29_4 c6s29_4 c6s29_5 3.17
Rc6s29_5 c6s29_5 c6s29_6 0.5768
Cc6s29_0 c6s29_0 0 0.04285f
Cc6s29_1 c6s29_1 0 0.1275f
Cc6s29_2 c6s29_2 0 0.2774f
Cc6s29_3 c6s29_3 0 0.2665f
Cc6s29_4 c6s29_4 0 0.285f
Cc6s29_5 c6s29_5 0 0.2498f
Cc6s29_6 c6s29_6 0 0.03845f
CCc6s29_0 c6s29_0 c6s30_0 0.06719f
CCc6s29_2 c6s29_2 c6s30_2 0.0206f
CCc6s29_4 c6s29_4 c6s30_4 0.1163f
CCc6s29_6 c6s29_6 c6s30_6 0.1061f
Rc6s30_0 c6s30_0 c6s30_1 4.921
Rc6s30_1 c6s30_1 c6s30_2 3.019
Rc6s30_2 c6s30_2 c6s30_3 3.31
Rc6s30_3 c6s30_3 c6s30_4 1.784
Rc6s30_4 c6s30_4 c6s30_5 1.605
Rc6s30_5 c6s30_5 c6s30_6 2.367
Cc6s30_0 c6s30_0 0 0.1947f
Cc6s30_1 c6s30_1 0 0.396f
Cc6s30_2 c6s30_2 0 0.4219f
Cc6s30_3 c6s30_3 0 0.3396f
Cc6s30_4 c6s30_4 0 0.226f
Cc6s30_5 c6s30_5 0 0.2648f
Cc6s30_6 c6s30_6 0 0.1578f
CCc6s30_0 c6s30_0 c6s31_0 0.08803f
CCc6s30_2 c6s30_2 c6s31_2 0.0471f
CCc6s30_4 c6s30_4 c6s31_4 0.08056f
CCc6s30_6 c6s30_6 c6s31_6 0.07482f
Rc6s31_0 c6s31_0 c6s31_1 5.25
Rc6s31_1 c6s31_1 c6s31_2 0.7048
Rc6s31_2 c6s31_2 c6s31_3 2.739
Rc6s31_3 c6s31_3 c6s31_4 2.674
Rc6s31_4 c6s31_4 c6s31_5 3.329
Rc6s31_5 c6s31_5 c6s31_6 2.241
Cc6s31_0 c6s31_0 0 0.2167f
Cc6s31_1 c6s31_1 0 0.2637f
Cc6s31_2 c6s31_2 0 0.2296f
Cc6s31_3 c6s31_3 0 0.3609f
Cc6s31_4 c6s31_4 0 0.4002f
Cc6s31_5 c6s31_5 0 0.3713f
Cc6s31_6 c6s31_6 0 0.1494f
CCc6s31_0 c6s31_0 c6s32_0 0.1187f
CCc6s31_2 c6s31_2 c6s32_2 0.03723f
CCc6s31_4 c6s31_4 c6s32_4 0.1423f
CCc6s31_6 c6s31_6 c6s32_6 0.02727f
Rc6s32_0 c6s32_0 c6s32_1 4.365
Rc6s32_1 c6s32_1 c6s32_2 0.805
Rc6s32_2 c6s32_2 c6s32_3 1.172
Rc6s32_3 c6s32_3 c6s32_4 2.616
Rc6s32_4 c6s32_4 c6s32_5 1.659
Rc6s32_5 c6s32_5 c6s32_6 2.611
Cc6s32_0 c6s32_0 0 0.1577f
Cc6s32_1 c6s32_1 0 0.2114f
Cc6s32_2 c6s32_2 0 0.1318f
Cc6s32_3 c6s32_3 0 0.2525f
Cc6s32_4 c6s32_4 0 0.285f
Cc6s32_5 c6s32_5 0 0.2847f
Cc6s32_6 c6s32_6 0 0.1741f
CCc6s32_0 c6s32_0 c6s33_0 0.05081f
CCc6s32_2 c6s32_2 c6s33_2 0.03342f
CCc6s32_4 c6s32_4 c6s33_4 0.06856f
CCc6s32_6 c6s32_6 c6s33_6 0.0908f
Rc6s33_0 c6s33_0 c6s33_1 5.001
Rc6s33_1 c6s33_1 c6s33_2 3.179
Rc6s33_2 c6s33_2 c6s33_3 1.642
Rc6s33_3 c6s33_3 c6s33_4 3.419
Rc6s33_4 c6s33_4 c6s33_5 2.224
Rc6s33_5 c6s33_5 c6s33_6 1.03
Cc6s33_0 c6s33_0 0 0.2001f
Cc6s33_1 c6s33_1 0 0.412f
Cc6s33_2 c6s33_2 0 0.3214f
Cc6s33_3 c6s33_3 0 0.3374f
Cc6s33_4 c6s33_4 0 0.3762f
Cc6s33_5 c6s33_5 0 0.217f
Cc6s33_6 c6s33_6 0 0.06869f
CCc6s33_0 c6s33_0 c6s34_0 0.09051f
CCc6s33_2 c6s33_2 c6s34_2 0.1152f
CCc6s33_4 c6s33_4 c6s34_4 0.1268f
CCc6s33_6 c6s33_6 c6s34_6 0.03673f
Rc6s34_0 c6s34_0 c6s34_1 5.513
Rc6s34_1 c6s34_1 c6s34_2 2.205
Rc6s34_2 c6s34_2 c6s34_3 0.4654
Rc6s34_3 c6s34_3 c6s34_4 1.349
Rc6s34_4 c6s34_4 c6s34_5 3.071
Rc6s34_5 c6s34_5 c6s34_6 0.6214
Cc6s34_0 c6s34_0 0 0.2342f
Cc6s34_1 c6s34_1 0 0.3812f
Cc6s34_2 c6s34_2 0 0.178f
Cc6s34_3 c6s34_3 0 0.121f
Cc6s34_4 c6s34_4 0 0.2947f
Cc6s34_5 c6s34_5 0 0.2462f
Cc6s34_6 c6s34_6 0 0.04143f
CCc6s34_0 c6s34_0 c6s35_0 0.06365f
CCc6s34_2 c6s34_2 c6s35_2 0.115f
CCc6s34_4 c6s34_4 c6s35_4 0.03784f
CCc6s34_6 c6s34_6 c6s35_6 0.1205f
Rc6s35_0 c6s35_0 c6s35_1 4.307
Rc6s35_1 c6s35_1 c6s35_2 1.296
Rc6s35_2 c6s35_2 c6s35_3 3.003
Rc6s35_3 c6s35_3 c6s35_4 0.6798
Rc6s35_4 c6s35_4 c6s35_5 1.059
Rc6s35_5 c6s35_5 c6s35_6 2.858
Cc6s35_0 c6s35_0 0 0.1538f
Cc6s35_1 c6s35_1 0 0.2402f
Cc6s35_2 c6s35_2 0 0.2865f
Cc6s35_3 c6s35_3 0 0.2455f
Cc6s35_4 c6s35_4 0 0.1159f
Cc6s35_5 c6s35_5 0 0.2611f
Cc6s35_6 c6s35_6 0 0.1905f
CCc6s35_0 c6s35_0 c6s36_0 0.1043f
CCc6s35_2 c6s35_2 c6s36_2 0.05032f
CCc6s35_4 c6s35_4 c6s36_4 0.07496f
CCc6s35_6 c6s35_6 c6s36_6 0.1388f
Rc6s36_0 c6s36_0 c6s36_1 2.995
Rc6s36_1 c6s36_1 c6s36_2 0.653
Rc6s36_2 c6s36_2 c6s36_3 2.02
Rc6s36_3 c6s36_3 c6s36_4 1.092
Rc6s36_4 c6s36_4 c6s36_5 2.6
Rc6s36_5 c6s36_5 c6s36_6 1.22
Cc6s36_0 c6s36_0 0 0.06635f
Cc6s36_1 c6s36_1 0 0.1099f
Cc6s36_2 c6s36_2 0 0.1782f
Cc6s36_3 c6s36_3 0 0.2075f
Cc6s36_4 c6s36_4 0 0.2462f
Cc6s36_5 c6s36_5 0 0.2547f
Cc6s36_6 c6s36_6 0 0.08135f
CCc6s36_0 c6s36_0 c6s37_0 0.0465f
CCc6s36_2 c6s36_2 c6s37_2 0.1059f
CCc6s36_4 c6s36_4 c6s37_4 0.1543f
CCc6s36_6 c6s36_6 c6s37_6 0.09677f
Rc6s37_0 c6s37_0 c6s37_1 5.494
Rc6s37_1 c6s37_1 c6s37_2 3.574
Rc6s37_2 c6s37_2 c6s37_3 2.817
Rc6s37_3 c6s37_3 c6s37_4 2.258
Rc6s37_4 c6s37_4 c6s37_5 1.622
Rc6s37_5 c6s37_5 c6s37_6 0.6984
Cc6s37_0 c6s37_0 0 0.2329f
Cc6s37_1 c6s37_1 0 0.4711f
Cc6s37_2 c6s37_2 0 0.4261f
Cc6s37_3 c6s37_3 0 0.3384f
Cc6s37_4 c6s37_4 0 0.2587f
Cc6s37_5 c6s37_5 0 0.1547f
Cc6s37_6 c6s37_6 0 0.04656f
CCc6s37_0 c6s37_0 c6s38_0 0.09396f
CCc6s37_2 c6s37_2 c6s38_2 0.0451f
CCc6s37_4 c6s37_4 c6s38_4 0.09937f
CCc6s37_6 c6s37_6 c6s38_6 0.0807f
Rc6s38_0 c6s38_0 c6s38_1 4.204
Rc6s38_1 c6s38_1 c6s38_2 2.263
Rc6s38_2 c6s38_2 c6s38_3 2.214
Rc6s38_3 c6s38_3 c6s38_4 3.372
Rc6s38_4 c6s38_4 c6s38_5 2.195
Rc6s38_5 c6s38_5 c6s38_6 0.8202
Cc6s38_0 c6s38_0 0 0.1469f
Cc6s38_1 c6s38_1 0 0.2978f
Cc6s38_2 c6s38_2 0 0.2985f
Cc6s38_3 c6s38_3 0 0.3724f
Cc6s38_4 c6s38_4 0 0.3711f
Cc6s38_5 c6s38_5 0 0.201f
Cc6s38_6 c6s38_6 0 0.05468f
CCc6s38_0 c6s38_0 c6s39_0 0.1438f
CCc6s38_2 c6s38_2 c6s39_2 0.1238f
CCc6s38_4 c6s38_4 c6s39_4 0.07148f
CCc6s38_6 c6s38_6 c6s39_6 0.08213f
Rc6s39_0 c6s39_0 c6s39_1 4.221
Rc6s39_1 c6s39_1 c6s39_2 1.684
Rc6s39_2 c6s39_2 c6s39_3 2.559
Rc6s39_3 c6s39_3 c6s39_4 3.594
Rc6s39_4 c6s39_4 c6s39_5 0.6148
Rc6s39_5 c6s39_5 c6s39_6 3.34
Cc6s39_0 c6s39_0 0 0.1481f
Cc6s39_1 c6s39_1 0 0.2603f
Cc6s39_2 c6s39_2 0 0.2829f
Cc6s39_3 c6s39_3 0 0.4102f
Cc6s39_4 c6s39_4 0 0.2806f
Cc6s39_5 c6s39_5 0 0.2637f
Cc6s39_6 c6s39_6 0 0.2227f
CCc6s39_0 c6s39_0 c6s40_0 0.1586f
CCc6s39_2 c6s39_2 c6s40_2 0.1408f
CCc6s39_4 c6s39_4 c6s40_4 0.08487f
CCc6s39_6 c6s39_6 c6s40_6 0.1129f
Rc6s40_0 c6s40_0 c6s40_1 3.92
Rc6s40_1 c6s40_1 c6s40_2 1.626
Rc6s40_2 c6s40_2 c6s40_3 0.9421
Rc6s40_3 c6s40_3 c6s40_4 1.083
Rc6s40_4 c6s40_4 c6s40_5 1.953
Rc6s40_5 c6s40_5 c6s40_6 1.339
Cc6s40_0 c6s40_0 0 0.128f
Cc6s40_1 c6s40_1 0 0.2364f
Cc6s40_2 c6s40_2 0 0.1712f
Cc6s40_3 c6s40_3 0 0.135f
Cc6s40_4 c6s40_4 0 0.2024f
Cc6s40_5 c6s40_5 0 0.2195f
Cc6s40_6 c6s40_6 0 0.08926f
CCc6s40_0 c6s40_0 c6s41_0 0.04913f
CCc6s40_2 c6s40_2 c6s41_2 0.1053f
CCc6s40_4 c6s40_4 c6s41_4 0.05957f
CCc6s40_6 c6s40_6 c6s41_6 0.1365f
Rc6s41_0 c6s41_0 c6s41_1 2.727
Rc6s41_1 c6s41_1 c6s41_2 1.165
Rc6s41_2 c6s41_2 c6s41_3 1.787
Rc6s41_3 c6s41_3 c6s41_4 1.125
Rc6s41_4 c6s41_4 c6s41_5 3.087
Rc6s41_5 c6s41_5 c6s41_6 2
Cc6s41_0 c6s41_0 0 0.0485f
Cc6s41_1 c6s41_1 0 0.1262f
Cc6s41_2 c6s41_2 0 0.1968f
Cc6s41_3 c6s41_3 0 0.1941f
Cc6s41_4 c6s41_4 0 0.2807f
Cc6s41_5 c6s41_5 0 0.3391f
Cc6s41_6 c6s41_6 0 0.1334f
CCc6s41_0 c6s41_0 c6s42_0 0.02864f
CCc6s41_2 c6s41_2 c6s42_2 0.04856f
CCc6s41_4 c6s41_4 c6s42_4 0.1178f
CCc6s41_6 c6s41_6 c6s42_6 0.06326f
Rc6s42_0 c6s42_0 c6s42_1 3.393
Rc6s42_1 c6s42_1 c6s42_2 1.114
Rc6s42_2 c6s42_2 c6s42_3 0.4893
Rc6s42_3 c6s42_3 c6s42_4 2.839
Rc6s42_4 c6s42_4 c6s42_5 1.476
Rc6s42_5 c6s42_5 c6s42_6 1.219
Cc6s42_0 c6s42_0 0 0.09287f
Cc6s42_1 c6s42_1 0 0.1671f
Cc6s42_2 c6s42_2 0 0.1069f
Cc6s42_3 c6s42_3 0 0.2219f
Cc6s42_4 c6s42_4 0 0.2876f
Cc6s42_5 c6s42_5 0 0.1796f
Cc6s42_6 c6s42_6 0 0.08124f
CCc6s42_0 c6s42_0 c6s43_0 0.03474f
CCc6s42_2 c6s42_2 c6s43_2 0.09075f
CCc6s42_4 c6s42_4 c6s43_4 0.1234f
CCc6s42_6 c6s42_6 c6s43_6 0.1526f
Rc6s43_0 c6s43_0 c6s43_1 5.388
Rc6s43_1 c6s43_1 c6s43_2 0.5043
Rc6s43_2 c6s43_2 c6s43_3 2.012
Rc6s43_3 c6s43_3 c6s43_4 1.979
Rc6s43_4 c6s43_4 c6s43_5 2.18
Rc6s43_5 c6s43_5 c6s43_6 1.794
Cc6s43_0 c6s43_0 0 0.2259f
Cc6s43_1 c6s43_1 0 0.2595f
Cc6s43_2 c6s43_2 0 0.1678f
Cc6s43_3 c6s43_3 0 0.2661f
Cc6s43_4 c6s43_4 0 0.2772f
Cc6s43_5 c6s43_5 0 0.2649f
Cc6s43_6 c6s43_6 0 0.1196f
CCc6s43_0 c6s43_0 c6s44_0 0.1499f
CCc6s43_2 c6s43_2 c6s44_2 0.1032f
CCc6s43_4 c6s43_4 c6s44_4 0.08103f
CCc6s43_6 c6s43_6 c6s44_6 0.1548f
Rc6s44_0 c6s44_0 c6s44_1 4.081
Rc6s44_1 c6s44_1 c6s44_2 0.4756
Rc6s44_2 c6s44_2 c6s44_3 2.425
Rc6s44_3 c6s44_3 c6s44_4 3.49
Rc6s44_4 c6s44_4 c6s44_5 2.507
Rc6s44_5 c6s44_5 c6s44_6 1.079
Cc6s44_0 c6s44_0 0 0.1388f
Cc6s44_1 c6s44_1 0 0.1705f
Cc6s44_2 c6s44_2 0 0.1934f
Cc6s44_3 c6s44_3 0 0.3943f
Cc6s44_4 c6s44_4 0 0.3998f
Cc6s44_5 c6s44_5 0 0.2391f
Cc6s44_6 c6s44_6 0 0.07194f
CCc6s44_0 c6s44_0 c6s45_0 0.1374f
CCc6s44_2 c6s44_2 c6s45_2 0.02501f
CCc6s44_4 c6s44_4 c6s45_4 0.1386f
CCc6s44_6 c6s44_6 c6s45_6 0.03888f
Rc6s45_0 c6s45_0 c6s45_1 5.1
Rc6s45_1 c6s45_1 c6s45_2 1.012
Rc6s45_2 c6s45_2 c6s45_3 0.911
Rc6s45_3 c6s45_3 c6s45_4 1.243
Rc6s45_4 c6s45_4 c6s45_5 2.038
Rc6s45_5 c6s45_5 c6s45_6 2.631
Cc6s45_0 c6s45_0 0 0.2066f
Cc6s45_1 c6s45_1 0 0.2741f
Cc6s45_2 c6s45_2 0 0.1282f
Cc6s45_3 c6s45_3 0 0.1436f
Cc6s45_4 c6s45_4 0 0.2187f
Cc6s45_5 c6s45_5 0 0.3112f
Cc6s45_6 c6s45_6 0 0.1754f
CCc6s45_0 c6s45_0 c6s46_0 0.09174f
CCc6s45_2 c6s45_2 c6s46_2 0.02993f
CCc6s45_4 c6s45_4 c6s46_4 0.1526f
CCc6s45_6 c6s45_6 c6s46_6 0.1374f
Rc6s46_0 c6s46_0 c6s46_1 3.605
Rc6s46_1 c6s46_1 c6s46_2 0.5686
Rc6s46_2 c6s46_2 c6s46_3 1.739
Rc6s46_3 c6s46_3 c6s46_4 3.484
Rc6s46_4 c6s46_4 c6s46_5 3.455
Rc6s46_5 c6s46_5 c6s46_6 0.9818
Cc6s46_0 c6s46_0 0 0.107f
Cc6s46_1 c6s46_1 0 0.1449f
Cc6s46_2 c6s46_2 0 0.1539f
Cc6s46_3 c6s46_3 0 0.3482f
Cc6s46_4 c6s46_4 0 0.4626f
Cc6s46_5 c6s46_5 0 0.2958f
Cc6s46_6 c6s46_6 0 0.06546f
CCc6s46_0 c6s46_0 c6s47_0 0.04759f
CCc6s46_2 c6s46_2 c6s47_2 0.1568f
CCc6s46_4 c6s46_4 c6s47_4 0.0674f
CCc6s46_6 c6s46_6 c6s47_6 0.1174f
Rc6s47_0 c6s47_0 c6s47_1 5.376
Rc6s47_1 c6s47_1 c6s47_2 3.051
Rc6s47_2 c6s47_2 c6s47_3 2.984
Rc6s47_3 c6s47_3 c6s47_4 2.38
Rc6s47_4 c6s47_4 c6s47_5 2.994
Rc6s47_5 c6s47_5 c6s47_6 1.191
Cc6s47_0 c6s47_0 0 0.2251f
Cc6s47_1 c6s47_1 0 0.4285f
Cc6s47_2 c6s47_2 0 0.4023f
Cc6s47_3 c6s47_3 0 0.3576f
Cc6s47_4 c6s47_4 0 0.3583f
Cc6s47_5 c6s47_5 0 0.279f
Cc6s47_6 c6s47_6 0 0.0794f
CCc6s47_0 c6s47_0 c6s48_0 0.1466f
CCc6s47_2 c6s47_2 c6s48_2 0.04983f
CCc6s47_4 c6s47_4 c6s48_4 0.03726f
CCc6s47_6 c6s47_6 c6s48_6 0.1278f
Rc6s48_0 c6s48_0 c6s48_1 5.573
Rc6s48_1 c6s48_1 c6s48_2 2.841
Rc6s48_2 c6s48_2 c6s48_3 2.413
Rc6s48_3 c6s48_3 c6s48_4 0.7303
Rc6s48_4 c6s48_4 c6s48_5 2.114
Rc6s48_5 c6s48_5 c6s48_6 1.012
Cc6s48_0 c6s48_0 0 0.2382f
Cc6s48_1 c6s48_1 0 0.4276f
Cc6s48_2 c6s48_2 0 0.3503f
Cc6s48_3 c6s48_3 0 0.2095f
Cc6s48_4 c6s48_4 0 0.1896f
Cc6s48_5 c6s48_5 0 0.2084f
Cc6s48_6 c6s48_6 0 0.06749f
CCc6s48_0 c6s48_0 c6s49_0 0.09571f
Cc6s49_0 c6s49_0 0 0f
CCc6s49_0 c6s49_0 c7s0_0 0.07737f
Rc7s0_0 c7s0_0 c7s0_1 2.892
Rc7s0_1 c7s0_1 c7s0_2 2.164
Rc7s0_2 c7s0_2 c7s0_3 2.943
Rc7s0_3 c7s0_3 c7s0_4 2.702
Rc7s0_4 c7s0_4 c7s0_5 0.8916
Rc7s0_5 c7s0_5 c7s0_6 3.399
Cc7s0_0 c7s0_0 0 0.05946f
Cc7s0_1 c7s0_1 0 0.2037f
Cc7s0_2 c7s0_2 0 0.3404f
Cc7s0_3 c7s0_3 0 0.3763f
Cc7s0_4 c7s0_4 0 0.2395f
Cc7s0_5 c7s0_5 0 0.2861f
Cc7s0_6 c7s0_6 0 0.2266f
CCc7s0_0 c7s0_0 c7s1_0 0.1505f
CCc7s0_2 c7s0_2 c7s1_2 0.07022f
CCc7s0_4 c7s0_4 c7s1_4 0.1569f
CCc7s0_6 c7s0_6 c7s1_6 0.04667f
Rc7s1_0 c7s1_0 c7s1_1 3.711
Rc7s1_1 c7s1_1 c7s1_2 3.099
Rc7s1_2 c7s1_2 c7s1_3 0.7207
Rc7s1_3 c7s1_3 c7s1_4 1.692
Rc7s1_4 c7s1_4 c7s1_5 0.4809
Rc7s1_5 c7s1_5 c7s1_6 1.116
Cc7s1_0 c7s1_0 0 0.1141f
Cc7s1_1 c7s1_1 0 0.3207f
Cc7s1_2 c7s1_2 0 0.2546f
Cc7s1_3 c7s1_3 0 0.1609f
Cc7s1_4 c7s1_4 0 0.1449f
Cc7s1_5 c7s1_5 0 0.1065f
Cc7s1_6 c7s1_6 0 0.07443f
CCc7s1_0 c7s1_0 c7s2_0 0.06985f
CCc7s1_2 c7s1_2 c7s2_2 0.1368f
CCc7s1_4 c7s1_4 c7s2_4 0.1075f
CCc7s1_6 c7s1_6 c7s2_6 0.03328f
Rc7s2_0 c7s2_0 c7s2_1 4.959
Rc7s2_1 c7s2_1 c7s2_2 2.841
Rc7s2_2 c7s2_2 c7s2_3 1.416
Rc7s2_3 c7s2_3 c7s2_4 0.9959
Rc7s2_4 c7s2_4 c7s2_5 2.765
Rc7s2_5 c7s2_5 c7s2_6 3.403
Cc7s2_0 c7s2_0 0 0.1973f
Cc7s2_1 c7s2_1 0 0.3867f
Cc7s2_2 c7s2_2 0 0.2838f
Cc7s2_3 c7s2_3 0 0.1608f
Cc7s2_4 c7s2_4 0 0.2507f
Cc7s2_5 c7s2_5 0 0.4112f
Cc7s2_6 c7s2_6 0 0.2269f
CCc7s2_0 c7s2_0 c7s3_0 0.0507f
CCc7s2_2 c7s2_2 c7s3_2 0.0662f
CCc7s2_4 c7s2_4 c7s3_4 0.06654f
CCc7s2_6 c7s2_6 c7s3_6 0.1554f
Rc7s3_0 c7s3_0 c7s3_1 2.611
Rc7s3_1 c7s3_1 c7s3_2 0.5086
Rc7s3_2 c7s3_2 c7s3_3 1.023
Rc7s3_3 c7s3_3 c7s3_4 1.907
Rc7s3_4 c7s3_4 c7s3_5 3.492
Rc7s3_5 c7s3_5 c7s3_6 0.5657
Cc7s3_0 c7s3_0 0 0.0407f
Cc7s3_1 c7s3_1 0 0.07461f
Cc7s3_2 c7s3_2 0 0.1021f
Cc7s3_3 c7s3_3 0 0.1953f
Cc7s3_4 c7s3_4 0 0.3599f
Cc7s3_5 c7s3_5 0 0.2705f
Cc7s3_6 c7s3_6 0 0.03771f
CCc7s3_0 c7s3_0 c7s4_0 0.1317f
CCc7s3_2 c7s3_2 c7s4_2 0.09356f
CCc7s3_4 c7s3_4 c7s4_4 0.1446f
CCc7s3_6 c7s3_6 c7s4_6 0.1549f
Rc7s4_0 c7s4_0 c7s4_1 4.711
Rc7s4_1 c7s4_1 c7s4_2 1.237
Rc7s4_2 c7s4_2 c7s4_3 3.318
Rc7s4_3 c7s4_3 c7s4_4 0.4874
Rc7s4_4 c7s4_4 c7s4_5 3.562
Rc7s4_5 c7s4_5 c7s4_6 1.752
Cc7s4_0 c7s4_0 0 0.1808f
Cc7s4_1 c7s4_1 0 0.2632f
Cc7s4_2 c7s4_2 0 0.3037f
Cc7s4_3 c7s4_3 0 0.2537f
Cc7s4_4 c7s4_4 0 0.27f
Cc7s4_5 c7s4_5 0 0.3543f
Cc7s4_6 c7s4_6 0 0.1168f
CCc7s4_0 c7s4_0 c7s5_0 0.0578f
CCc7s4_2 c7s4_2 c7s5_2 0.1436f
CCc7s4_4 c7s4_4 c7s5_4 0.08979f
CCc7s4_6 c7s4_6 c7s5_6 0.074f
Rc7s5_0 c7s5_0 c7s5_1 3.412
Rc7s5_1 c7s5_1 c7s5_2 1.771
Rc7s5_2 c7s5_2 c7s5_3 1.232
Rc7s5_3 c7s5_3 c7s5_4 2.082
Rc7s5_4 c7s5_4 c7s5_5 1.823
Rc7s5_5 c7s5_5 c7s5_6 1.282
Cc7s5_0 c7s5_0 0 0.0941f
Cc7s5_1 c7s5_1 0 0.2121f
Cc7s5_2 c7s5_2 0 0.2002f
Cc7s5_3 c7s5_3 0 0.2209f
Cc7s5_4 c7s5_4 0 0.2603f
Cc7s5_5 c7s5_5 0 0.207f
Cc7s5_6 c7s5_6 0 0.08544f
CCc7s5_0 c7s5_0 c7s6_0 0.02082f
CCc7s5_2 c7s5_2 c7s6_2 0.04122f
CCc7s5_4 c7s5_4 c7s6_4 0.1294f
CCc7s5_6 c7s5_6 c7s6_6 0.1192f
Rc7s6_0 c7s6_0 c7s6_1 5.36
Rc7s6_1 c7s6_1 c7s6_2 0.9198
Rc7s6_2 c7s6_2 c7s6_3 3.368
Rc7s6_3 c7s6_3 c7s6_4 3.245
Rc7s6_4 c7s6_4 c7s6_5 1.553
Rc7s6_5 c7s6_5 c7s6_6 3.457
Cc7s6_0 c7s6_0 0 0.224f
Cc7s6_1 c7s6_1 0 0.2853f
Cc7s6_2 c7s6_2 0 0.2859f
Cc7s6_3 c7s6_3 0 0.4409f
Cc7s6_4 c7s6_4 0 0.3198f
Cc7s6_5 c7s6_5 0 0.334f
Cc7s6_6 c7s6_6 0 0.2304f
CCc7s6_0 c7s6_0 c7s7_0 0.1577f
CCc7s6_2 c7s6_2 c7s7_2 0.1384f
CCc7s6_4 c7s6_4 c7s7_4 0.09797f
CCc7s6_6 c7s6_6 c7s7_6 0.1419f
Rc7s7_0 c7s7_0 c7s7_1 2.936
Rc7s7_1 c7s7_1 c7s7_2 0.8682
Rc7s7_2 c7s7_2 c7s7_3 0.8874
Rc7s7_3 c7s7_3 c7s7_4 2.638
Rc7s7_4 c7s7_4 c7s7_5 3.474
Rc7s7_5 c7s7_5 c7s7_6 1.062
Cc7s7_0 c7s7_0 0 0.06241f
Cc7s7_1 c7s7_1 0 0.1203f
Cc7s7_2 c7s7_2 0 0.117f
Cc7s7_3 c7s7_3 0 0.2351f
Cc7s7_4 c7s7_4 0 0.4075f
Cc7s7_5 c7s7_5 0 0.3024f
Cc7s7_6 c7s7_6 0 0.07081f
CCc7s7_0 c7s7_0 c7s8_0 0.03916f
CCc7s7_2 c7s7_2 c7s8_2 0.144f
CCc7s7_4 c7s7_4 c7s8_4 0.1429f
CCc7s7_6 c7s7_6 c7s8_6 0.03781f
Rc7s8_0 c7s8_0 c7s8_1 2.555
Rc7s8_1 c7s8_1 c7s8_2 1.326
Rc7s8_2 c7s8_2 c7s8_3 1.31
Rc7s8_3 c7s8_3 c7s8_4 0.4734
Rc7s8_4 c7s8_4 c7s8_5 0.9079
Rc7s8_5 c7s8_5 c7s8_6 3.081
Cc7s8_0 c7s8_0 0 0.03702f
Cc7s8_1 c7s8_1 0 0.1255f
Cc7s8_2 c7s8_2 0 0.1758f
Cc7s8_3 c7s8_3 0 0.1189f
Cc7s8_4 c7s8_4 0 0.09208f
Cc7s8_5 c7s8_5 0 0.2659f
Cc7s8_6 c7s8_6 0 0.2054f
CCc7s8_0 c7s8_0 c7s9_0 0.02893f
CCc7s8_2 c7s8_2 c7s9_2 0.08387f
CCc7s8_4 c7s8_4 c7s9_4 0.1203f
CCc7s8_6 c7s8_6 c7s9_6 0.12f
Rc7s9_0 c7s9_0 c7s9_1 3.425
Rc7s9_1 c7s9_1 c7s9_2 0.8711
Rc7s9_2 c7s9_2 c7s9_3 1.792
Rc7s9_3 c7s9_3 c7s9_4 1.584
Rc7s9_4 c7s9_4 c7s9_5 1.861
Rc7s9_5 c7s9_5 c7s9_6 1.371
Cc7s9_0 c7s9_0 0 0.09498f
Cc7s9_1 c7s9_1 0 0.153f
Cc7s9_2 c7s9_2 0 0.1775f
Cc7s9_3 c7s9_3 0 0.2251f
Cc7s9_4 c7s9_4 0 0.2297f
Cc7s9_5 c7s9_5 0 0.2155f
Cc7s9_6 c7s9_6 0 0.0914f
CCc7s9_0 c7s9_0 c7s10_0 0.08653f
CCc7s9_2 c7s9_2 c7s10_2 0.1564f
CCc7s9_4 c7s9_4 c7s10_4 0.02112f
CCc7s9_6 c7s9_6 c7s10_6 0.05219f
Rc7s10_0 c7s10_0 c7s10_1 5.125
Rc7s10_1 c7s10_1 c7s10_2 2.023
Rc7s10_2 c7s10_2 c7s10_3 2.919
Rc7s10_3 c7s10_3 c7s10_4 0.6993
Rc7s10_4 c7s10_4 c7s10_5 3.568
Rc7s10_5 c7s10_5 c7s10_6 0.4579
Cc7s10_0 c7s10_0 0 0.2083f
Cc7s10_1 c7s10_1 0 0.3432f
Cc7s10_2 c7s10_2 0 0.3295f
Cc7s10_3 c7s10_3 0 0.2412f
Cc7s10_4 c7s10_4 0 0.2845f
Cc7s10_5 c7s10_5 0 0.2684f
Cc7s10_6 c7s10_6 0 0.03053f
CCc7s10_0 c7s10_0 c7s11_0 0.1301f
CCc7s10_2 c7s10_2 c7s11_2 0.05436f
CCc7s10_4 c7s10_4 c7s11_4 0.1196f
CCc7s10_6 c7s10_6 c7s11_6 0.1327f
Rc7s11_0 c7s11_0 c7s11_1 4.764
Rc7s11_1 c7s11_1 c7s11_2 3.458
Rc7s11_2 c7s11_2 c7s11_3 1.151
Rc7s11_3 c7s11_3 c7s11_4 3.134
Rc7s11_4 c7s11_4 c7s11_5 2.396
Rc7s11_5 c7s11_5 c7s11_6 1.028
Cc7s11_0 c7s11_0 0 0.1842f
Cc7s11_1 c7s11_1 0 0.4148f
Cc7s11_2 c7s11_2 0 0.3072f
Cc7s11_3 c7s11_3 0 0.2857f
Cc7s11_4 c7s11_4 0 0.3687f
Cc7s11_5 c7s11_5 0 0.2282f
Cc7s11_6 c7s11_6 0 0.0685f
CCc7s11_0 c7s11_0 c7s12_0 0.05055f
CCc7s11_2 c7s11_2 c7s12_2 0.03268f
CCc7s11_4 c7s11_4 c7s12_4 0.1464f
CCc7s11_6 c7s11_6 c7s12_6 0.06625f
Rc7s12_0 c7s12_0 c7s12_1 3.543
Rc7s12_1 c7s12_1 c7s12_2 0.8343
Rc7s12_2 c7s12_2 c7s12_3 2.98
Rc7s12_3 c7s12_3 c7s12_4 2.202
Rc7s12_4 c7s12_4 c7s12_5 1.095
Rc7s12_5 c7s12_5 c7s12_6 2.955
Cc7s12_0 c7s12_0 0 0.1029f
Cc7s12_1 c7s12_1 0 0.1585f
Cc7s12_2 c7s12_2 0 0.2543f
Cc7s12_3 c7s12_3 0 0.3455f
Cc7s12_4 c7s12_4 0 0.2198f
Cc7s12_5 c7s12_5 0 0.27f
Cc7s12_6 c7s12_6 0 0.197f
CCc7s12_0 c7s12_0 c7s13_0 0.0951f
CCc7s12_2 c7s12_2 c7s13_2 0.131f
CCc7s12_4 c7s12_4 c7s13_4 0.1188f
CCc7s12_6 c7s12_6 c7s13_6 0.08039f
Rc7s13_0 c7s13_0 c7s13_1 3.573
Rc7s13_1 c7s13_1 c7s13_2 3.262
Rc7s13_2 c7s13_2 c7s13_3 1.02
Rc7s13_3 c7s13_3 c7s13_4 0.7701
Rc7s13_4 c7s13_4 c7s13_5 3.155
Rc7s13_5 c7s13_5 c7s13_6 2.615
Cc7s13_0 c7s13_0 0 0.1048f
Cc7s13_1 c7s13_1 0 0.3223f
Cc7s13_2 c7s13_2 0 0.2855f
Cc7s13_3 c7s13_3 0 0.1194f
Cc7s13_4 c7s13_4 0 0.2617f
Cc7s13_5 c7s13_5 0 0.3847f
Cc7s13_6 c7s13_6 0 0.1744f
CCc7s13_0 c7s13_0 c7s14_0 0.1496f
CCc7s13_2 c7s13_2 c7s14_2 0.1055f
CCc7s13_4 c7s13_4 c7s14_4 0.1599f
CCc7s13_6 c7s13_6 c7s14_6 0.0804f
Rc7s14_0 c7s14_0 c7s14_1 2.65
Rc7s14_1 c7s14_1 c7s14_2 2.548
Rc7s14_2 c7s14_2 c7s14_3 1.243
Rc7s14_3 c7s14_3 c7s14_4 1.685
Rc7s14_4 c7s14_4 c7s14_5 1.61
Rc7s14_5 c7s14_5 c7s14_6 1.478
Cc7s14_0 c7s14_0 0 0.04332f
Cc7s14_1 c7s14_1 0 0.2132f
Cc7s14_2 c7s14_2 0 0.2527f
Cc7s14_3 c7s14_3 0 0.1952f
Cc7s14_4 c7s14_4 0 0.2197f
Cc7s14_5 c7s14_5 0 0.2059f
Cc7s14_6 c7s14_6 0 0.09854f
CCc7s14_0 c7s14_0 c7s15_0 0.09233f
CCc7s14_2 c7s14_2 c7s15_2 0.1038f
CCc7s14_4 c7s14_4 c7s15_4 0.0299f
CCc7s14_6 c7s14_6 c7s15_6 0.1451f
Rc7s15_0 c7s15_0 c7s15_1 3.545
Rc7s15_1 c7s15_1 c7s15_2 2.772
Rc7s15_2 c7s15_2 c7s15_3 1.542
Rc7s15_3 c7s15_3 c7s15_4 0.826
Rc7s15_4 c7s15_4 c7s15_5 1.487
Rc7s15_5 c7s15_5 c7s15_6 1.16
Cc7s15_0 c7s15_0 0 0.103f
Cc7s15_1 c7s15_1 0 0.2878f
Cc7s15_2 c7s15_2 0 0.2876f
Cc7s15_3 c7s15_3 0 0.1579f
Cc7s15_4 c7s15_4 0 0.1542f
Cc7s15_5 c7s15_5 0 0.1765f
Cc7s15_6 c7s15_6 0 0.07731f
CCc7s15_0 c7s15_0 c7s16_0 0.06258f
CCc7s15_2 c7s15_2 c7s16_2 0.1135f
CCc7s15_4 c7s15_4 c7s16_4 0.115f
CCc7s15_6 c7s15_6 c7s16_6 0.04681f
Rc7s16_0 c7s16_0 c7s16_1 4.672
Rc7s16_1 c7s16_1 c7s16_2 2.391
Rc7s16_2 c7s16_2 c7s16_3 0.9613
Rc7s16_3 c7s16_3 c7s16_4 2.277
Rc7s16_4 c7s16_4 c7s16_5 0.6294
Rc7s16_5 c7s16_5 c7s16_6 2.531
Cc7s16_0 c7s16_0 0 0.1781f
Cc7s16_1 c7s16_1 0 0.3375f
Cc7s16_2 c7s16_2 0 0.2235f
Cc7s16_3 c7s16_3 0 0.2159f
Cc7s16_4 c7s16_4 0 0.1938f
Cc7s16_5 c7s16_5 0 0.2107f
Cc7s16_6 c7s16_6 0 0.1687f
CCc7s16_0 c7s16_0 c7s17_0 0.0572f
CCc7s16_2 c7s16_2 c7s17_2 0.1025f
CCc7s16_4 c7s16_4 c7s17_4 0.1513f
CCc7s16_6 c7s16_6 c7s17_6 0.1189f
Rc7s17_0 c7s17_0 c7s17_1 4.208
Rc7s17_1 c7s17_1 c7s17_2 2.245
Rc7s17_2 c7s17_2 c7s17_3 1.231
Rc7s17_3 c7s17_3 c7s17_4 1.926
Rc7s17_4 c7s17_4 c7s17_5 0.6219
Rc7s17_5 c7s17_5 c7s17_6 2.002
Cc7s17_0 c7s17_0 0 0.1472f
Cc7s17_1 c7s17_1 0 0.2969f
Cc7s17_2 c7s17_2 0 0.2317f
Cc7s17_3 c7s17_3 0 0.2104f
Cc7s17_4 c7s17_4 0 0.1699f
Cc7s17_5 c7s17_5 0 0.175f
Cc7s17_6 c7s17_6 0 0.1335f
CCc7s17_0 c7s17_0 c7s18_0 0.1555f
CCc7s17_2 c7s17_2 c7s18_2 0.09043f
CCc7s17_4 c7s17_4 c7s18_4 0.1242f
CCc7s17_6 c7s17_6 c7s18_6 0.1464f
Rc7s18_0 c7s18_0 c7s18_1 4.233
Rc7s18_1 c7s18_1 c7s18_2 0.859
Rc7s18_2 c7s18_2 c7s18_3 3.569
Rc7s18_3 c7s18_3 c7s18_4 2.053
Rc7s18_4 c7s18_4 c7s18_5 1.798
Rc7s18_5 c7s18_5 c7s18_6 0.6474
Cc7s18_0 c7s18_0 0 0.1488f
Cc7s18_1 c7s18_1 0 0.2061f
Cc7s18_2 c7s18_2 0 0.2952f
Cc7s18_3 c7s18_3 0 0.3748f
Cc7s18_4 c7s18_4 0 0.2567f
Cc7s18_5 c7s18_5 0 0.163f
Cc7s18_6 c7s18_6 0 0.04316f
CCc7s18_0 c7s18_0 c7s19_0 0.1213f
CCc7s18_2 c7s18_2 c7s19_2 0.1386f
CCc7s18_4 c7s18_4 c7s19_4 0.09449f
CCc7s18_6 c7s18_6 c7s19_6 0.04592f
Rc7s19_0 c7s19_0 c7s19_1 4.675
Rc7s19_1 c7s19_1 c7s19_2 1.047
Rc7s19_2 c7s19_2 c7s19_3 1.543
Rc7s19_3 c7s19_3 c7s19_4 1.202
Rc7s19_4 c7s19_4 c7s19_5 2.11
Rc7s19_5 c7s19_5 c7s19_6 2.496
Cc7s19_0 c7s19_0 0 0.1783f
Cc7s19_1 c7s19_1 0 0.2481f
Cc7s19_2 c7s19_2 0 0.1727f
Cc7s19_3 c7s19_3 0 0.183f
Cc7s19_4 c7s19_4 0 0.2208f
Cc7s19_5 c7s19_5 0 0.3071f
Cc7s19_6 c7s19_6 0 0.1664f
CCc7s19_0 c7s19_0 c7s20_0 0.09817f
CCc7s19_2 c7s19_2 c7s20_2 0.04313f
CCc7s19_4 c7s19_4 c7s20_4 0.05286f
CCc7s19_6 c7s19_6 c7s20_6 0.05075f
Rc7s20_0 c7s20_0 c7s20_1 4.058
Rc7s20_1 c7s20_1 c7s20_2 3.486
Rc7s20_2 c7s20_2 c7s20_3 2.515
Rc7s20_3 c7s20_3 c7s20_4 3.157
Rc7s20_4 c7s20_4 c7s20_5 0.7343
Rc7s20_5 c7s20_5 c7s20_6 0.5278
Cc7s20_0 c7s20_0 0 0.1372f
Cc7s20_1 c7s20_1 0 0.3696f
Cc7s20_2 c7s20_2 0 0.4001f
Cc7s20_3 c7s20_3 0 0.3782f
Cc7s20_4 c7s20_4 0 0.2594f
Cc7s20_5 c7s20_5 0 0.08414f
Cc7s20_6 c7s20_6 0 0.03519f
CCc7s20_0 c7s20_0 c7s21_0 0.09624f
CCc7s20_2 c7s20_2 c7s21_2 0.05214f
CCc7s20_4 c7s20_4 c7s21_4 0.06656f
CCc7s20_6 c7s20_6 c7s21_6 0.1223f
Rc7s21_0 c7s21_0 c7s21_1 2.745
Rc7s21_1 c7s21_1 c7s21_2 3.217
Rc7s21_2 c7s21_2 c7s21_3 1.75
Rc7s21_3 c7s21_3 c7s21_4 2.321
Rc7s21_4 c7s21_4 c7s21_5 0.5837
Rc7s21_5 c7s21_5 c7s21_6 0.6457
Cc7s21_0 c7s21_0 0 0.04969f
Cc7s21_1 c7s21_1 0 0.2642f
Cc7s21_2 c7s21_2 0 0.3311f
Cc7s21_3 c7s21_3 0 0.2714f
Cc7s21_4 c7s21_4 0 0.1936f
Cc7s21_5 c7s21_5 0 0.08196f
Cc7s21_6 c7s21_6 0 0.04305f
CCc7s21_0 c7s21_0 c7s22_0 0.1143f
CCc7s21_2 c7s21_2 c7s22_2 0.0253f
CCc7s21_4 c7s21_4 c7s22_4 0.1091f
CCc7s21_6 c7s21_6 c7s22_6 0.06359f
Rc7s22_0 c7s22_0 c7s22_1 3.396
Rc7s22_1 c7s22_1 c7s22_2 3.46
Rc7s22_2 c7s22_2 c7s22_3 3.169
Rc7s22_3 c7s22_3 c7s22_4 1.416
Rc7s22_4 c7s22_4 c7s22_5 1.663
Rc7s22_5 c7s22_5 c7s22_6 1.378
Cc7s22_0 c7s22_0 0 0.09305f
Cc7s22_1 c7s22_1 0 0.3237f
Cc7s22_2 c7s22_2 0 0.4419f
Cc7s22_3 c7s22_3 0 0.3057f
Cc7s22_4 c7s22_4 0 0.2053f
Cc7s22_5 c7s22_5 0 0.2027f
Cc7s22_6 c7s22_6 0 0.09188f
CCc7s22_0 c7s22_0 c7s23_0 0.03679f
CCc7s22_2 c7s22_2 c7s23_2 0.1535f
CCc7s22_4 c7s22_4 c7s23_4 0.1111f
CCc7s22_6 c7s22_6 c7s23_6 0.12f
Rc7s23_0 c7s23_0 c7s23_1 3.786
Rc7s23_1 c7s23_1 c7s23_2 1.107
Rc7s23_2 c7s23_2 c7s23_3 2.437
Rc7s23_3 c7s23_3 c7s23_4 1.224
Rc7s23_4 c7s23_4 c7s23_5 3.327
Rc7s23_5 c7s23_5 c7s23_6 3.427
Cc7s23_0 c7s23_0 0 0.119f
Cc7s23_1 c7s23_1 0 0.1928f
Cc7s23_2 c7s23_2 0 0.2363f
Cc7s23_3 c7s23_3 0 0.244f
Cc7s23_4 c7s23_4 0 0.3034f
Cc7s23_5 c7s23_5 0 0.4503f
Cc7s23_6 c7s23_6 0 0.2284f
CCc7s23_0 c7s23_0 c7s24_0 0.1555f
CCc7s23_2 c7s23_2 c7s24_2 0.05008f
CCc7s23_4 c7s23_4 c7s24_4 0.06145f
CCc7s23_6 c7s23_6 c7s24_6 0.1407f
Rc7s24_0 c7s24_0 c7s24_1 3.915
Rc7s24_1 c7s24_1 c7s24_2 2.209
Rc7s24_2 c7s24_2 c7s24_3 2.699
Rc7s24_3 c7s24_3 c7s24_4 1.113
Rc7s24_4 c7s24_4 c7s24_5 1.908
Rc7s24_5 c7s24_5 c7s24_6 0.7131
Cc7s24_0 c7s24_0 0 0.1277f
Cc7s24_1 c7s24_1 0 0.2749f
Cc7s24_2 c7s24_2 0 0.3272f
Cc7s24_3 c7s24_3 0 0.2541f
Cc7s24_4 c7s24_4 0 0.2014f
Cc7s24_5 c7s24_5 0 0.1747f
Cc7s24_6 c7s24_6 0 0.04754f
CCc7s24_0 c7s24_0 c7s25_0 0.02432f
CCc7s24_2 c7s24_2 c7s25_2 0.1556f
CCc7s24_4 c7s24_4 c7s25_4 0.1211f
CCc7s24_6 c7s24_6 c7s25_6 0.1071f
Rc7s25_0 c7s25_0 c7s25_1 3.095
Rc7s25_1 c7s25_1 c7s25_2 1.38
Rc7s25_2 c7s25_2 c7s25_3 3.347
Rc7s25_3 c7s25_3 c7s25_4 3.581
Rc7s25_4 c7s25_4 c7s25_5 2.474
Rc7s25_5 c7s25_5 c7s25_6 3.359
Cc7s25_0 c7s25_0 0 0.07302f
Cc7s25_1 c7s25_1 0 0.165f
Cc7s25_2 c7s25_2 0 0.3151f
Cc7s25_3 c7s25_3 0 0.4618f
Cc7s25_4 c7s25_4 0 0.4037f
Cc7s25_5 c7s25_5 0 0.3889f
Cc7s25_6 c7s25_6 0 0.2239f
CCc7s25_0 c7s25_0 c7s26_0 0.07526f
CCc7s25_2 c7s25_2 c7s26_2 0.1381f
CCc7s25_4 c7s25_4 c7s26_4 0.1219f
CCc7s25_6 c7s25_6 c7s26_6 0.05099f
Rc7s26_0 c7s26_0 c7s26_1 5.353
Rc7s26_1 c7s26_1 c7s26_2 0.4944
Rc7s26_2 c7s26_2 c7s26_3 1.295
Rc7s26_3 c7s26_3 c7s26_4 2.004
Rc7s26_4 c7s26_4 c7s26_5 3.405
Rc7s26_5 c7s26_5 c7s26_6 1.559
Cc7s26_0 c7s26_0 0 0.2236f
Cc7s26_1 c7s26_1 0 0.2565f
Cc7s26_2 c7s26_2 0 0.1193f
Cc7s26_3 c7s26_3 0 0.22f
Cc7s26_4 c7s26_4 0 0.3606f
Cc7s26_5 c7s26_5 0 0.3309f
Cc7s26_6 c7s26_6 0 0.1039f
CCc7s26_0 c7s26_0 c7s27_0 0.03532f
CCc7s26_2 c7s26_2 c7s27_2 0.1212f
CCc7s26_4 c7s26_4 c7s27_4 0.1138f
CCc7s26_6 c7s26_6 c7s27_6 0.03679f
Rc7s27_0 c7s27_0 c7s27_1 4.621
Rc7s27_1 c7s27_1 c7s27_2 1.672
Rc7s27_2 c7s27_2 c7s27_3 1.776
Rc7s27_3 c7s27_3 c7s27_4 3.413
Rc7s27_4 c7s27_4 c7s27_5 3.072
Rc7s27_5 c7s27_5 c7s27_6 3.528
Cc7s27_0 c7s27_0 0 0.1747f
Cc7s27_1 c7s27_1 0 0.2862f
Cc7s27_2 c7s27_2 0 0.2299f
Cc7s27_3 c7s27_3 0 0.346f
Cc7s27_4 c7s27_4 0 0.4323f
Cc7s27_5 c7s27_5 0 0.44f
Cc7s27_6 c7s27_6 0 0.2352f
CCc7s27_0 c7s27_0 c7s28_0 0.1183f
CCc7s27_2 c7s27_2 c7s28_2 0.07411f
CCc7s27_4 c7s27_4 c7s28_4 0.0723f
CCc7s27_6 c7s27_6 c7s28_6 0.03984f
Rc7s28_0 c7s28_0 c7s28_1 2.664
Rc7s28_1 c7s28_1 c7s28_2 2.062
Rc7s28_2 c7s28_2 c7s28_3 0.9532
Rc7s28_3 c7s28_3 c7s28_4 2.284
Rc7s28_4 c7s28_4 c7s28_5 1.118
Rc7s28_5 c7s28_5 c7s28_6 2.034
Cc7s28_0 c7s28_0 0 0.04427f
Cc7s28_1 c7s28_1 0 0.1817f
Cc7s28_2 c7s28_2 0 0.201f
Cc7s28_3 c7s28_3 0 0.2158f
Cc7s28_4 c7s28_4 0 0.2268f
Cc7s28_5 c7s28_5 0 0.2101f
Cc7s28_6 c7s28_6 0 0.1356f
CCc7s28_0 c7s28_0 c7s29_0 0.1457f
CCc7s28_2 c7s28_2 c7s29_2 0.08515f
CCc7s28_4 c7s28_4 c7s29_4 0.1494f
CCc7s28_6 c7s28_6 c7s29_6 0.06213f
Rc7s29_0 c7s29_0 c7s29_1 2.874
Rc7s29_1 c7s29_1 c7s29_2 2.678
Rc7s29_2 c7s29_2 c7s29_3 1.816
Rc7s29_3 c7s29_3 c7s29_4 2.556
Rc7s29_4 c7s29_4 c7s29_5 2.273
Rc7s29_5 c7s29_5 c7s29_6 1.823
Cc7s29_0 c7s29_0 0 0.0583f
Cc7s29_1 c7s29_1 0 0.2368f
Cc7s29_2 c7s29_2 0 0.2996f
Cc7s29_3 c7s29_3 0 0.2915f
Cc7s29_4 c7s29_4 0 0.3219f
Cc7s29_5 c7s29_5 0 0.273f
Cc7s29_6 c7s29_6 0 0.1215f
CCc7s29_0 c7s29_0 c7s30_0 0.07086f
CCc7s29_2 c7s29_2 c7s30_2 0.0505f
CCc7s29_4 c7s29_4 c7s30_4 0.1588f
CCc7s29_6 c7s29_6 c7s30_6 0.04846f
Rc7s30_0 c7s30_0 c7s30_1 3.903
Rc7s30_1 c7s30_1 c7s30_2 3.261
Rc7s30_2 c7s30_2 c7s30_3 3.021
Rc7s30_3 c7s30_3 c7s30_4 3.545
Rc7s30_4 c7s30_4 c7s30_5 2.414
Rc7s30_5 c7s30_5 c7s30_6 1.346
Cc7s30_0 c7s30_0 0 0.1268f
Cc7s30_1 c7s30_1 0 0.3442f
Cc7s30_2 c7s30_2 0 0.4188f
Cc7s30_3 c7s30_3 0 0.4378f
Cc7s30_4 c7s30_4 0 0.3973f
Cc7s30_5 c7s30_5 0 0.2507f
Cc7s30_6 c7s30_6 0 0.08975f
CCc7s30_0 c7s30_0 c7s31_0 0.1415f
CCc7s30_2 c7s30_2 c7s31_2 0.02922f
CCc7s30_4 c7s30_4 c7s31_4 0.1519f
CCc7s30_6 c7s30_6 c7s31_6 0.08268f
Rc7s31_0 c7s31_0 c7s31_1 4.598
Rc7s31_1 c7s31_1 c7s31_2 3.266
Rc7s31_2 c7s31_2 c7s31_3 2.084
Rc7s31_3 c7s31_3 c7s31_4 3.034
Rc7s31_4 c7s31_4 c7s31_5 3.092
Rc7s31_5 c7s31_5 c7s31_6 2.053
Cc7s31_0 c7s31_0 0 0.1732f
Cc7s31_1 c7s31_1 0 0.391f
Cc7s31_2 c7s31_2 0 0.3567f
Cc7s31_3 c7s31_3 0 0.3412f
Cc7s31_4 c7s31_4 0 0.4084f
Cc7s31_5 c7s31_5 0 0.343f
Cc7s31_6 c7s31_6 0 0.1369f
CCc7s31_0 c7s31_0 c7s32_0 0.1476f
CCc7s31_2 c7s31_2 c7s32_2 0.05476f
CCc7s31_4 c7s31_4 c7s32_4 0.04198f
CCc7s31_6 c7s31_6 c7s32_6 0.1191f
Rc7s32_0 c7s32_0 c7s32_1 5.046
Rc7s32_1 c7s32_1 c7s32_2 1.747
Rc7s32_2 c7s32_2 c7s32_3 0.5452
Rc7s32_3 c7s32_3 c7s32_4 1.802
Rc7s32_4 c7s32_4 c7s32_5 1.16
Rc7s32_5 c7s32_5 c7s32_6 0.6765
Cc7s32_0 c7s32_0 0 0.2031f
Cc7s32_1 c7s32_1 0 0.3195f
Cc7s32_2 c7s32_2 0 0.1528f
Cc7s32_3 c7s32_3 0 0.1565f
Cc7s32_4 c7s32_4 0 0.1975f
Cc7s32_5 c7s32_5 0 0.1224f
Cc7s32_6 c7s32_6 0 0.0451f
CCc7s32_0 c7s32_0 c7s33_0 0.04313f
CCc7s32_2 c7s32_2 c7s33_2 0.1043f
CCc7s32_4 c7s32_4 c7s33_4 0.07313f
CCc7s32_6 c7s32_6 c7s33_6 0.1315f
Rc7s33_0 c7s33_0 c7s33_1 3.143
Rc7s33_1 c7s33_1 c7s33_2 2.352
Rc7s33_2 c7s33_2 c7s33_3 1.295
Rc7s33_3 c7s33_3 c7s33_4 1.344
Rc7s33_4 c7s33_4 c7s33_5 0.9219
Rc7s33_5 c7s33_5 c7s33_6 2.787
Cc7s33_0 c7s33_0 0 0.07618f
Cc7s33_1 c7s33_1 0 0.233f
Cc7s33_2 c7s33_2 0 0.2432f
Cc7s33_3 c7s33_3 0 0.176f
Cc7s33_4 c7s33_4 0 0.1511f
Cc7s33_5 c7s33_5 0 0.2473f
Cc7s33_6 c7s33_6 0 0.1858f
CCc7s33_0 c7s33_0 c7s34_0 0.05944f
CCc7s33_2 c7s33_2 c7s34_2 0.1139f
CCc7s33_4 c7s33_4 c7s34_4 0.1164f
CCc7s33_6 c7s33_6 c7s34_6 0.09758f
Rc7s34_0 c7s34_0 c7s34_1 4.536
Rc7s34_1 c7s34_1 c7s34_2 2.598
Rc7s34_2 c7s34_2 c7s34_3 0.7567
Rc7s34_3 c7s34_3 c7s34_4 2.884
Rc7s34_4 c7s34_4 c7s34_5 2.083
Rc7s34_5 c7s34_5 c7s34_6 3.016
Cc7s34_0 c7s34_0 0 0.1691f
Cc7s34_1 c7s34_1 0 0.3422f
Cc7s34_2 c7s34_2 0 0.2236f
Cc7s34_3 c7s34_3 0 0.2427f
Cc7s34_4 c7s34_4 0 0.3311f
Cc7s34_5 c7s34_5 0 0.3399f
Cc7s34_6 c7s34_6 0 0.2011f
CCc7s34_0 c7s34_0 c7s35_0 0.03553f
CCc7s34_2 c7s34_2 c7s35_2 0.02805f
CCc7s34_4 c7s34_4 c7s35_4 0.1105f
CCc7s34_6 c7s34_6 c7s35_6 0.06301f
Rc7s35_0 c7s35_0 c7s35_1 5.553
Rc7s35_1 c7s35_1 c7s35_2 1.415
Rc7s35_2 c7s35_2 c7s35_3 1.871
Rc7s35_3 c7s35_3 c7s35_4 1.534
Rc7s35_4 c7s35_4 c7s35_5 2.21
Rc7s35_5 c7s35_5 c7s35_6 1.12
Cc7s35_0 c7s35_0 0 0.2368f
Cc7s35_1 c7s35_1 0 0.3312f
Cc7s35_2 c7s35_2 0 0.2191f
Cc7s35_3 c7s35_3 0 0.227f
Cc7s35_4 c7s35_4 0 0.2496f
Cc7s35_5 c7s35_5 0 0.222f
Cc7s35_6 c7s35_6 0 0.07465f
CCc7s35_0 c7s35_0 c7s36_0 0.1545f
CCc7s35_2 c7s35_2 c7s36_2 0.05834f
CCc7s35_4 c7s35_4 c7s36_4 0.1487f
CCc7s35_6 c7s35_6 c7s36_6 0.1579f
Rc7s36_0 c7s36_0 c7s36_1 3.515
Rc7s36_1 c7s36_1 c7s36_2 3.023
Rc7s36_2 c7s36_2 c7s36_3 3.274
Rc7s36_3 c7s36_3 c7s36_4 0.5622
Rc7s36_4 c7s36_4 c7s36_5 3.508
Rc7s36_5 c7s36_5 c7s36_6 1.659
Cc7s36_0 c7s36_0 0 0.101f
Cc7s36_1 c7s36_1 0 0.3026f
Cc7s36_2 c7s36_2 0 0.4198f
Cc7s36_3 c7s36_3 0 0.2557f
Cc7s36_4 c7s36_4 0 0.2714f
Cc7s36_5 c7s36_5 0 0.3444f
Cc7s36_6 c7s36_6 0 0.1106f
CCc7s36_0 c7s36_0 c7s37_0 0.06745f
CCc7s36_2 c7s36_2 c7s37_2 0.1325f
CCc7s36_4 c7s36_4 c7s37_4 0.04344f
CCc7s36_6 c7s36_6 c7s37_6 0.02382f
Rc7s37_0 c7s37_0 c7s37_1 5.5
Rc7s37_1 c7s37_1 c7s37_2 0.5055
Rc7s37_2 c7s37_2 c7s37_3 2.459
Rc7s37_3 c7s37_3 c7s37_4 2.242
Rc7s37_4 c7s37_4 c7s37_5 1.774
Rc7s37_5 c7s37_5 c7s37_6 3.052
Cc7s37_0 c7s37_0 0 0.2333f
Cc7s37_1 c7s37_1 0 0.267f
Cc7s37_2 c7s37_2 0 0.1977f
Cc7s37_3 c7s37_3 0 0.3134f
Cc7s37_4 c7s37_4 0 0.2677f
Cc7s37_5 c7s37_5 0 0.3218f
Cc7s37_6 c7s37_6 0 0.2035f
CCc7s37_0 c7s37_0 c7s38_0 0.1343f
CCc7s37_2 c7s37_2 c7s38_2 0.0234f
CCc7s37_4 c7s37_4 c7s38_4 0.1065f
CCc7s37_6 c7s37_6 c7s38_6 0.1402f
Rc7s38_0 c7s38_0 c7s38_1 3.676
Rc7s38_1 c7s38_1 c7s38_2 0.8422
Rc7s38_2 c7s38_2 c7s38_3 2.259
Rc7s38_3 c7s38_3 c7s38_4 0.5019
Rc7s38_4 c7s38_4 c7s38_5 1.659
Rc7s38_5 c7s38_5 c7s38_6 2.023
Cc7s38_0 c7s38_0 0 0.1117f
Cc7s38_1 c7s38_1 0 0.1679f
Cc7s38_2 c7s38_2 0 0.2067f
Cc7s38_3 c7s38_3 0 0.184f
Cc7s38_4 c7s38_4 0 0.144f
Cc7s38_5 c7s38_5 0 0.2454f
Cc7s38_6 c7s38_6 0 0.1349f
CCc7s38_0 c7s38_0 c7s39_0 0.05007f
CCc7s38_2 c7s38_2 c7s39_2 0.102f
CCc7s38_4 c7s38_4 c7s39_4 0.1359f
CCc7s38_6 c7s38_6 c7s39_6 0.08609f
Rc7s39_0 c7s39_0 c7s39_1 4.158
Rc7s39_1 c7s39_1 c7s39_2 1.046
Rc7s39_2 c7s39_2 c7s39_3 0.4764
Rc7s39_3 c7s39_3 c7s39_4 1.936
Rc7s39_4 c7s39_4 c7s39_5 1.239
Rc7s39_5 c7s39_5 c7s39_6 2.439
Cc7s39_0 c7s39_0 0 0.1439f
Cc7s39_1 c7s39_1 0 0.2136f
Cc7s39_2 c7s39_2 0 0.1015f
Cc7s39_3 c7s39_3 0 0.1609f
Cc7s39_4 c7s39_4 0 0.2117f
Cc7s39_5 c7s39_5 0 0.2452f
Cc7s39_6 c7s39_6 0 0.1626f
CCc7s39_0 c7s39_0 c7s40_0 0.03408f
CCc7s39_2 c7s39_2 c7s40_2 0.08335f
CCc7s39_4 c7s39_4 c7s40_4 0.09229f
CCc7s39_6 c7s39_6 c7s40_6 0.1297f
Rc7s40_0 c7s40_0 c7s40_1 2.614
Rc7s40_1 c7s40_1 c7s40_2 3.251
Rc7s40_2 c7s40_2 c7s40_3 0.9348
Rc7s40_3 c7s40_3 c7s40_4 3.343
Rc7s40_4 c7s40_4 c7s40_5 3.007
Rc7s40_5 c7s40_5 c7s40_6 3.254
Cc7s40_0 c7s40_0 0 0.04093f
Cc7s40_1 c7s40_1 0 0.2577f
Cc7s40_2 c7s40_2 0 0.2791f
Cc7s40_3 c7s40_3 0 0.2852f
Cc7s40_4 c7s40_4 0 0.4233f
Cc7s40_5 c7s40_5 0 0.4174f
Cc7s40_6 c7s40_6 0 0.217f
CCc7s40_0 c7s40_0 c7s41_0 0.1496f
CCc7s40_2 c7s40_2 c7s41_2 0.03159f
CCc7s40_4 c7s40_4 c7s41_4 0.07065f
CCc7s40_6 c7s40_6 c7s41_6 0.1029f
Rc7s41_0 c7s41_0 c7s41_1 3.493
Rc7s41_1 c7s41_1 c7s41_2 2.53
Rc7s41_2 c7s41_2 c7s41_3 3.191
Rc7s41_3 c7s41_3 c7s41_4 1.091
Rc7s41_4 c7s41_4 c7s41_5 1.451
Rc7s41_5 c7s41_5 c7s41_6 3.194
Cc7s41_0 c7s41_0 0 0.09956f
Cc7s41_1 c7s41_1 0 0.2682f
Cc7s41_2 c7s41_2 0 0.3814f
Cc7s41_3 c7s41_3 0 0.2855f
Cc7s41_4 c7s41_4 0 0.1694f
Cc7s41_5 c7s41_5 0 0.3097f
Cc7s41_6 c7s41_6 0 0.213f
CCc7s41_0 c7s41_0 c7s42_0 0.06626f
CCc7s41_2 c7s41_2 c7s42_2 0.03142f
CCc7s41_4 c7s41_4 c7s42_4 0.1246f
CCc7s41_6 c7s41_6 c7s42_6 0.06105f
Rc7s42_0 c7s42_0 c7s42_1 4.288
Rc7s42_1 c7s42_1 c7s42_2 0.6573
Rc7s42_2 c7s42_2 c7s42_3 2.23
Rc7s42_3 c7s42_3 c7s42_4 3.014
Rc7s42_4 c7s42_4 c7s42_5 1.85
Rc7s42_5 c7s42_5 c7s42_6 1.597
Cc7s42_0 c7s42_0 0 0.1525f
Cc7s42_1 c7s42_1 0 0.1963f
Cc7s42_2 c7s42_2 0 0.1925f
Cc7s42_3 c7s42_3 0 0.3496f
Cc7s42_4 c7s42_4 0 0.3243f
Cc7s42_5 c7s42_5 0 0.2298f
Cc7s42_6 c7s42_6 0 0.1065f
CCc7s42_0 c7s42_0 c7s43_0 0.1278f
CCc7s42_2 c7s42_2 c7s43_2 0.09352f
CCc7s42_4 c7s42_4 c7s43_4 0.08649f
CCc7s42_6 c7s42_6 c7s43_6 0.04441f
Rc7s43_0 c7s43_0 c7s43_1 4.588
Rc7s43_1 c7s43_1 c7s43_2 3.061
Rc7s43_2 c7s43_2 c7s43_3 0.4511
Rc7s43_3 c7s43_3 c7s43_4 1.422
Rc7s43_4 c7s43_4 c7s43_5 2.503
Rc7s43_5 c7s43_5 c7s43_6 0.9225
Cc7s43_0 c7s43_0 0 0.1726f
Cc7s43_1 c7s43_1 0 0.3766f
Cc7s43_2 c7s43_2 0 0.2342f
Cc7s43_3 c7s43_3 0 0.1249f
Cc7s43_4 c7s43_4 0 0.2616f
Cc7s43_5 c7s43_5 0 0.2283f
Cc7s43_6 c7s43_6 0 0.0615f
CCc7s43_0 c7s43_0 c7s44_0 0.1402f
CCc7s43_2 c7s43_2 c7s44_2 0.03881f
CCc7s43_4 c7s43_4 c7s44_4 0.05415f
CCc7s43_6 c7s43_6 c7s44_6 0.08404f
Rc7s44_0 c7s44_0 c7s44_1 2.885
Rc7s44_1 c7s44_1 c7s44_2 3.303
Rc7s44_2 c7s44_2 c7s44_3 2.045
Rc7s44_3 c7s44_3 c7s44_4 1.677
Rc7s44_4 c7s44_4 c7s44_5 2.374
Rc7s44_5 c7s44_5 c7s44_6 2.804
Cc7s44_0 c7s44_0 0 0.05899f
Cc7s44_1 c7s44_1 0 0.2792f
Cc7s44_2 c7s44_2 0 0.3565f
Cc7s44_3 c7s44_3 0 0.2482f
Cc7s44_4 c7s44_4 0 0.2701f
Cc7s44_5 c7s44_5 0 0.3452f
Cc7s44_6 c7s44_6 0 0.187f
CCc7s44_0 c7s44_0 c7s45_0 0.09619f
CCc7s44_2 c7s44_2 c7s45_2 0.1105f
CCc7s44_4 c7s44_4 c7s45_4 0.1154f
CCc7s44_6 c7s44_6 c7s45_6 0.08106f
Rc7s45_0 c7s45_0 c7s45_1 3.332
Rc7s45_1 c7s45_1 c7s45_2 0.845
Rc7s45_2 c7s45_2 c7s45_3 2.538
Rc7s45_3 c7s45_3 c7s45_4 1.641
Rc7s45_4 c7s45_4 c7s45_5 3.453
Rc7s45_5 c7s45_5 c7s45_6 1.314
Cc7s45_0 c7s45_0 0 0.08883f
Cc7s45_1 c7s45_1 0 0.1452f
Cc7s45_2 c7s45_2 0 0.2255f
Cc7s45_3 c7s45_3 0 0.2786f
Cc7s45_4 c7s45_4 0 0.3396f
Cc7s45_5 c7s45_5 0 0.3178f
Cc7s45_6 c7s45_6 0 0.08761f
CCc7s45_0 c7s45_0 c7s46_0 0.1296f
CCc7s45_2 c7s45_2 c7s46_2 0.08162f
CCc7s45_4 c7s45_4 c7s46_4 0.04172f
CCc7s45_6 c7s45_6 c7s46_6 0.07464f
Rc7s46_0 c7s46_0 c7s46_1 4.427
Rc7s46_1 c7s46_1 c7s46_2 2.571
Rc7s46_2 c7s46_2 c7s46_3 1.545
Rc7s46_3 c7s46_3 c7s46_4 1.162
Rc7s46_4 c7s46_4 c7s46_5 0.9418
Rc7s46_5 c7s46_5 c7s46_6 2.317
Cc7s46_0 c7s46_0 0 0.1618f
Cc7s46_1 c7s46_1 0 0.3332f
Cc7s46_2 c7s46_2 0 0.2744f
Cc7s46_3 c7s46_3 0 0.1804f
Cc7s46_4 c7s46_4 0 0.1402f
Cc7s46_5 c7s46_5 0 0.2173f
Cc7s46_6 c7s46_6 0 0.1545f
CCc7s46_0 c7s46_0 c7s47_0 0.1152f
CCc7s46_2 c7s46_2 c7s47_2 0.1461f
CCc7s46_4 c7s46_4 c7s47_4 0.08856f
CCc7s46_6 c7s46_6 c7s47_6 0.06631f
Rc7s47_0 c7s47_0 c7s47_1 4.966
Rc7s47_1 c7s47_1 c7s47_2 2.451
Rc7s47_2 c7s47_2 c7s47_3 2.734
Rc7s47_3 c7s47_3 c7s47_4 0.6531
Rc7s47_4 c7s47_4 c7s47_5 3.043
Rc7s47_5 c7s47_5 c7s47_6 1.689
Cc7s47_0 c7s47_0 0 0.1977f
Cc7s47_1 c7s47_1 0 0.3611f
Cc7s47_2 c7s47_2 0 0.3457f
Cc7s47_3 c7s47_3 0 0.2258f
Cc7s47_4 c7s47_4 0 0.2464f
Cc7s47_5 c7s47_5 0 0.3155f
Cc7s47_6 c7s47_6 0 0.1126f
CCc7s47_0 c7s47_0 c7s48_0 0.1139f
CCc7s47_2 c7s47_2 c7s48_2 0.03024f
CCc7s47_4 c7s47_4 c7s48_4 0.02003f
CCc7s47_6 c7s47_6 c7s48_6 0.02421f
Rc7s48_0 c7s48_0 c7s48_1 2.686
Rc7s48_1 c7s48_1 c7s48_2 0.7251
Rc7s48_2 c7s48_2 c7s48_3 3.163
Rc7s48_3 c7s48_3 c7s48_4 2.177
Rc7s48_4 c7s48_4 c7s48_5 0.6437
Rc7s48_5 c7s48_5 c7s48_6 3.596
Cc7s48_0 c7s48_0 0 0.04576f
Cc7s48_1 c7s48_1 0 0.0941f
Cc7s48_2 c7s48_2 0 0.2592f
Cc7s48_3 c7s48_3 0 0.356f
Cc7s48_4 c7s48_4 0 0.1881f
Cc7s48_5 c7s48_5 0 0.2827f
Cc7s48_6 c7s48_6 0 0.2398f
CCc7s48_0 c7s48_0 c7s49_0 0.0803f
Cc7s49_0 c7s49_0 0 0f
CCc7s49_0 c7s49_0 c8s0_0 0.1155f
Rc8s0_0 c8s0_0 c8s0_1 4.536
Rc8s0_1 c8s0_1 c8s0_2 1.57
Rc8s0_2 c8s0_2 c8s0_3 3.051
Rc8s0_3 c8s0_3 c8s0_4 3.496
Rc8s0_4 c8s0_4 c8s0_5 1.741
Rc8s0_5 c8s0_5 c8s0_6 1.566
Cc8s0_0 c8s0_0 0 0.1691f
Cc8s0_1 c8s0_1 0 0.2737f
Cc8s0_2 c8s0_2 0 0.308f
Cc8s0_3 c8s0_3 0 0.4365f
Cc8s0_4 c8s0_4 0 0.3491f
Cc8s0_5 c8s0_5 0 0.2205f
Cc8s0_6 c8s0_6 0 0.1044f
CCc8s0_0 c8s0_0 c8s1_0 0.07918f
CCc8s0_2 c8s0_2 c8s1_2 0.1364f
CCc8s0_4 c8s0_4 c8s1_4 0.0903f
CCc8s0_6 c8s0_6 c8s1_6 0.03422f
Rc8s1_0 c8s1_0 c8s1_1 2.482
Rc8s1_1 c8s1_1 c8s1_2 2.532
Rc8s1_2 c8s1_2 c8s1_3 0.9169
Rc8s1_3 c8s1_3 c8s1_4 2.865
Rc8s1_4 c8s1_4 c8s1_5 2.339
Rc8s1_5 c8s1_5 c8s1_6 1.115
Cc8s1_0 c8s1_0 0 0.03216f
Cc8s1_1 c8s1_1 0 0.201f
Cc8s1_2 c8s1_2 0 0.23f
Cc8s1_3 c8s1_3 0 0.2521f
Cc8s1_4 c8s1_4 0 0.347f
Cc8s1_5 c8s1_5 0 0.2303f
Cc8s1_6 c8s1_6 0 0.07433f
CCc8s1_0 c8s1_0 c8s2_0 0.02954f
CCc8s1_2 c8s1_2 c8s2_2 0.1138f
CCc8s1_4 c8s1_4 c8s2_4 0.04243f
CCc8s1_6 c8s1_6 c8s2_6 0.1573f
Rc8s2_0 c8s2_0 c8s2_1 4.068
Rc8s2_1 c8s2_1 c8s2_2 1.48
Rc8s2_2 c8s2_2 c8s2_3 2.983
Rc8s2_3 c8s2_3 c8s2_4 2.396
Rc8s2_4 c8s2_4 c8s2_5 2.525
Rc8s2_5 c8s2_5 c8s2_6 2.935
Cc8s2_0 c8s2_0 0 0.1379f
Cc8s2_1 c8s2_1 0 0.2366f
Cc8s2_2 c8s2_2 0 0.2976f
Cc8s2_3 c8s2_3 0 0.3586f
Cc8s2_4 c8s2_4 0 0.328f
Cc8s2_5 c8s2_5 0 0.364f
Cc8s2_6 c8s2_6 0 0.1957f
CCc8s2_0 c8s2_0 c8s3_0 0.08333f
CCc8s2_2 c8s2_2 c8s3_2 0.02614f
CCc8s2_4 c8s2_4 c8s3_4 0.04231f
CCc8s2_6 c8s2_6 c8s3_6 0.1588f
Rc8s3_0 c8s3_0 c8s3_1 4.415
Rc8s3_1 c8s3_1 c8s3_2 0.525
Rc8s3_2 c8s3_2 c8s3_3 0.916
Rc8s3_3 c8s3_3 c8s3_4 0.786
Rc8s3_4 c8s3_4 c8s3_5 1.258
Rc8s3_5 c8s3_5 c8s3_6 2.511
Cc8s3_0 c8s3_0 0 0.161f
Cc8s3_1 c8s3_1 0 0.196f
Cc8s3_2 c8s3_2 0 0.09607f
Cc8s3_3 c8s3_3 0 0.1135f
Cc8s3_4 c8s3_4 0 0.1363f
Cc8s3_5 c8s3_5 0 0.2512f
Cc8s3_6 c8s3_6 0 0.1674f
CCc8s3_0 c8s3_0 c8s4_0 0.1498f
CCc8s3_2 c8s3_2 c8s4_2 0.1f
CCc8s3_4 c8s3_4 c8s4_4 0.08987f
CCc8s3_6 c8s3_6 c8s4_6 0.1491f
Rc8s4_0 c8s4_0 c8s4_1 2.862
Rc8s4_1 c8s4_1 c8s4_2 3.281
Rc8s4_2 c8s4_2 c8s4_3 2.475
Rc8s4_3 c8s4_3 c8s4_4 1.193
Rc8s4_4 c8s4_4 c8s4_5 2.868
Rc8s4_5 c8s4_5 c8s4_6 1.001
Cc8s4_0 c8s4_0 0 0.05749f
Cc8s4_1 c8s4_1 0 0.2762f
Cc8s4_2 c8s4_2 0 0.3837f
Cc8s4_3 c8s4_3 0 0.2445f
Cc8s4_4 c8s4_4 0 0.2708f
Cc8s4_5 c8s4_5 0 0.258f
Cc8s4_6 c8s4_6 0 0.06673f
CCc8s4_0 c8s4_0 c8s5_0 0.1029f
CCc8s4_2 c8s4_2 c8s5_2 0.08442f
CCc8s4_4 c8s4_4 c8s5_4 0.03504f
CCc8s4_6 c8s4_6 c8s5_6 0.1512f
Rc8s5_0 c8s5_0 c8s5_1 3.066
Rc8s5_1 c8s5_1 c8s5_2 1.602
Rc8s5_2 c8s5_2 c8s5_3 2.456
Rc8s5_3 c8s5_3 c8s5_4 1.301
Rc8s5_4 c8s5_4 c8s5_5 0.7484
Rc8s5_5 c8s5_5 c8s5_6 1.396
Cc8s5_0 c8s5_0 0 0.07107f
Cc8s5_1 c8s5_1 0 0.1778f
Cc8s5_2 c8s5_2 0 0.2705f
Cc8s5_3 c8s5_3 0 0.2505f
Cc8s5_4 c8s5_4 0 0.1366f
Cc8s5_5 c8s5_5 0 0.143f
Cc8s5_6 c8s5_6 0 0.09307f
CCc8s5_0 c8s5_0 c8s6_0 0.07275f
CCc8s5_2 c8s5_2 c8s6_2 0.133f
CCc8s5_4 c8s5_4 c8s6_4 0.09631f
CCc8s5_6 c8s5_6 c8s6_6 0.1491f
Rc8s6_0 c8s6_0 c8s6_1 2.889
Rc8s6_1 c8s6_1 c8s6_2 3.055
Rc8s6_2 c8s6_2 c8s6_3 3.555
Rc8s6_3 c8s6_3 c8s6_4 3.547
Rc8s6_4 c8s6_4 c8s6_5 1.393
Rc8s6_5 c8s6_5 c8s6_6 0.7664
Cc8s6_0 c8s6_0 0 0.05926f
Cc8s6_1 c8s6_1 0 0.2629f
Cc8s6_2 c8s6_2 0 0.4407f
Cc8s6_3 c8s6_3 0 0.4735f
Cc8s6_4 c8s6_4 0 0.3293f
Cc8s6_5 c8s6_5 0 0.144f
Cc8s6_6 c8s6_6 0 0.05109f
CCc8s6_0 c8s6_0 c8s7_0 0.127f
CCc8s6_2 c8s6_2 c8s7_2 0.08161f
CCc8s6_4 c8s6_4 c8s7_4 0.1096f
CCc8s6_6 c8s6_6 c8s7_6 0.03369f
Rc8s7_0 c8s7_0 c8s7_1 5.487
Rc8s7_1 c8s7_1 c8s7_2 1.695
Rc8s7_2 c8s7_2 c8s7_3 3.491
Rc8s7_3 c8s7_3 c8s7_4 0.4742
Rc8s7_4 c8s7_4 c8s7_5 1.376
Rc8s7_5 c8s7_5 c8s7_6 1.928
Cc8s7_0 c8s7_0 0 0.2325f
Cc8s7_1 c8s7_1 0 0.3455f
Cc8s7_2 c8s7_2 0 0.3458f
Cc8s7_3 c8s7_3 0 0.2644f
Cc8s7_4 c8s7_4 0 0.1233f
Cc8s7_5 c8s7_5 0 0.2203f
Cc8s7_6 c8s7_6 0 0.1286f
CCc8s7_0 c8s7_0 c8s8_0 0.07167f
CCc8s7_2 c8s7_2 c8s8_2 0.0493f
CCc8s7_4 c8s7_4 c8s8_4 0.1572f
CCc8s7_6 c8s7_6 c8s8_6 0.09674f
Rc8s8_0 c8s8_0 c8s8_1 5.401
Rc8s8_1 c8s8_1 c8s8_2 2.085
Rc8s8_2 c8s8_2 c8s8_3 2.927
Rc8s8_3 c8s8_3 c8s8_4 2.472
Rc8s8_4 c8s8_4 c8s8_5 0.884
Rc8s8_5 c8s8_5 c8s8_6 2.65
Cc8s8_0 c8s8_0 0 0.2267f
Cc8s8_1 c8s8_1 0 0.3657f
Cc8s8_2 c8s8_2 0 0.3341f
Cc8s8_3 c8s8_3 0 0.3599f
Cc8s8_4 c8s8_4 0 0.2237f
Cc8s8_5 c8s8_5 0 0.2356f
Cc8s8_6 c8s8_6 0 0.1766f
CCc8s8_0 c8s8_0 c8s9_0 0.1247f
CCc8s8_2 c8s8_2 c8s9_2 0.1204f
CCc8s8_4 c8s8_4 c8s9_4 0.08879f
CCc8s8_6 c8s8_6 c8s9_6 0.02681f
Rc8s9_0 c8s9_0 c8s9_1 5.065
Rc8s9_1 c8s9_1 c8s9_2 3.501
Rc8s9_2 c8s9_2 c8s9_3 0.6602
Rc8s9_3 c8s9_3 c8s9_4 0.5842
Rc8s9_4 c8s9_4 c8s9_5 1.811
Rc8s9_5 c8s9_5 c8s9_6 2.771
Cc8s9_0 c8s9_0 0 0.2043f
Cc8s9_1 c8s9_1 0 0.4377f
Cc8s9_2 c8s9_2 0 0.2774f
Cc8s9_3 c8s9_3 0 0.08296f
Cc8s9_4 c8s9_4 0 0.1597f
Cc8s9_5 c8s9_5 0 0.3055f
Cc8s9_6 c8s9_6 0 0.1848f
CCc8s9_0 c8s9_0 c8s10_0 0.08291f
CCc8s9_2 c8s9_2 c8s10_2 0.1346f
CCc8s9_4 c8s9_4 c8s10_4 0.1432f
CCc8s9_6 c8s9_6 c8s10_6 0.1034f
Rc8s10_0 c8s10_0 c8s10_1 4.391
Rc8s10_1 c8s10_1 c8s10_2 2.479
Rc8s10_2 c8s10_2 c8s10_3 1.619
Rc8s10_3 c8s10_3 c8s10_4 1.091
Rc8s10_4 c8s10_4 c8s10_5 3.318
Rc8s10_5 c8s10_5 c8s10_6 1.268
Cc8s10_0 c8s10_0 0 0.1594f
Cc8s10_1 c8s10_1 0 0.3247f
Cc8s10_2 c8s10_2 0 0.2732f
Cc8s10_3 c8s10_3 0 0.1807f
Cc8s10_4 c8s10_4 0 0.2939f
Cc8s10_5 c8s10_5 0 0.3057f
Cc8s10_6 c8s10_6 0 0.0845f
CCc8s10_0 c8s10_0 c8s11_0 0.1357f
CCc8s10_2 c8s10_2 c8s11_2 0.09253f
CCc8s10_4 c8s10_4 c8s11_4 0.1235f
CCc8s10_6 c8s10_6 c8s11_6 0.1302f
Rc8s11_0 c8s11_0 c8s11_1 5.232
Rc8s11_1 c8s11_1 c8s11_2 3.091
Rc8s11_2 c8s11_2 c8s11_3 1.482
Rc8s11_3 c8s11_3 c8s11_4 3.078
Rc8s11_4 c8s11_4 c8s11_5 3.188
Rc8s11_5 c8s11_5 c8s11_6 2.472
Cc8s11_0 c8s11_0 0 0.2155f
Cc8s11_1 c8s11_1 0 0.4215f
Cc8s11_2 c8s11_2 0 0.3048f
Cc8s11_3 c8s11_3 0 0.304f
Cc8s11_4 c8s11_4 0 0.4177f
Cc8s11_5 c8s11_5 0 0.3773f
Cc8s11_6 c8s11_6 0 0.1648f
CCc8s11_0 c8s11_0 c8s12_0 0.04779f
CCc8s11_2 c8s11_2 c8s12_2 0.1579f
CCc8s11_4 c8s11_4 c8s12_4 0.1318f
CCc8s11_6 c8s11_6 c8s12_6 0.07379f
Rc8s12_0 c8s12_0 c8s12_1 3.404
Rc8s12_1 c8s12_1 c8s12_2 3.016
Rc8s12_2 c8s12_2 c8s12_3 2.528
Rc8s12_3 c8s12_3 c8s12_4 1.629
Rc8s12_4 c8s12_4 c8s12_5 3.307
Rc8s12_5 c8s12_5 c8s12_6 3.568
Cc8s12_0 c8s12_0 0 0.09363f
Cc8s12_1 c8s12_1 0 0.2947f
Cc8s12_2 c8s12_2 0 0.3696f
Cc8s12_3 c8s12_3 0 0.2772f
Cc8s12_4 c8s12_4 0 0.3291f
Cc8s12_5 c8s12_5 0 0.4583f
Cc8s12_6 c8s12_6 0 0.2379f
CCc8s12_0 c8s12_0 c8s13_0 0.115f
CCc8s12_2 c8s12_2 c8s13_2 0.1364f
CCc8s12_4 c8s12_4 c8s13_4 0.1035f
CCc8s12_6 c8s12_6 c8s13_6 0.06269f
Rc8s13_0 c8s13_0 c8s13_1 4.965
Rc8s13_1 c8s13_1 c8s13_2 2.656
Rc8s13_2 c8s13_2 c8s13_3 3.225
Rc8s13_3 c8s13_3 c8s13_4 1.546
Rc8s13_4 c8s13_4 c8s13_5 3.407
Rc8s13_5 c8s13_5 c8s13_6 2.639
Cc8s13_0 c8s13_0 0 0.1977f
Cc8s13_1 c8s13_1 0 0.3747f
Cc8s13_2 c8s13_2 0 0.3921f
Cc8s13_3 c8s13_3 0 0.3181f
Cc8s13_4 c8s13_4 0 0.3302f
Cc8s13_5 c8s13_5 0 0.403f
Cc8s13_6 c8s13_6 0 0.1759f
CCc8s13_0 c8s13_0 c8s14_0 0.1251f
CCc8s13_2 c8s13_2 c8s14_2 0.1379f
CCc8s13_4 c8s13_4 c8s14_4 0.08372f
CCc8s13_6 c8s13_6 c8s14_6 0.1375f
Rc8s14_0 c8s14_0 c8s14_1 5.257
Rc8s14_1 c8s14_1 c8s14_2 3.508
Rc8s14_2 c8s14_2 c8s14_3 2.338
Rc8s14_3 c8s14_3 c8s14_4 0.6444
Rc8s14_4 c8s14_4 c8s14_5 1.21
Rc8s14_5 c8s14_5 c8s14_6 1.071
Cc8s14_0 c8s14_0 0 0.2171f
Cc8s14_1 c8s14_1 0 0.451f
Cc8s14_2 c8s14_2 0 0.3898f
Cc8s14_3 c8s14_3 0 0.1988f
Cc8s14_4 c8s14_4 0 0.1237f
Cc8s14_5 c8s14_5 0 0.1521f
Cc8s14_6 c8s14_6 0 0.07143f
CCc8s14_0 c8s14_0 c8s15_0 0.03968f
CCc8s14_2 c8s14_2 c8s15_2 0.07301f
CCc8s14_4 c8s14_4 c8s15_4 0.1023f
CCc8s14_6 c8s14_6 c8s15_6 0.1586f
Rc8s15_0 c8s15_0 c8s15_1 2.709
Rc8s15_1 c8s15_1 c8s15_2 3.465
Rc8s15_2 c8s15_2 c8s15_3 2.173
Rc8s15_3 c8s15_3 c8s15_4 2.973
Rc8s15_4 c8s15_4 c8s15_5 3.058
Rc8s15_5 c8s15_5 c8s15_6 1.564
Cc8s15_0 c8s15_0 0 0.04728f
Cc8s15_1 c8s15_1 0 0.2783f
Cc8s15_2 c8s15_2 0 0.3759f
Cc8s15_3 c8s15_3 0 0.3431f
Cc8s15_4 c8s15_4 0 0.4021f
Cc8s15_5 c8s15_5 0 0.3081f
Cc8s15_6 c8s15_6 0 0.1043f
CCc8s15_0 c8s15_0 c8s16_0 0.1184f
CCc8s15_2 c8s15_2 c8s16_2 0.1242f
CCc8s15_4 c8s15_4 c8s16_4 0.06606f
CCc8s15_6 c8s15_6 c8s16_6 0.1494f
Rc8s16_0 c8s16_0 c8s16_1 5.228
Rc8s16_1 c8s16_1 c8s16_2 0.4846
Rc8s16_2 c8s16_2 c8s16_3 3.142
Rc8s16_3 c8s16_3 c8s16_4 1.669
Rc8s16_4 c8s16_4 c8s16_5 3.466
Rc8s16_5 c8s16_5 c8s16_6 0.6341
Cc8s16_0 c8s16_0 0 0.2152f
Cc8s16_1 c8s16_1 0 0.2475f
Cc8s16_2 c8s16_2 0 0.2418f
Cc8s16_3 c8s16_3 0 0.3207f
Cc8s16_4 c8s16_4 0 0.3423f
Cc8s16_5 c8s16_5 0 0.2733f
Cc8s16_6 c8s16_6 0 0.04228f
CCc8s16_0 c8s16_0 c8s17_0 0.138f
CCc8s16_2 c8s16_2 c8s17_2 0.09162f
CCc8s16_4 c8s16_4 c8s17_4 0.0587f
CCc8s16_6 c8s16_6 c8s17_6 0.08883f
Rc8s17_0 c8s17_0 c8s17_1 5.078
Rc8s17_1 c8s17_1 c8s17_2 1.799
Rc8s17_2 c8s17_2 c8s17_3 1.885
Rc8s17_3 c8s17_3 c8s17_4 3.235
Rc8s17_4 c8s17_4 c8s17_5 3.098
Rc8s17_5 c8s17_5 c8s17_6 1.144
Cc8s17_0 c8s17_0 0 0.2052f
Cc8s17_1 c8s17_1 0 0.3251f
Cc8s17_2 c8s17_2 0 0.2456f
Cc8s17_3 c8s17_3 0 0.3413f
Cc8s17_4 c8s17_4 0 0.4222f
Cc8s17_5 c8s17_5 0 0.2828f
Cc8s17_6 c8s17_6 0 0.07624f
CCc8s17_0 c8s17_0 c8s18_0 0.09161f
CCc8s17_2 c8s17_2 c8s18_2 0.07613f
CCc8s17_4 c8s17_4 c8s18_4 0.04686f
CCc8s17_6 c8s17_6 c8s18_6 0.0482f
Rc8s18_0 c8s18_0 c8s18_1 2.802
Rc8s18_1 c8s18_1 c8s18_2 0.9768
Rc8s18_2 c8s18_2 c8s18_3 1.778
Rc8s18_3 c8s18_3 c8s18_4 1.247
Rc8s18_4 c8s18_4 c8s18_5 2.734
Rc8s18_5 c8s18_5 c8s18_6 0.7423
Cc8s18_0 c8s18_0 0 0.05348f
Cc8s18_1 c8s18_1 0 0.1186f
Cc8s18_2 c8s18_2 0 0.1837f
Cc8s18_3 c8s18_3 0 0.2017f
Cc8s18_4 c8s18_4 0 0.2654f
Cc8s18_5 c8s18_5 0 0.2318f
Cc8s18_6 c8s18_6 0 0.04949f
CCc8s18_0 c8s18_0 c8s19_0 0.05356f
CCc8s18_2 c8s18_2 c8s19_2 0.1546f
CCc8s18_4 c8s18_4 c8s19_4 0.09988f
CCc8s18_6 c8s18_6 c8s19_6 0.04575f
Rc8s19_0 c8s19_0 c8s19_1 5.037
Rc8s19_1 c8s19_1 c8s19_2 0.5033
Rc8s19_2 c8s19_2 c8s19_3 1.412
Rc8s19_3 c8s19_3 c8s19_4 0.8864
Rc8s19_4 c8s19_4 c8s19_5 1.746
Rc8s19_5 c8s19_5 c8s19_6 1.921
Cc8s19_0 c8s19_0 0 0.2025f
Cc8s19_1 c8s19_1 0 0.236f
Cc8s19_2 c8s19_2 0 0.1277f
Cc8s19_3 c8s19_3 0 0.1532f
Cc8s19_4 c8s19_4 0 0.1755f
Cc8s19_5 c8s19_5 0 0.2445f
Cc8s19_6 c8s19_6 0 0.1281f
CCc8s19_0 c8s19_0 c8s20_0 0.1483f
CCc8s19_2 c8s19_2 c8s20_2 0.08938f
CCc8s19_4 c8s19_4 c8s20_4 0.1459f
CCc8s19_6 c8s19_6 c8s20_6 0.1541f
Rc8s20_0 c8s20_0 c8s20_1 2.591
Rc8s20_1 c8s20_1 c8s20_2 0.7839
Rc8s20_2 c8s20_2 c8s20_3 3.003
Rc8s20_3 c8s20_3 c8s20_4 1.376
Rc8s20_4 c8s20_4 c8s20_5 1.91
Rc8s20_5 c8s20_5 c8s20_6 2.513
Cc8s20_0 c8s20_0 0 0.03939f
Cc8s20_1 c8s20_1 0 0.09165f
Cc8s20_2 c8s20_2 0 0.2525f
Cc8s20_3 c8s20_3 0 0.292f
Cc8s20_4 c8s20_4 0 0.2191f
Cc8s20_5 c8s20_5 0 0.2948f
Cc8s20_6 c8s20_6 0 0.1675f
CCc8s20_0 c8s20_0 c8s21_0 0.07982f
CCc8s20_2 c8s20_2 c8s21_2 0.1413f
CCc8s20_4 c8s20_4 c8s21_4 0.02373f
CCc8s20_6 c8s20_6 c8s21_6 0.05675f
Rc8s21_0 c8s21_0 c8s21_1 2.645
Rc8s21_1 c8s21_1 c8s21_2 1.267
Rc8s21_2 c8s21_2 c8s21_3 3.556
Rc8s21_3 c8s21_3 c8s21_4 0.5404
Rc8s21_4 c8s21_4 c8s21_5 2.163
Rc8s21_5 c8s21_5 c8s21_6 1.138
Cc8s21_0 c8s21_0 0 0.04299f
Cc8s21_1 c8s21_1 0 0.1275f
Cc8s21_2 c8s21_2 0 0.3215f
Cc8s21_3 c8s21_3 0 0.2731f
Cc8s21_4 c8s21_4 0 0.1802f
Cc8s21_5 c8s21_5 0 0.2201f
Cc8s21_6 c8s21_6 0 0.07584f
CCc8s21_0 c8s21_0 c8s22_0 0.1238f
CCc8s21_2 c8s21_2 c8s22_2 0.04295f
CCc8s21_4 c8s21_4 c8s22_4 0.1241f
CCc8s21_6 c8s21_6 c8s22_6 0.09274f
Rc8s22_0 c8s22_0 c8s22_1 5.483
Rc8s22_1 c8s22_1 c8s22_2 0.6998
Rc8s22_2 c8s22_2 c8s22_3 2.099
Rc8s22_3 c8s22_3 c8s22_4 3.318
Rc8s22_4 c8s22_4 c8s22_5 2.091
Rc8s22_5 c8s22_5 c8s22_6 1.791
Cc8s22_0 c8s22_0 0 0.2322f
Cc8s22_1 c8s22_1 0 0.2788f
Cc8s22_2 c8s22_2 0 0.1866f
Cc8s22_3 c8s22_3 0 0.3611f
Cc8s22_4 c8s22_4 0 0.3606f
Cc8s22_5 c8s22_5 0 0.2588f
Cc8s22_6 c8s22_6 0 0.1194f
CCc8s22_0 c8s22_0 c8s23_0 0.1493f
CCc8s22_2 c8s22_2 c8s23_2 0.136f
CCc8s22_4 c8s22_4 c8s23_4 0.1294f
CCc8s22_6 c8s22_6 c8s23_6 0.07687f
Rc8s23_0 c8s23_0 c8s23_1 3.482
Rc8s23_1 c8s23_1 c8s23_2 1.338
Rc8s23_2 c8s23_2 c8s23_3 3.517
Rc8s23_3 c8s23_3 c8s23_4 0.6946
Rc8s23_4 c8s23_4 c8s23_5 0.8756
Rc8s23_5 c8s23_5 c8s23_6 2.442
Cc8s23_0 c8s23_0 0 0.09882f
Cc8s23_1 c8s23_1 0 0.188f
Cc8s23_2 c8s23_2 0 0.3237f
Cc8s23_3 c8s23_3 0 0.2808f
Cc8s23_4 c8s23_4 0 0.1047f
Cc8s23_5 c8s23_5 0 0.2212f
Cc8s23_6 c8s23_6 0 0.1628f
CCc8s23_0 c8s23_0 c8s24_0 0.1437f
CCc8s23_2 c8s23_2 c8s24_2 0.1571f
CCc8s23_4 c8s23_4 c8s24_4 0.1052f
CCc8s23_6 c8s23_6 c8s24_6 0.1404f
Rc8s24_0 c8s24_0 c8s24_1 3.596
Rc8s24_1 c8s24_1 c8s24_2 2.074
Rc8s24_2 c8s24_2 c8s24_3 2.872
Rc8s24_3 c8s24_3 c8s24_4 1.001
Rc8s24_4 c8s24_4 c8s24_5 2.662
Rc8s24_5 c8s24_5 c8s24_6 1.788
Cc8s24_0 c8s24_0 0 0.1064f
Cc8s24_1 c8s24_1 0 0.2446f
Cc8s24_2 c8s24_2 0 0.3297f
Cc8s24_3 c8s24_3 0 0.2582f
Cc8s24_4 c8s24_4 0 0.2442f
Cc8s24_5 c8s24_5 0 0.2967f
Cc8s24_6 c8s24_6 0 0.1192f
CCc8s24_0 c8s24_0 c8s25_0 0.02637f
CCc8s24_2 c8s24_2 c8s25_2 0.06985f
CCc8s24_4 c8s24_4 c8s25_4 0.1237f
CCc8s24_6 c8s24_6 c8s25_6 0.1319f
Rc8s25_0 c8s25_0 c8s25_1 4.607
Rc8s25_1 c8s25_1 c8s25_2 2.728
Rc8s25_2 c8s25_2 c8s25_3 1.616
Rc8s25_3 c8s25_3 c8s25_4 1.427
Rc8s25_4 c8s25_4 c8s25_5 1.706
Rc8s25_5 c8s25_5 c8s25_6 1.831
Cc8s25_0 c8s25_0 0 0.1738f
Cc8s25_1 c8s25_1 0 0.3557f
Cc8s25_2 c8s25_2 0 0.2896f
Cc8s25_3 c8s25_3 0 0.2028f
Cc8s25_4 c8s25_4 0 0.2088f
Cc8s25_5 c8s25_5 0 0.2357f
Cc8s25_6 c8s25_6 0 0.122f
CCc8s25_0 c8s25_0 c8s26_0 0.06566f
CCc8s25_2 c8s25_2 c8s26_2 0.144f
CCc8s25_4 c8s25_4 c8s26_4 0.1181f
CCc8s25_6 c8s25_6 c8s26_6 0.04121f
Rc8s26_0 c8s26_0 c8s26_1 2.868
Rc8s26_1 c8s26_1 c8s26_2 1.955
Rc8s26_2 c8s26_2 c8s26_3 2.457
Rc8s26_3 c8s26_3 c8s26_4 2.636
Rc8s26_4 c8s26_4 c8s26_5 1.796
Rc8s26_5 c8s26_5 c8s26_6 2.269
Cc8s26_0 c8s26_0 0 0.05789f
Cc8s26_1 c8s26_1 0 0.1882f
Cc8s26_2 c8s26_2 0 0.2941f
Cc8s26_3 c8s26_3 0 0.3395f
Cc8s26_4 c8s26_4 0 0.2954f
Cc8s26_5 c8s26_5 0 0.271f
Cc8s26_6 c8s26_6 0 0.1513f
CCc8s26_0 c8s26_0 c8s27_0 0.1047f
CCc8s26_2 c8s26_2 c8s27_2 0.06118f
CCc8s26_4 c8s26_4 c8s27_4 0.1328f
CCc8s26_6 c8s26_6 c8s27_6 0.06825f
Rc8s27_0 c8s27_0 c8s27_1 2.864
Rc8s27_1 c8s27_1 c8s27_2 0.9067
Rc8s27_2 c8s27_2 c8s27_3 2.492
Rc8s27_3 c8s27_3 c8s27_4 1.944
Rc8s27_4 c8s27_4 c8s27_5 3.112
Rc8s27_5 c8s27_5 c8s27_6 3.212
Cc8s27_0 c8s27_0 0 0.05759f
Cc8s27_1 c8s27_1 0 0.118f
Cc8s27_2 c8s27_2 0 0.2266f
Cc8s27_3 c8s27_3 0 0.2957f
Cc8s27_4 c8s27_4 0 0.337f
Cc8s27_5 c8s27_5 0 0.4216f
Cc8s27_6 c8s27_6 0 0.2141f
CCc8s27_0 c8s27_0 c8s28_0 0.05258f
CCc8s27_2 c8s27_2 c8s28_2 0.1292f
CCc8s27_4 c8s27_4 c8s28_4 0.1156f
CCc8s27_6 c8s27_6 c8s28_6 0.09877f
Rc8s28_0 c8s28_0 c8s28_1 5.586
Rc8s28_1 c8s28_1 c8s28_2 0.9854
Rc8s28_2 c8s28_2 c8s28_3 1.773
Rc8s28_3 c8s28_3 c8s28_4 1.741
Rc8s28_4 c8s28_4 c8s28_5 1.3
Rc8s28_5 c8s28_5 c8s28_6 2.393
Cc8s28_0 c8s28_0 0 0.2391f
Cc8s28_1 c8s28_1 0 0.3048f
Cc8s28_2 c8s28_2 0 0.1839f
Cc8s28_3 c8s28_3 0 0.2343f
Cc8s28_4 c8s28_4 0 0.2027f
Cc8s28_5 c8s28_5 0 0.2462f
Cc8s28_6 c8s28_6 0 0.1595f
CCc8s28_0 c8s28_0 c8s29_0 0.1398f
CCc8s28_2 c8s28_2 c8s29_2 0.08717f
CCc8s28_4 c8s28_4 c8s29_4 0.03134f
CCc8s28_6 c8s28_6 c8s29_6 0.05678f
Rc8s29_0 c8s29_0 c8s29_1 4.716
Rc8s29_1 c8s29_1 c8s29_2 1.897
Rc8s29_2 c8s29_2 c8s29_3 0.5937
Rc8s29_3 c8s29_3 c8s29_4 1.247
Rc8s29_4 c8s29_4 c8s29_5 2.12
Rc8s29_5 c8s29_5 c8s29_6 1.464
Cc8s29_0 c8s29_0 0 0.1811f
Cc8s29_1 c8s29_1 0 0.3076f
Cc8s29_2 c8s29_2 0 0.1661f
Cc8s29_3 c8s29_3 0 0.1227f
Cc8s29_4 c8s29_4 0 0.2245f
Cc8s29_5 c8s29_5 0 0.239f
Cc8s29_6 c8s29_6 0 0.09762f
CCc8s29_0 c8s29_0 c8s30_0 0.04884f
CCc8s29_2 c8s29_2 c8s30_2 0.07338f
CCc8s29_4 c8s29_4 c8s30_4 0.03552f
CCc8s29_6 c8s29_6 c8s30_6 0.1442f
Rc8s30_0 c8s30_0 c8s30_1 3.462
Rc8s30_1 c8s30_1 c8s30_2 1.927
Rc8s30_2 c8s30_2 c8s30_3 2.091
Rc8s30_3 c8s30_3 c8s30_4 1.865
Rc8s30_4 c8s30_4 c8s30_5 3.353
Rc8s30_5 c8s30_5 c8s30_6 0.9364
Cc8s30_0 c8s30_0 0 0.09748f
Cc8s30_1 c8s30_1 0 0.226f
Cc8s30_2 c8s30_2 0 0.2679f
Cc8s30_3 c8s30_3 0 0.2637f
Cc8s30_4 c8s30_4 0 0.3479f
Cc8s30_5 c8s30_5 0 0.286f
Cc8s30_6 c8s30_6 0 0.06243f
CCc8s30_0 c8s30_0 c8s31_0 0.08916f
CCc8s30_2 c8s30_2 c8s31_2 0.04182f
CCc8s30_4 c8s30_4 c8s31_4 0.02851f
CCc8s30_6 c8s30_6 c8s31_6 0.1186f
Rc8s31_0 c8s31_0 c8s31_1 3.503
Rc8s31_1 c8s31_1 c8s31_2 2.782
Rc8s31_2 c8s31_2 c8s31_3 1.987
Rc8s31_3 c8s31_3 c8s31_4 0.5664
Rc8s31_4 c8s31_4 c8s31_5 0.7035
Rc8s31_5 c8s31_5 c8s31_6 0.5341
Cc8s31_0 c8s31_0 0 0.1002f
Cc8s31_1 c8s31_1 0 0.2857f
Cc8s31_2 c8s31_2 0 0.3179f
Cc8s31_3 c8s31_3 0 0.1703f
Cc8s31_4 c8s31_4 0 0.08466f
Cc8s31_5 c8s31_5 0 0.0825f
Cc8s31_6 c8s31_6 0 0.0356f
CCc8s31_0 c8s31_0 c8s32_0 0.1006f
CCc8s31_2 c8s31_2 c8s32_2 0.07666f
CCc8s31_4 c8s31_4 c8s32_4 0.06083f
CCc8s31_6 c8s31_6 c8s32_6 0.06203f
Rc8s32_0 c8s32_0 c8s32_1 3.81
Rc8s32_1 c8s32_1 c8s32_2 3.175
Rc8s32_2 c8s32_2 c8s32_3 3.259
Rc8s32_3 c8s32_3 c8s32_4 3.045
Rc8s32_4 c8s32_4 c8s32_5 2.8
Rc8s32_5 c8s32_5 c8s32_6 0.8293
Cc8s32_0 c8s32_0 0 0.1207f
Cc8s32_1 c8s32_1 0 0.3323f
Cc8s32_2 c8s32_2 0 0.4289f
Cc8s32_3 c8s32_3 0 0.4203f
Cc8s32_4 c8s32_4 0 0.3897f
Cc8s32_5 c8s32_5 0 0.2419f
Cc8s32_6 c8s32_6 0 0.05529f
CCc8s32_0 c8s32_0 c8s33_0 0.07205f
CCc8s32_2 c8s32_2 c8s33_2 0.135f
CCc8s32_4 c8s32_4 c8s33_4 0.04845f
CCc8s32_6 c8s32_6 c8s33_6 0.1215f
Rc8s33_0 c8s33_0 c8s33_1 2.793
Rc8s33_1 c8s33_1 c8s33_2 3.017
Rc8s33_2 c8s33_2 c8s33_3 1.264
Rc8s33_3 c8s33_3 c8s33_4 1.263
Rc8s33_4 c8s33_4 c8s33_5 3.489
Rc8s33_5 c8s33_5 c8s33_6 0.7978
Cc8s33_0 c8s33_0 0 0.05283f
Cc8s33_1 c8s33_1 0 0.254f
Cc8s33_2 c8s33_2 0 0.2854f
Cc8s33_3 c8s33_3 0 0.1684f
Cc8s33_4 c8s33_4 0 0.3168f
Cc8s33_5 c8s33_5 0 0.2858f
Cc8s33_6 c8s33_6 0 0.05319f
CCc8s33_0 c8s33_0 c8s34_0 0.146f
CCc8s33_2 c8s33_2 c8s34_2 0.06129f
CCc8s33_4 c8s33_4 c8s34_4 0.05915f
CCc8s33_6 c8s33_6 c8s34_6 0.04022f
Rc8s34_0 c8s34_0 c8s34_1 2.632
Rc8s34_1 c8s34_1 c8s34_2 1.643
Rc8s34_2 c8s34_2 c8s34_3 1.85
Rc8s34_3 c8s34_3 c8s34_4 1.436
Rc8s34_4 c8s34_4 c8s34_5 0.4718
Rc8s34_5 c8s34_5 c8s34_6 3.257
Cc8s34_0 c8s34_0 0 0.0421f
Cc8s34_1 c8s34_1 0 0.1517f
Cc8s34_2 c8s34_2 0 0.2329f
Cc8s34_3 c8s34_3 0 0.2191f
Cc8s34_4 c8s34_4 0 0.1272f
Cc8s34_5 c8s34_5 0 0.2486f
Cc8s34_6 c8s34_6 0 0.2171f
CCc8s34_0 c8s34_0 c8s35_0 0.1379f
CCc8s34_2 c8s34_2 c8s35_2 0.1081f
CCc8s34_4 c8s34_4 c8s35_4 0.0391f
CCc8s34_6 c8s34_6 c8s35_6 0.041f
Rc8s35_0 c8s35_0 c8s35_1 3.978
Rc8s35_1 c8s35_1 c8s35_2 0.9913
Rc8s35_2 c8s35_2 c8s35_3 1.337
Rc8s35_3 c8s35_3 c8s35_4 1.141
Rc8s35_4 c8s35_4 c8s35_5 2.874
Rc8s35_5 c8s35_5 c8s35_6 2.555
Cc8s35_0 c8s35_0 0 0.1319f
Cc8s35_1 c8s35_1 0 0.198f
Cc8s35_2 c8s35_2 0 0.1552f
Cc8s35_3 c8s35_3 0 0.1652f
Cc8s35_4 c8s35_4 0 0.2676f
Cc8s35_5 c8s35_5 0 0.3619f
Cc8s35_6 c8s35_6 0 0.1703f
CCc8s35_0 c8s35_0 c8s36_0 0.04904f
CCc8s35_2 c8s35_2 c8s36_2 0.1527f
CCc8s35_4 c8s35_4 c8s36_4 0.1045f
CCc8s35_6 c8s35_6 c8s36_6 0.131f
Rc8s36_0 c8s36_0 c8s36_1 4.564
Rc8s36_1 c8s36_1 c8s36_2 1.91
Rc8s36_2 c8s36_2 c8s36_3 1.93
Rc8s36_3 c8s36_3 c8s36_4 1.796
Rc8s36_4 c8s36_4 c8s36_5 0.665
Rc8s36_5 c8s36_5 c8s36_6 3.418
Cc8s36_0 c8s36_0 0 0.1709f
Cc8s36_1 c8s36_1 0 0.2983f
Cc8s36_2 c8s36_2 0 0.256f
Cc8s36_3 c8s36_3 0 0.2484f
Cc8s36_4 c8s36_4 0 0.164f
Cc8s36_5 c8s36_5 0 0.2722f
Cc8s36_6 c8s36_6 0 0.2279f
CCc8s36_0 c8s36_0 c8s37_0 0.06823f
CCc8s36_2 c8s36_2 c8s37_2 0.02778f
CCc8s36_4 c8s36_4 c8s37_4 0.03456f
CCc8s36_6 c8s36_6 c8s37_6 0.0737f
Rc8s37_0 c8s37_0 c8s37_1 4.702
Rc8s37_1 c8s37_1 c8s37_2 2.025
Rc8s37_2 c8s37_2 c8s37_3 1.492
Rc8s37_3 c8s37_3 c8s37_4 3.304
Rc8s37_4 c8s37_4 c8s37_5 0.6657
Rc8s37_5 c8s37_5 c8s37_6 1.295
Cc8s37_0 c8s37_0 0 0.1801f
Cc8s37_1 c8s37_1 0 0.3151f
Cc8s37_2 c8s37_2 0 0.2345f
Cc8s37_3 c8s37_3 0 0.3198f
Cc8s37_4 c8s37_4 0 0.2647f
Cc8s37_5 c8s37_5 0 0.1307f
Cc8s37_6 c8s37_6 0 0.08635f
CCc8s37_0 c8s37_0 c8s38_0 0.1437f
CCc8s37_2 c8s37_2 c8s38_2 0.0856f
CCc8s37_4 c8s37_4 c8s38_4 0.08517f
CCc8s37_6 c8s37_6 c8s38_6 0.03121f
Rc8s38_0 c8s38_0 c8s38_1 4.33
Rc8s38_1 c8s38_1 c8s38_2 2.744
Rc8s38_2 c8s38_2 c8s38_3 3.091
Rc8s38_3 c8s38_3 c8s38_4 0.8074
Rc8s38_4 c8s38_4 c8s38_5 2.25
Rc8s38_5 c8s38_5 c8s38_6 3.02
Cc8s38_0 c8s38_0 0 0.1554f
Cc8s38_1 c8s38_1 0 0.3383f
Cc8s38_2 c8s38_2 0 0.389f
Cc8s38_3 c8s38_3 0 0.2599f
Cc8s38_4 c8s38_4 0 0.2038f
Cc8s38_5 c8s38_5 0 0.3513f
Cc8s38_6 c8s38_6 0 0.2013f
CCc8s38_0 c8s38_0 c8s39_0 0.1449f
CCc8s38_2 c8s38_2 c8s39_2 0.03304f
CCc8s38_4 c8s38_4 c8s39_4 0.04024f
CCc8s38_6 c8s38_6 c8s39_6 0.1468f
Rc8s39_0 c8s39_0 c8s39_1 3.654
Rc8s39_1 c8s39_1 c8s39_2 1.785
Rc8s39_2 c8s39_2 c8s39_3 2.759
Rc8s39_3 c8s39_3 c8s39_4 1.137
Rc8s39_4 c8s39_4 c8s39_5 0.9118
Rc8s39_5 c8s39_5 c8s39_6 2.213
Cc8s39_0 c8s39_0 0 0.1103f
Cc8s39_1 c8s39_1 0 0.2293f
Cc8s39_2 c8s39_2 0 0.3029f
Cc8s39_3 c8s39_3 0 0.2598f
Cc8s39_4 c8s39_4 0 0.1366f
Cc8s39_5 c8s39_5 0 0.2083f
Cc8s39_6 c8s39_6 0 0.1476f
CCc8s39_0 c8s39_0 c8s40_0 0.1064f
CCc8s39_2 c8s39_2 c8s40_2 0.1509f
CCc8s39_4 c8s39_4 c8s40_4 0.0342f
CCc8s39_6 c8s39_6 c8s40_6 0.1104f
Rc8s40_0 c8s40_0 c8s40_1 2.842
Rc8s40_1 c8s40_1 c8s40_2 2.286
Rc8s40_2 c8s40_2 c8s40_3 2.477
Rc8s40_3 c8s40_3 c8s40_4 1.763
Rc8s40_4 c8s40_4 c8s40_5 1.693
Rc8s40_5 c8s40_5 c8s40_6 1.754
Cc8s40_0 c8s40_0 0 0.05611f
Cc8s40_1 c8s40_1 0 0.2085f
Cc8s40_2 c8s40_2 0 0.3176f
Cc8s40_3 c8s40_3 0 0.2826f
Cc8s40_4 c8s40_4 0 0.2304f
Cc8s40_5 c8s40_5 0 0.2298f
Cc8s40_6 c8s40_6 0 0.1169f
CCc8s40_0 c8s40_0 c8s41_0 0.1352f
CCc8s40_2 c8s40_2 c8s41_2 0.1389f
CCc8s40_4 c8s40_4 c8s41_4 0.08316f
CCc8s40_6 c8s40_6 c8s41_6 0.1242f
Rc8s41_0 c8s41_0 c8s41_1 3.823
Rc8s41_1 c8s41_1 c8s41_2 1.838
Rc8s41_2 c8s41_2 c8s41_3 2.411
Rc8s41_3 c8s41_3 c8s41_4 2.366
Rc8s41_4 c8s41_4 c8s41_5 1.89
Rc8s41_5 c8s41_5 c8s41_6 1.956
Cc8s41_0 c8s41_0 0 0.1215f
Cc8s41_1 c8s41_1 0 0.2441f
Cc8s41_2 c8s41_2 0 0.2833f
Cc8s41_3 c8s41_3 0 0.3185f
Cc8s41_4 c8s41_4 0 0.2837f
Cc8s41_5 c8s41_5 0 0.2564f
Cc8s41_6 c8s41_6 0 0.1304f
CCc8s41_0 c8s41_0 c8s42_0 0.1406f
CCc8s41_2 c8s41_2 c8s42_2 0.06649f
CCc8s41_4 c8s41_4 c8s42_4 0.1078f
CCc8s41_6 c8s41_6 c8s42_6 0.03976f
Rc8s42_0 c8s42_0 c8s42_1 5.53
Rc8s42_1 c8s42_1 c8s42_2 0.5871
Rc8s42_2 c8s42_2 c8s42_3 2.908
Rc8s42_3 c8s42_3 c8s42_4 0.9744
Rc8s42_4 c8s42_4 c8s42_5 2.526
Rc8s42_5 c8s42_5 c8s42_6 0.4642
Cc8s42_0 c8s42_0 0 0.2353f
Cc8s42_1 c8s42_1 0 0.2745f
Cc8s42_2 c8s42_2 0 0.233f
Cc8s42_3 c8s42_3 0 0.2588f
Cc8s42_4 c8s42_4 0 0.2333f
Cc8s42_5 c8s42_5 0 0.1993f
Cc8s42_6 c8s42_6 0 0.03095f
CCc8s42_0 c8s42_0 c8s43_0 0.06577f
CCc8s42_2 c8s42_2 c8s43_2 0.02577f
CCc8s42_4 c8s42_4 c8s43_4 0.07906f
CCc8s42_6 c8s42_6 c8s43_6 0.1067f
Rc8s43_0 c8s43_0 c8s43_1 2.505
Rc8s43_1 c8s43_1 c8s43_2 2.181
Rc8s43_2 c8s43_2 c8s43_3 1.715
Rc8s43_3 c8s43_3 c8s43_4 3.198
Rc8s43_4 c8s43_4 c8s43_5 1.695
Rc8s43_5 c8s43_5 c8s43_6 0.5366
Cc8s43_0 c8s43_0 0 0.03363f
Cc8s43_1 c8s43_1 0 0.179f
Cc8s43_2 c8s43_2 0 0.2598f
Cc8s43_3 c8s43_3 0 0.3276f
Cc8s43_4 c8s43_4 0 0.3262f
Cc8s43_5 c8s43_5 0 0.1488f
Cc8s43_6 c8s43_6 0 0.03577f
CCc8s43_0 c8s43_0 c8s44_0 0.05362f
CCc8s43_2 c8s43_2 c8s44_2 0.1425f
CCc8s43_4 c8s43_4 c8s44_4 0.08805f
CCc8s43_6 c8s43_6 c8s44_6 0.07467f
Rc8s44_0 c8s44_0 c8s44_1 3.439
Rc8s44_1 c8s44_1 c8s44_2 1.359
Rc8s44_2 c8s44_2 c8s44_3 0.8886
Rc8s44_3 c8s44_3 c8s44_4 2.233
Rc8s44_4 c8s44_4 c8s44_5 0.8909
Rc8s44_5 c8s44_5 c8s44_6 0.8952
Cc8s44_0 c8s44_0 0 0.09592f
Cc8s44_1 c8s44_1 0 0.1865f
Cc8s44_2 c8s44_2 0 0.1498f
Cc8s44_3 c8s44_3 0 0.2081f
Cc8s44_4 c8s44_4 0 0.2083f
Cc8s44_5 c8s44_5 0 0.1191f
Cc8s44_6 c8s44_6 0 0.05968f
CCc8s44_0 c8s44_0 c8s45_0 0.04041f
CCc8s44_2 c8s44_2 c8s45_2 0.05317f
CCc8s44_4 c8s44_4 c8s45_4 0.1452f
CCc8s44_6 c8s44_6 c8s45_6 0.04777f
Rc8s45_0 c8s45_0 c8s45_1 2.547
Rc8s45_1 c8s45_1 c8s45_2 3.442
Rc8s45_2 c8s45_2 c8s45_3 1.992
Rc8s45_3 c8s45_3 c8s45_4 3.505
Rc8s45_4 c8s45_4 c8s45_5 2.931
Rc8s45_5 c8s45_5 c8s45_6 1.93
Cc8s45_0 c8s45_0 0 0.03644f
Cc8s45_1 c8s45_1 0 0.2659f
Cc8s45_2 c8s45_2 0 0.3623f
Cc8s45_3 c8s45_3 0 0.3665f
Cc8s45_4 c8s45_4 0 0.4291f
Cc8s45_5 c8s45_5 0 0.324f
Cc8s45_6 c8s45_6 0 0.1286f
CCc8s45_0 c8s45_0 c8s46_0 0.07993f
CCc8s45_2 c8s45_2 c8s46_2 0.02007f
CCc8s45_4 c8s45_4 c8s46_4 0.07881f
CCc8s45_6 c8s45_6 c8s46_6 0.0534f
Rc8s46_0 c8s46_0 c8s46_1 3.644
Rc8s46_1 c8s46_1 c8s46_2 3.153
Rc8s46_2 c8s46_2 c8s46_3 2.4
Rc8s46_3 c8s46_3 c8s46_4 3.418
Rc8s46_4 c8s46_4 c8s46_5 2.871
Rc8s46_5 c8s46_5 c8s46_6 3.138
Cc8s46_0 c8s46_0 0 0.1096f
Cc8s46_1 c8s46_1 0 0.3198f
Cc8s46_2 c8s46_2 0 0.3702f
Cc8s46_3 c8s46_3 0 0.3879f
Cc8s46_4 c8s46_4 0 0.4193f
Cc8s46_5 c8s46_5 0 0.4006f
Cc8s46_6 c8s46_6 0 0.2092f
CCc8s46_0 c8s46_0 c8s47_0 0.03522f
CCc8s46_2 c8s46_2 c8s47_2 0.09185f
CCc8s46_4 c8s46_4 c8s47_4 0.1352f
CCc8s46_6 c8s46_6 c8s47_6 0.1288f
Rc8s47_0 c8s47_0 c8s47_1 5.03
Rc8s47_1 c8s47_1 c8s47_2 1.8
Rc8s47_2 c8s47_2 c8s47_3 0.857
Rc8s47_3 c8s47_3 c8s47_4 2.091
Rc8s47_4 c8s47_4 c8s47_5 2.238
Rc8s47_5 c8s47_5 c8s47_6 2.851
Cc8s47_0 c8s47_0 0 0.202f
Cc8s47_1 c8s47_1 0 0.322f
Cc8s47_2 c8s47_2 0 0.1771f
Cc8s47_3 c8s47_3 0 0.1966f
Cc8s47_4 c8s47_4 0 0.2886f
Cc8s47_5 c8s47_5 0 0.3393f
Cc8s47_6 c8s47_6 0 0.1901f
CCc8s47_0 c8s47_0 c8s48_0 0.07144f
CCc8s47_2 c8s47_2 c8s48_2 0.1456f
CCc8s47_4 c8s47_4 c8s48_4 0.1427f
CCc8s47_6 c8s47_6 c8s48_6 0.1248f
Rc8s48_0 c8s48_0 c8s48_1 4.796
Rc8s48_1 c8s48_1 c8s48_2 3.568
Rc8s48_2 c8s48_2 c8s48_3 0.7371
Rc8s48_3 c8s48_3 c8s48_4 1.552
Rc8s48_4 c8s48_4 c8s48_5 1.842
Rc8s48_5 c8s48_5 c8s48_6 1.779
Cc8s48_0 c8s48_0 0 0.1864f
Cc8s48_1 c8s48_1 0 0.4242f
Cc8s48_2 c8s48_2 0 0.287f
Cc8s48_3 c8s48_3 0 0.1526f
Cc8s48_4 c8s48_4 0 0.2263f
Cc8s48_5 c8s48_5 0 0.2414f
Cc8s48_6 c8s48_6 0 0.1186f
CCc8s48_0 c8s48_0 c8s49_0 0.1147f
Cc8s49_0 c8s49_0 0 0f
CCc8s49_0 c8s49_0 c9s0_0 0.08148f
Rc9s0_0 c9s0_0 c9s0_1 3.636
Rc9s0_1 c9s0_1 c9s0_2 0.5388
Rc9s0_2 c9s0_2 c9s0_3 0.6009
Rc9s0_3 c9s0_3 c9s0_4 1.987
Rc9s0_4 c9s0_4 c9s0_5 1.466
Rc9s0_5 c9s0_5 c9s0_6 1.178
Cc9s0_0 c9s0_0 0 0.1091f
Cc9s0_1 c9s0_1 0 0.145f
Cc9s0_2 c9s0_2 0 0.07598f
Cc9s0_3 c9s0_3 0 0.1725f
Cc9s0_4 c9s0_4 0 0.2302f
Cc9s0_5 c9s0_5 0 0.1763f
Cc9s0_6 c9s0_6 0 0.07851f
CCc9s0_0 c9s0_0 c9s1_0 0.02274f
CCc9s0_2 c9s0_2 c9s1_2 0.03079f
CCc9s0_4 c9s0_4 c9s1_4 0.04514f
CCc9s0_6 c9s0_6 c9s1_6 0.08652f
Rc9s1_0 c9s1_0 c9s1_1 3.178
Rc9s1_1 c9s1_1 c9s1_2 1.898
Rc9s1_2 c9s1_2 c9s1_3 2.785
Rc9s1_3 c9s1_3 c9s1_4 0.6881
Rc9s1_4 c9s1_4 c9s1_5 2.429
Rc9s1_5 c9s1_5 c9s1_6 2.833
Cc9s1_0 c9s1_0 0 0.07853f
Cc9s1_1 c9s1_1 0 0.2051f
Cc9s1_2 c9s1_2 0 0.3122f
Cc9s1_3 c9s1_3 0 0.2315f
Cc9s1_4 c9s1_4 0 0.2078f
Cc9s1_5 c9s1_5 0 0.3508f
Cc9s1_6 c9s1_6 0 0.1889f
CCc9s1_0 c9s1_0 c9s2_0 0.1466f
CCc9s1_2 c9s1_2 c9s2_2 0.1592f
CCc9s1_4 c9s1_4 c9s2_4 0.04616f
CCc9s1_6 c9s1_6 c9s2_6 0.02609f
Rc9s2_0 c9s2_0 c9s2_1 4.493
Rc9s2_1 c9s2_1 c9s2_2 2.163
Rc9s2_2 c9s2_2 c9s2_3 3.303
Rc9s2_3 c9s2_3 c9s2_4 2.325
Rc9s2_4 c9s2_4 c9s2_5 3.04
Rc9s2_5 c9s2_5 c9s2_6 0.4848
Cc9s2_0 c9s2_0 0 0.1662f
Cc9s2_1 c9s2_1 0 0.3104f
Cc9s2_2 c9s2_2 0 0.3644f
Cc9s2_3 c9s2_3 0 0.3752f
Cc9s2_4 c9s2_4 0 0.3577f
Cc9s2_5 c9s2_5 0 0.235f
Cc9s2_6 c9s2_6 0 0.03232f
CCc9s2_0 c9s2_0 c9s3_0 0.08582f
CCc9s2_2 c9s2_2 c9s3_2 0.04778f
CCc9s2_4 c9s2_4 c9s3_4 0.04541f
CCc9s2_6 c9s2_6 c9s3_6 0.03009f
Rc9s3_0 c9s3_0 c9s3_1 5.429
Rc9s3_1 c9s3_1 c9s3_2 1.684
Rc9s3_2 c9s3_2 c9s3_3 2.961
Rc9s3_3 c9s3_3 c9s3_4 2.888
Rc9s3_4 c9s3_4 c9s3_5 2.995
Rc9s3_5 c9s3_5 c9s3_6 1.403
Cc9s3_0 c9s3_0 0 0.2286f
Cc9s3_1 c9s3_1 0 0.3408f
Cc9s3_2 c9s3_2 0 0.3096f
Cc9s3_3 c9s3_3 0 0.3899f
Cc9s3_4 c9s3_4 0 0.3922f
Cc9s3_5 c9s3_5 0 0.2932f
Cc9s3_6 c9s3_6 0 0.0935f
CCc9s3_0 c9s3_0 c9s4_0 0.1275f
CCc9s3_2 c9s3_2 c9s4_2 0.08364f
CCc9s3_4 c9s3_4 c9s4_4 0.1508f
CCc9s3_6 c9s3_6 c9s4_6 0.1153f
Rc9s4_0 c9s4_0 c9s4_1 5.278
Rc9s4_1 c9s4_1 c9s4_2 3.453
Rc9s4_2 c9s4_2 c9s4_3 1.576
Rc9s4_3 c9s4_3 c9s4_4 1.574
Rc9s4_4 c9s4_4 c9s4_5 0.459
Rc9s4_5 c9s4_5 c9s4_6 3.073
Cc9s4_0 c9s4_0 0 0.2185f
Cc9s4_1 c9s4_1 0 0.4488f
Cc9s4_2 c9s4_2 0 0.3353f
Cc9s4_3 c9s4_3 0 0.21f
Cc9s4_4 c9s4_4 0 0.1355f
Cc9s4_5 c9s4_5 0 0.2355f
Cc9s4_6 c9s4_6 0 0.2049f
CCc9s4_0 c9s4_0 c9s5_0 0.1065f
CCc9s4_2 c9s4_2 c9s5_2 0.04302f
CCc9s4_4 c9s4_4 c9s5_4 0.1071f
CCc9s4_6 c9s4_6 c9s5_6 0.152f
Rc9s5_0 c9s5_0 c9s5_1 5.366
Rc9s5_1 c9s5_1 c9s5_2 3.572
Rc9s5_2 c9s5_2 c9s5_3 1.511
Rc9s5_3 c9s5_3 c9s5_4 1.239
Rc9s5_4 c9s5_4 c9s5_5 0.4601
Rc9s5_5 c9s5_5 c9s5_6 0.9018
Cc9s5_0 c9s5_0 0 0.2244f
Cc9s5_1 c9s5_1 0 0.4625f
Cc9s5_2 c9s5_2 0 0.3389f
Cc9s5_3 c9s5_3 0 0.1834f
Cc9s5_4 c9s5_4 0 0.1133f
Cc9s5_5 c9s5_5 0 0.09079f
Cc9s5_6 c9s5_6 0 0.06012f
CCc9s5_0 c9s5_0 c9s6_0 0.05602f
CCc9s5_2 c9s5_2 c9s6_2 0.1078f
CCc9s5_4 c9s5_4 c9s6_4 0.02088f
CCc9s5_6 c9s5_6 c9s6_6 0.1501f
Rc9s6_0 c9s6_0 c9s6_1 4.492
Rc9s6_1 c9s6_1 c9s6_2 3.151
Rc9s6_2 c9s6_2 c9s6_3 1.346
Rc9s6_3 c9s6_3 c9s6_4 2.099
Rc9s6_4 c9s6_4 c9s6_5 3.329
Rc9s6_5 c9s6_5 c9s6_6 0.7958
Cc9s6_0 c9s6_0 0 0.1661f
Cc9s6_1 c9s6_1 0 0.3762f
Cc9s6_2 c9s6_2 0 0.2998f
Cc9s6_3 c9s6_3 0 0.2297f
Cc9s6_4 c9s6_4 0 0.3619f
Cc9s6_5 c9s6_5 0 0.275f
Cc9s6_6 c9s6_6 0 0.05305f
CCc9s6_0 c9s6_0 c9s7_0 0.03092f
CCc9s6_2 c9s6_2 c9s7_2 0.04095f
CCc9s6_4 c9s6_4 c9s7_4 0.04842f
CCc9s6_6 c9s6_6 c9s7_6 0.04495f
Rc9s7_0 c9s7_0 c9s7_1 2.548
Rc9s7_1 c9s7_1 c9s7_2 0.9441
Rc9s7_2 c9s7_2 c9s7_3 1.836
Rc9s7_3 c9s7_3 c9s7_4 1.46
Rc9s7_4 c9s7_4 c9s7_5 1.857
Rc9s7_5 c9s7_5 c9s7_6 2.031
Cc9s7_0 c9s7_0 0 0.03656f
Cc9s7_1 c9s7_1 0 0.0995f
Cc9s7_2 c9s7_2 0 0.1853f
Cc9s7_3 c9s7_3 0 0.2197f
Cc9s7_4 c9s7_4 0 0.2211f
Cc9s7_5 c9s7_5 0 0.2592f
Cc9s7_6 c9s7_6 0 0.1354f
CCc9s7_0 c9s7_0 c9s8_0 0.119f
CCc9s7_2 c9s7_2 c9s8_2 0.101f
CCc9s7_4 c9s7_4 c9s8_4 0.1559f
CCc9s7_6 c9s7_6 c9s8_6 0.1523f
Rc9s8_0 c9s8_0 c9s8_1 5.281
Rc9s8_1 c9s8_1 c9s8_2 2.094
Rc9s8_2 c9s8_2 c9s8_3 1.216
Rc9s8_3 c9s8_3 c9s8_4 1.874
Rc9s8_4 c9s8_4 c9s8_5 1.999
Rc9s8_5 c9s8_5 c9s8_6 2.069
Cc9s8_0 c9s8_0 0 0.2187f
Cc9s8_1 c9s8_1 0 0.3583f
Cc9s8_2 c9s8_2 0 0.2207f
Cc9s8_3 c9s8_3 0 0.206f
Cc9s8_4 c9s8_4 0 0.2582f
Cc9s8_5 c9s8_5 0 0.2712f
Cc9s8_6 c9s8_6 0 0.1379f
CCc9s8_0 c9s8_0 c9s9_0 0.1516f
CCc9s8_2 c9s8_2 c9s9_2 0.1139f
CCc9s8_4 c9s8_4 c9s9_4 0.151f
CCc9s8_6 c9s8_6 c9s9_6 0.04112f
Rc9s9_0 c9s9_0 c9s9_1 4.466
Rc9s9_1 c9s9_1 c9s9_2 1.285
Rc9s9_2 c9s9_2 c9s9_3 0.5075
Rc9s9_3 c9s9_3 c9s9_4 0.4634
Rc9s9_4 c9s9_4 c9s9_5 1.618
Rc9s9_5 c9s9_5 c9s9_6 1.03
Cc9s9_0 c9s9_0 0 0.1644f
Cc9s9_1 c9s9_1 0 0.2501f
Cc9s9_2 c9s9_2 0 0.1195f
Cc9s9_3 c9s9_3 0 0.06473f
Cc9s9_4 c9s9_4 0 0.1388f
Cc9s9_5 c9s9_5 0 0.1765f
Cc9s9_6 c9s9_6 0 0.06866f
CCc9s9_0 c9s9_0 c9s10_0 0.06582f
CCc9s9_2 c9s9_2 c9s10_2 0.02593f
CCc9s9_4 c9s9_4 c9s10_4 0.02412f
CCc9s9_6 c9s9_6 c9s10_6 0.05468f
Rc9s10_0 c9s10_0 c9s10_1 4.734
Rc9s10_1 c9s10_1 c9s10_2 1.969
Rc9s10_2 c9s10_2 c9s10_3 2.724
Rc9s10_3 c9s10_3 c9s10_4 3.335
Rc9s10_4 c9s10_4 c9s10_5 2.023
Rc9s10_5 c9s10_5 c9s10_6 2.3
Cc9s10_0 c9s10_0 0 0.1823f
Cc9s10_1 c9s10_1 0 0.3136f
Cc9s10_2 c9s10_2 0 0.3129f
Cc9s10_3 c9s10_3 0 0.4039f
Cc9s10_4 c9s10_4 0 0.3572f
Cc9s10_5 c9s10_5 0 0.2882f
Cc9s10_6 c9s10_6 0 0.1533f
CCc9s10_0 c9s10_0 c9s11_0 0.04794f
CCc9s10_2 c9s10_2 c9s11_2 0.06918f
CCc9s10_4 c9s10_4 c9s11_4 0.1248f
CCc9s10_6 c9s10_6 c9s11_6 0.13f
Rc9s11_0 c9s11_0 c9s11_1 2.905
Rc9s11_1 c9s11_1 c9s11_2 1.061
Rc9s11_2 c9s11_2 c9s11_3 1.904
Rc9s11_3 c9s11_3 c9s11_4 1.862
Rc9s11_4 c9s11_4 c9s11_5 2.385
Rc9s11_5 c9s11_5 c9s11_6 3.179
Cc9s11_0 c9s11_0 0 0.06033f
Cc9s11_1 c9s11_1 0 0.131f
Cc9s11_2 c9s11_2 0 0.1977f
Cc9s11_3 c9s11_3 0 0.2511f
Cc9s11_4 c9s11_4 0 0.2831f
Cc9s11_5 c9s11_5 0 0.3709f
Cc9s11_6 c9s11_6 0 0.2119f
CCc9s11_0 c9s11_0 c9s12_0 0.05455f
CCc9s11_2 c9s11_2 c9s12_2 0.03331f
CCc9s11_4 c9s11_4 c9s12_4 0.03234f
CCc9s11_6 c9s11_6 c9s12_6 0.06371f
Rc9s12_0 c9s12_0 c9s12_1 3.615
Rc9s12_1 c9s12_1 c9s12_2 0.8344
Rc9s12_2 c9s12_2 c9s12_3 3.07
Rc9s12_3 c9s12_3 c9s12_4 1.585
Rc9s12_4 c9s12_4 c9s12_5 1.235
Rc9s12_5 c9s12_5 c9s12_6 1.343
Cc9s12_0 c9s12_0 0 0.1077f
Cc9s12_1 c9s12_1 0 0.1633f
Cc9s12_2 c9s12_2 0 0.2603f
Cc9s12_3 c9s12_3 0 0.3103f
Cc9s12_4 c9s12_4 0 0.188f
Cc9s12_5 c9s12_5 0 0.1719f
Cc9s12_6 c9s12_6 0 0.08955f
CCc9s12_0 c9s12_0 c9s13_0 0.1437f
CCc9s12_2 c9s12_2 c9s13_2 0.1081f
CCc9s12_4 c9s12_4 c9s13_4 0.1333f
CCc9s12_6 c9s12_6 c9s13_6 0.03744f
Rc9s13_0 c9s13_0 c9s13_1 2.977
Rc9s13_1 c9s13_1 c9s13_2 1.731
Rc9s13_2 c9s13_2 c9s13_3 1.911
Rc9s13_3 c9s13_3 c9s13_4 0.8802
Rc9s13_4 c9s13_4 c9s13_5 1.07
Rc9s13_5 c9s13_5 c9s13_6 0.7
Cc9s13_0 c9s13_0 0 0.06515f
Cc9s13_1 c9s13_1 0 0.1805f
Cc9s13_2 c9s13_2 0 0.2428f
Cc9s13_3 c9s13_3 0 0.1861f
Cc9s13_4 c9s13_4 0 0.13f
Cc9s13_5 c9s13_5 0 0.118f
Cc9s13_6 c9s13_6 0 0.04667f
CCc9s13_0 c9s13_0 c9s14_0 0.03018f
CCc9s13_2 c9s13_2 c9s14_2 0.04155f
CCc9s13_4 c9s13_4 c9s14_4 0.05415f
CCc9s13_6 c9s13_6 c9s14_6 0.0622f
Rc9s14_0 c9s14_0 c9s14_1 4.346
Rc9s14_1 c9s14_1 c9s14_2 3.596
Rc9s14_2 c9s14_2 c9s14_3 2.256
Rc9s14_3 c9s14_3 c9s14_4 1.959
Rc9s14_4 c9s14_4 c9s14_5 1.667
Rc9s14_5 c9s14_5 c9s14_6 0.7922
Cc9s14_0 c9s14_0 0 0.1564f
Cc9s14_1 c9s14_1 0 0.3961f
Cc9s14_2 c9s14_2 0 0.3902f
Cc9s14_3 c9s14_3 0 0.281f
Cc9s14_4 c9s14_4 0 0.2417f
Cc9s14_5 c9s14_5 0 0.1639f
Cc9s14_6 c9s14_6 0 0.05281f
CCc9s14_0 c9s14_0 c9s15_0 0.1124f
CCc9s14_2 c9s14_2 c9s15_2 0.0836f
CCc9s14_4 c9s14_4 c9s15_4 0.1123f
CCc9s14_6 c9s14_6 c9s15_6 0.07526f
Rc9s15_0 c9s15_0 c9s15_1 3.119
Rc9s15_1 c9s15_1 c9s15_2 1.501
Rc9s15_2 c9s15_2 c9s15_3 0.9234
Rc9s15_3 c9s15_3 c9s15_4 1.296
Rc9s15_4 c9s15_4 c9s15_5 3.45
Rc9s15_5 c9s15_5 c9s15_6 1.067
Cc9s15_0 c9s15_0 0 0.07459f
Cc9s15_1 c9s15_1 0 0.1746f
Cc9s15_2 c9s15_2 0 0.1616f
Cc9s15_3 c9s15_3 0 0.1479f
Cc9s15_4 c9s15_4 0 0.3164f
Cc9s15_5 c9s15_5 0 0.3011f
Cc9s15_6 c9s15_6 0 0.07113f
CCc9s15_0 c9s15_0 c9s16_0 0.1037f
CCc9s15_2 c9s15_2 c9s16_2 0.1496f
CCc9s15_4 c9s15_4 c9s16_4 0.07634f
CCc9s15_6 c9s15_6 c9s16_6 0.06507f
Rc9s16_0 c9s16_0 c9s16_1 2.788
Rc9s16_1 c9s16_1 c9s16_2 0.8677
Rc9s16_2 c9s16_2 c9s16_3 3.374
Rc9s16_3 c9s16_3 c9s16_4 1.932
Rc9s16_4 c9s16_4 c9s16_5 1.472
Rc9s16_5 c9s16_5 c9s16_6 0.5859
Cc9s16_0 c9s16_0 0 0.05256f
Cc9s16_1 c9s16_1 0 0.1104f
Cc9s16_2 c9s16_2 0 0.2828f
Cc9s16_3 c9s16_3 0 0.3537f
Cc9s16_4 c9s16_4 0 0.2269f
Cc9s16_5 c9s16_5 0 0.1372f
Cc9s16_6 c9s16_6 0 0.03906f
CCc9s16_0 c9s16_0 c9s17_0 0.1193f
CCc9s16_2 c9s16_2 c9s17_2 0.03878f
CCc9s16_4 c9s16_4 c9s17_4 0.08985f
CCc9s16_6 c9s16_6 c9s17_6 0.1256f
Rc9s17_0 c9s17_0 c9s17_1 4.978
Rc9s17_1 c9s17_1 c9s17_2 3.155
Rc9s17_2 c9s17_2 c9s17_3 1.261
Rc9s17_3 c9s17_3 c9s17_4 0.9416
Rc9s17_4 c9s17_4 c9s17_5 0.8244
Rc9s17_5 c9s17_5 c9s17_6 1.451
Cc9s17_0 c9s17_0 0 0.1985f
Cc9s17_1 c9s17_1 0 0.4089f
Cc9s17_2 c9s17_2 0 0.2944f
Cc9s17_3 c9s17_3 0 0.1468f
Cc9s17_4 c9s17_4 0 0.1177f
Cc9s17_5 c9s17_5 0 0.1517f
Cc9s17_6 c9s17_6 0 0.09674f
CCc9s17_0 c9s17_0 c9s18_0 0.06783f
CCc9s17_2 c9s17_2 c9s18_2 0.0475f
CCc9s17_4 c9s17_4 c9s18_4 0.03702f
CCc9s17_6 c9s17_6 c9s18_6 0.07818f
Rc9s18_0 c9s18_0 c9s18_1 3.774
Rc9s18_1 c9s18_1 c9s18_2 0.8691
Rc9s18_2 c9s18_2 c9s18_3 3.034
Rc9s18_3 c9s18_3 c9s18_4 0.7298
Rc9s18_4 c9s18_4 c9s18_5 1.674
Rc9s18_5 c9s18_5 c9s18_6 1.666
Cc9s18_0 c9s18_0 0 0.1183f
Cc9s18_1 c9s18_1 0 0.1762f
Cc9s18_2 c9s18_2 0 0.2602f
Cc9s18_3 c9s18_3 0 0.2509f
Cc9s18_4 c9s18_4 0 0.1603f
Cc9s18_5 c9s18_5 0 0.2227f
Cc9s18_6 c9s18_6 0 0.111f
CCc9s18_0 c9s18_0 c9s19_0 0.07515f
CCc9s18_2 c9s18_2 c9s19_2 0.1066f
CCc9s18_4 c9s18_4 c9s19_4 0.09228f
CCc9s18_6 c9s18_6 c9s19_6 0.1043f
Rc9s19_0 c9s19_0 c9s19_1 4.756
Rc9s19_1 c9s19_1 c9s19_2 0.7437
Rc9s19_2 c9s19_2 c9s19_3 3.491
Rc9s19_3 c9s19_3 c9s19_4 2.098
Rc9s19_4 c9s19_4 c9s19_5 2.826
Rc9s19_5 c9s19_5 c9s19_6 1.079
Cc9s19_0 c9s19_0 0 0.1838f
Cc9s19_1 c9s19_1 0 0.2333f
Cc9s19_2 c9s19_2 0 0.2823f
Cc9s19_3 c9s19_3 0 0.3726f
Cc9s19_4 c9s19_4 0 0.3283f
Cc9s19_5 c9s19_5 0 0.2603f
Cc9s19_6 c9s19_6 0 0.07191f
CCc9s19_0 c9s19_0 c9s20_0 0.08622f
CCc9s19_2 c9s19_2 c9s20_2 0.128f
CCc9s19_4 c9s19_4 c9s20_4 0.06447f
CCc9s19_6 c9s19_6 c9s20_6 0.09804f
Rc9s20_0 c9s20_0 c9s20_1 5.198
Rc9s20_1 c9s20_1 c9s20_2 2.115
Rc9s20_2 c9s20_2 c9s20_3 2.101
Rc9s20_3 c9s20_3 c9s20_4 2.652
Rc9s20_4 c9s20_4 c9s20_5 3.353
Rc9s20_5 c9s20_5 c9s20_6 1.271
Cc9s20_0 c9s20_0 0 0.2132f
Cc9s20_1 c9s20_1 0 0.3542f
Cc9s20_2 c9s20_2 0 0.281f
Cc9s20_3 c9s20_3 0 0.3169f
Cc9s20_4 c9s20_4 0 0.4003f
Cc9s20_5 c9s20_5 0 0.3082f
Cc9s20_6 c9s20_6 0 0.08471f
CCc9s20_0 c9s20_0 c9s21_0 0.1564f
CCc9s20_2 c9s20_2 c9s21_2 0.1237f
CCc9s20_4 c9s20_4 c9s21_4 0.07505f
CCc9s20_6 c9s20_6 c9s21_6 0.04387f
Rc9s21_0 c9s21_0 c9s21_1 3.268
Rc9s21_1 c9s21_1 c9s21_2 1.731
Rc9s21_2 c9s21_2 c9s21_3 2.675
Rc9s21_3 c9s21_3 c9s21_4 1.723
Rc9s21_4 c9s21_4 c9s21_5 0.6191
Rc9s21_5 c9s21_5 c9s21_6 0.7071
Cc9s21_0 c9s21_0 0 0.08451f
Cc9s21_1 c9s21_1 0 0.1999f
Cc9s21_2 c9s21_2 0 0.2937f
Cc9s21_3 c9s21_3 0 0.2932f
Cc9s21_4 c9s21_4 0 0.1561f
Cc9s21_5 c9s21_5 0 0.08841f
Cc9s21_6 c9s21_6 0 0.04714f
CCc9s21_0 c9s21_0 c9s22_0 0.1515f
CCc9s21_2 c9s21_2 c9s22_2 0.03113f
CCc9s21_4 c9s21_4 c9s22_4 0.1464f
CCc9s21_6 c9s21_6 c9s22_6 0.1479f
Rc9s22_0 c9s22_0 c9s22_1 4.374
Rc9s22_1 c9s22_1 c9s22_2 2.527
Rc9s22_2 c9s22_2 c9s22_3 3.139
Rc9s22_3 c9s22_3 c9s22_4 3.083
Rc9s22_4 c9s22_4 c9s22_5 2.696
Rc9s22_5 c9s22_5 c9s22_6 2.825
Cc9s22_0 c9s22_0 0 0.1583f
Cc9s22_1 c9s22_1 0 0.3268f
Cc9s22_2 c9s22_2 0 0.3777f
Cc9s22_3 c9s22_3 0 0.4148f
Cc9s22_4 c9s22_4 0 0.3853f
Cc9s22_5 c9s22_5 0 0.3681f
Cc9s22_6 c9s22_6 0 0.1883f
CCc9s22_0 c9s22_0 c9s23_0 0.1491f
CCc9s22_2 c9s22_2 c9s23_2 0.05382f
CCc9s22_4 c9s22_4 c9s23_4 0.07738f
CCc9s22_6 c9s22_6 c9s23_6 0.1253f
Rc9s23_0 c9s23_0 c9s23_1 4.603
Rc9s23_1 c9s23_1 c9s23_2 1.713
Rc9s23_2 c9s23_2 c9s23_3 3.591
Rc9s23_3 c9s23_3 c9s23_4 0.5962
Rc9s23_4 c9s23_4 c9s23_5 1.042
Rc9s23_5 c9s23_5 c9s23_6 0.9149
Cc9s23_0 c9s23_0 0 0.1735f
Cc9s23_1 c9s23_1 0 0.2878f
Cc9s23_2 c9s23_2 0 0.3537f
Cc9s23_3 c9s23_3 0 0.2792f
Cc9s23_4 c9s23_4 0 0.1092f
Cc9s23_5 c9s23_5 0 0.1305f
Cc9s23_6 c9s23_6 0 0.06099f
CCc9s23_0 c9s23_0 c9s24_0 0.06746f
CCc9s23_2 c9s23_2 c9s24_2 0.1514f
CCc9s23_4 c9s23_4 c9s24_4 0.1588f
CCc9s23_6 c9s23_6 c9s24_6 0.1279f
Rc9s24_0 c9s24_0 c9s24_1 3.775
Rc9s24_1 c9s24_1 c9s24_2 3.377
Rc9s24_2 c9s24_2 c9s24_3 1.497
Rc9s24_3 c9s24_3 c9s24_4 2.142
Rc9s24_4 c9s24_4 c9s24_5 2.709
Rc9s24_5 c9s24_5 c9s24_6 1.55
Cc9s24_0 c9s24_0 0 0.1183f
Cc9s24_1 c9s24_1 0 0.3435f
Cc9s24_2 c9s24_2 0 0.325f
Cc9s24_3 c9s24_3 0 0.2426f
Cc9s24_4 c9s24_4 0 0.3234f
Cc9s24_5 c9s24_5 0 0.284f
Cc9s24_6 c9s24_6 0 0.1033f
CCc9s24_0 c9s24_0 c9s25_0 0.119f
CCc9s24_2 c9s24_2 c9s25_2 0.1483f
CCc9s24_4 c9s24_4 c9s25_4 0.06906f
CCc9s24_6 c9s24_6 c9s25_6 0.1284f
Rc9s25_0 c9s25_0 c9s25_1 2.675
Rc9s25_1 c9s25_1 c9s25_2 3.309
Rc9s25_2 c9s25_2 c9s25_3 1.924
Rc9s25_3 c9s25_3 c9s25_4 1.574
Rc9s25_4 c9s25_4 c9s25_5 3.469
Rc9s25_5 c9s25_5 c9s25_6 0.7411
Cc9s25_0 c9s25_0 0 0.04498f
Cc9s25_1 c9s25_1 0 0.2656f
Cc9s25_2 c9s25_2 0 0.3489f
Cc9s25_3 c9s25_3 0 0.2332f
Cc9s25_4 c9s25_4 0 0.3362f
Cc9s25_5 c9s25_5 0 0.2806f
Cc9s25_6 c9s25_6 0 0.0494f
CCc9s25_0 c9s25_0 c9s26_0 0.09216f
CCc9s25_2 c9s25_2 c9s26_2 0.1537f
CCc9s25_4 c9s25_4 c9s26_4 0.07284f
CCc9s25_6 c9s25_6 c9s26_6 0.0568f
Rc9s26_0 c9s26_0 c9s26_1 3.892
Rc9s26_1 c9s26_1 c9s26_2 2.544
Rc9s26_2 c9s26_2 c9s26_3 1.281
Rc9s26_3 c9s26_3 c9s26_4 3.423
Rc9s26_4 c9s26_4 c9s26_5 3.334
Rc9s26_5 c9s26_5 c9s26_6 2.921
Cc9s26_0 c9s26_0 0 0.1261f
Cc9s26_1 c9s26_1 0 0.2957f
Cc9s26_2 c9s26_2 0 0.255f
Cc9s26_3 c9s26_3 0 0.3136f
Cc9s26_4 c9s26_4 0 0.4505f
Cc9s26_5 c9s26_5 0 0.417f
Cc9s26_6 c9s26_6 0 0.1947f
CCc9s26_0 c9s26_0 c9s27_0 0.09387f
CCc9s26_2 c9s26_2 c9s27_2 0.07932f
CCc9s26_4 c9s26_4 c9s27_4 0.0531f
CCc9s26_6 c9s26_6 c9s27_6 0.06917f
Rc9s27_0 c9s27_0 c9s27_1 3.917
Rc9s27_1 c9s27_1 c9s27_2 1.494
Rc9s27_2 c9s27_2 c9s27_3 2.087
Rc9s27_3 c9s27_3 c9s27_4 0.4865
Rc9s27_4 c9s27_4 c9s27_5 2.99
Rc9s27_5 c9s27_5 c9s27_6 2.841
Cc9s27_0 c9s27_0 0 0.1278f
Cc9s27_1 c9s27_1 0 0.2274f
Cc9s27_2 c9s27_2 0 0.2387f
Cc9s27_3 c9s27_3 0 0.1715f
Cc9s27_4 c9s27_4 0 0.2318f
Cc9s27_5 c9s27_5 0 0.3888f
Cc9s27_6 c9s27_6 0 0.1894f
CCc9s27_0 c9s27_0 c9s28_0 0.1301f
CCc9s27_2 c9s27_2 c9s28_2 0.03386f
CCc9s27_4 c9s27_4 c9s28_4 0.05817f
CCc9s27_6 c9s27_6 c9s28_6 0.05136f
Rc9s28_0 c9s28_0 c9s28_1 4.229
Rc9s28_1 c9s28_1 c9s28_2 3.482
Rc9s28_2 c9s28_2 c9s28_3 1.577
Rc9s28_3 c9s28_3 c9s28_4 3.079
Rc9s28_4 c9s28_4 c9s28_5 0.5727
Rc9s28_5 c9s28_5 c9s28_6 2.563
Cc9s28_0 c9s28_0 0 0.1486f
Cc9s28_1 c9s28_1 0 0.3808f
Cc9s28_2 c9s28_2 0 0.3373f
Cc9s28_3 c9s28_3 0 0.3104f
Cc9s28_4 c9s28_4 0 0.2435f
Cc9s28_5 c9s28_5 0 0.2091f
Cc9s28_6 c9s28_6 0 0.1709f
CCc9s28_0 c9s28_0 c9s29_0 0.07442f
CCc9s28_2 c9s28_2 c9s29_2 0.06947f
CCc9s28_4 c9s28_4 c9s29_4 0.1126f
CCc9s28_6 c9s28_6 c9s29_6 0.1382f
Rc9s29_0 c9s29_0 c9s29_1 5.391
Rc9s29_1 c9s29_1 c9s29_2 1.738
Rc9s29_2 c9s29_2 c9s29_3 2.054
Rc9s29_3 c9s29_3 c9s29_4 1.894
Rc9s29_4 c9s29_4 c9s29_5 0.6178
Rc9s29_5 c9s29_5 c9s29_6 2.204
Cc9s29_0 c9s29_0 0 0.226f
Cc9s29_1 c9s29_1 0 0.3419f
Cc9s29_2 c9s29_2 0 0.2528f
Cc9s29_3 c9s29_3 0 0.2632f
Cc9s29_4 c9s29_4 0 0.1674f
Cc9s29_5 c9s29_5 0 0.1881f
Cc9s29_6 c9s29_6 0 0.1469f
CCc9s29_0 c9s29_0 c9s30_0 0.124f
CCc9s29_2 c9s29_2 c9s30_2 0.1487f
CCc9s29_4 c9s29_4 c9s30_4 0.04975f
CCc9s29_6 c9s29_6 c9s30_6 0.09801f
Rc9s30_0 c9s30_0 c9s30_1 4.956
Rc9s30_1 c9s30_1 c9s30_2 1.08
Rc9s30_2 c9s30_2 c9s30_3 1.329
Rc9s30_3 c9s30_3 c9s30_4 1.764
Rc9s30_4 c9s30_4 c9s30_5 2.593
Rc9s30_5 c9s30_5 c9s30_6 3.121
Cc9s30_0 c9s30_0 0 0.1971f
Cc9s30_1 c9s30_1 0 0.2691f
Cc9s30_2 c9s30_2 0 0.1606f
Cc9s30_3 c9s30_3 0 0.2062f
Cc9s30_4 c9s30_4 0 0.2904f
Cc9s30_5 c9s30_5 0 0.3809f
Cc9s30_6 c9s30_6 0 0.208f
CCc9s30_0 c9s30_0 c9s31_0 0.06093f
CCc9s30_2 c9s30_2 c9s31_2 0.1047f
CCc9s30_4 c9s30_4 c9s31_4 0.1546f
CCc9s30_6 c9s30_6 c9s31_6 0.1532f
Rc9s31_0 c9s31_0 c9s31_1 5.05
Rc9s31_1 c9s31_1 c9s31_2 1.751
Rc9s31_2 c9s31_2 c9s31_3 2.656
Rc9s31_3 c9s31_3 c9s31_4 1.967
Rc9s31_4 c9s31_4 c9s31_5 2.071
Rc9s31_5 c9s31_5 c9s31_6 1.581
Cc9s31_0 c9s31_0 0 0.2033f
Cc9s31_1 c9s31_1 0 0.3201f
Cc9s31_2 c9s31_2 0 0.2938f
Cc9s31_3 c9s31_3 0 0.3082f
Cc9s31_4 c9s31_4 0 0.2692f
Cc9s31_5 c9s31_5 0 0.2435f
Cc9s31_6 c9s31_6 0 0.1054f
CCc9s31_0 c9s31_0 c9s32_0 0.1589f
CCc9s31_2 c9s31_2 c9s32_2 0.125f
CCc9s31_4 c9s31_4 c9s32_4 0.09611f
CCc9s31_6 c9s31_6 c9s32_6 0.02438f
Rc9s32_0 c9s32_0 c9s32_1 3.468
Rc9s32_1 c9s32_1 c9s32_2 3.16
Rc9s32_2 c9s32_2 c9s32_3 0.7359
Rc9s32_3 c9s32_3 c9s32_4 3.236
Rc9s32_4 c9s32_4 c9s32_5 1.84
Rc9s32_5 c9s32_5 c9s32_6 0.7196
Cc9s32_0 c9s32_0 0 0.09788f
Cc9s32_1 c9s32_1 0 0.3085f
Cc9s32_2 c9s32_2 0 0.2597f
Cc9s32_3 c9s32_3 0 0.2648f
Cc9s32_4 c9s32_4 0 0.3384f
Cc9s32_5 c9s32_5 0 0.1706f
Cc9s32_6 c9s32_6 0 0.04797f
CCc9s32_0 c9s32_0 c9s33_0 0.08593f
CCc9s32_2 c9s32_2 c9s33_2 0.1311f
CCc9s32_4 c9s32_4 c9s33_4 0.027f
CCc9s32_6 c9s32_6 c9s33_6 0.08919f
Rc9s33_0 c9s33_0 c9s33_1 4.622
Rc9s33_1 c9s33_1 c9s33_2 1.824
Rc9s33_2 c9s33_2 c9s33_3 1.377
Rc9s33_3 c9s33_3 c9s33_4 2.363
Rc9s33_4 c9s33_4 c9s33_5 2.164
Rc9s33_5 c9s33_5 c9s33_6 0.8247
Cc9s33_0 c9s33_0 0 0.1748f
Cc9s33_1 c9s33_1 0 0.2964f
Cc9s33_2 c9s33_2 0 0.2134f
Cc9s33_3 c9s33_3 0 0.2494f
Cc9s33_4 c9s33_4 0 0.3018f
Cc9s33_5 c9s33_5 0 0.1993f
Cc9s33_6 c9s33_6 0 0.05498f
CCc9s33_0 c9s33_0 c9s34_0 0.145f
CCc9s33_2 c9s33_2 c9s34_2 0.1396f
CCc9s33_4 c9s33_4 c9s34_4 0.09476f
CCc9s33_6 c9s33_6 c9s34_6 0.1488f
Rc9s34_0 c9s34_0 c9s34_1 4.395
Rc9s34_1 c9s34_1 c9s34_2 0.5555
Rc9s34_2 c9s34_2 c9s34_3 3.416
Rc9s34_3 c9s34_3 c9s34_4 2.55
Rc9s34_4 c9s34_4 c9s34_5 0.9272
Rc9s34_5 c9s34_5 c9s34_6 0.5187
Cc9s34_0 c9s34_0 0 0.1597f
Cc9s34_1 c9s34_1 0 0.1967f
Cc9s34_2 c9s34_2 0 0.2648f
Cc9s34_3 c9s34_3 0 0.3978f
Cc9s34_4 c9s34_4 0 0.2318f
Cc9s34_5 c9s34_5 0 0.0964f
Cc9s34_6 c9s34_6 0 0.03458f
CCc9s34_0 c9s34_0 c9s35_0 0.1253f
CCc9s34_2 c9s34_2 c9s35_2 0.07332f
CCc9s34_4 c9s34_4 c9s35_4 0.03855f
CCc9s34_6 c9s34_6 c9s35_6 0.1138f
Rc9s35_0 c9s35_0 c9s35_1 4.199
Rc9s35_1 c9s35_1 c9s35_2 3.051
Rc9s35_2 c9s35_2 c9s35_3 2.347
Rc9s35_3 c9s35_3 c9s35_4 1.869
Rc9s35_4 c9s35_4 c9s35_5 1.483
Rc9s35_5 c9s35_5 c9s35_6 3.574
Cc9s35_0 c9s35_0 0 0.1466f
Cc9s35_1 c9s35_1 0 0.3499f
Cc9s35_2 c9s35_2 0 0.3598f
Cc9s35_3 c9s35_3 0 0.281f
Cc9s35_4 c9s35_4 0 0.2234f
Cc9s35_5 c9s35_5 0 0.3371f
Cc9s35_6 c9s35_6 0 0.2383f
CCc9s35_0 c9s35_0 c9s36_0 0.1532f
CCc9s35_2 c9s35_2 c9s36_2 0.02897f
CCc9s35_4 c9s35_4 c9s36_4 0.1588f
CCc9s35_6 c9s35_6 c9s36_6 0.1265f
Rc9s36_0 c9s36_0 c9s36_1 3.244
Rc9s36_1 c9s36_1 c9s36_2 2.917
Rc9s36_2 c9s36_2 c9s36_3 2.497
Rc9s36_3 c9s36_3 c9s36_4 2.429
Rc9s36_4 c9s36_4 c9s36_5 3.196
Rc9s36_5 c9s36_5 c9s36_6 1.402
Cc9s36_0 c9s36_0 0 0.08296f
Cc9s36_1 c9s36_1 0 0.2774f
Cc9s36_2 c9s36_2 0 0.3609f
Cc9s36_3 c9s36_3 0 0.3284f
Cc9s36_4 c9s36_4 0 0.375f
Cc9s36_5 c9s36_5 0 0.3065f
Cc9s36_6 c9s36_6 0 0.09343f
CCc9s36_0 c9s36_0 c9s37_0 0.1343f
CCc9s36_2 c9s36_2 c9s37_2 0.09937f
CCc9s36_4 c9s36_4 c9s37_4 0.07291f
CCc9s36_6 c9s36_6 c9s37_6 0.1561f
Rc9s37_0 c9s37_0 c9s37_1 2.688
Rc9s37_1 c9s37_1 c9s37_2 2.301
Rc9s37_2 c9s37_2 c9s37_3 3.105
Rc9s37_3 c9s37_3 c9s37_4 0.6471
Rc9s37_4 c9s37_4 c9s37_5 3.158
Rc9s37_5 c9s37_5 c9s37_6 2.11
Cc9s37_0 c9s37_0 0 0.04589f
Cc9s37_1 c9s37_1 0 0.1993f
Cc9s37_2 c9s37_2 0 0.3604f
Cc9s37_3 c9s37_3 0 0.2501f
Cc9s37_4 c9s37_4 0 0.2537f
Cc9s37_5 c9s37_5 0 0.3512f
Cc9s37_6 c9s37_6 0 0.1407f
CCc9s37_0 c9s37_0 c9s38_0 0.09745f
CCc9s37_2 c9s37_2 c9s38_2 0.06355f
CCc9s37_4 c9s37_4 c9s38_4 0.1275f
CCc9s37_6 c9s37_6 c9s38_6 0.04012f
Rc9s38_0 c9s38_0 c9s38_1 3.978
Rc9s38_1 c9s38_1 c9s38_2 1.608
Rc9s38_2 c9s38_2 c9s38_3 2.175
Rc9s38_3 c9s38_3 c9s38_4 1.1
Rc9s38_4 c9s38_4 c9s38_5 2.157
Rc9s38_5 c9s38_5 c9s38_6 0.4945
Cc9s38_0 c9s38_0 0 0.1319f
Cc9s38_1 c9s38_1 0 0.2391f
Cc9s38_2 c9s38_2 0 0.2522f
Cc9s38_3 c9s38_3 0 0.2183f
Cc9s38_4 c9s38_4 0 0.2172f
Cc9s38_5 c9s38_5 0 0.1768f
Cc9s38_6 c9s38_6 0 0.03297f
CCc9s38_0 c9s38_0 c9s39_0 0.1076f
CCc9s38_2 c9s38_2 c9s39_2 0.1025f
CCc9s38_4 c9s38_4 c9s39_4 0.04016f
CCc9s38_6 c9s38_6 c9s39_6 0.06426f
Rc9s39_0 c9s39_0 c9s39_1 3.841
Rc9s39_1 c9s39_1 c9s39_2 3.08
Rc9s39_2 c9s39_2 c9s39_3 3.574
Rc9s39_3 c9s39_3 c9s39_4 2.314
Rc9s39_4 c9s39_4 c9s39_5 2.921
Rc9s39_5 c9s39_5 c9s39_6 1.616
Cc9s39_0 c9s39_0 0 0.1227f
Cc9s39_1 c9s39_1 0 0.328f
Cc9s39_2 c9s39_2 0 0.4436f
Cc9s39_3 c9s39_3 0 0.3925f
Cc9s39_4 c9s39_4 0 0.349f
Cc9s39_5 c9s39_5 0 0.3025f
Cc9s39_6 c9s39_6 0 0.1078f
CCc9s39_0 c9s39_0 c9s40_0 0.1465f
CCc9s39_2 c9s39_2 c9s40_2 0.1525f
CCc9s39_4 c9s39_4 c9s40_4 0.159f
CCc9s39_6 c9s39_6 c9s40_6 0.1065f
Rc9s40_0 c9s40_0 c9s40_1 2.714
Rc9s40_1 c9s40_1 c9s40_2 1.13
Rc9s40_2 c9s40_2 c9s40_3 1.152
Rc9s40_3 c9s40_3 c9s40_4 2.37
Rc9s40_4 c9s40_4 c9s40_5 1.544
Rc9s40_5 c9s40_5 c9s40_6 1.815
Cc9s40_0 c9s40_0 0 0.04761f
Cc9s40_1 c9s40_1 0 0.1229f
Cc9s40_2 c9s40_2 0 0.1521f
Cc9s40_3 c9s40_3 0 0.2348f
Cc9s40_4 c9s40_4 0 0.261f
Cc9s40_5 c9s40_5 0 0.224f
Cc9s40_6 c9s40_6 0 0.121f
CCc9s40_0 c9s40_0 c9s41_0 0.1271f
CCc9s40_2 c9s40_2 c9s41_2 0.03345f
CCc9s40_4 c9s40_4 c9s41_4 0.0241f
CCc9s40_6 c9s40_6 c9s41_6 0.05268f
Rc9s41_0 c9s41_0 c9s41_1 4.485
Rc9s41_1 c9s41_1 c9s41_2 1.206
Rc9s41_2 c9s41_2 c9s41_3 3.373
Rc9s41_3 c9s41_3 c9s41_4 2.116
Rc9s41_4 c9s41_4 c9s41_5 2.179
Rc9s41_5 c9s41_5 c9s41_6 2.057
Cc9s41_0 c9s41_0 0 0.1657f
Cc9s41_1 c9s41_1 0 0.2461f
Cc9s41_2 c9s41_2 0 0.3053f
Cc9s41_3 c9s41_3 0 0.366f
Cc9s41_4 c9s41_4 0 0.2864f
Cc9s41_5 c9s41_5 0 0.2824f
Cc9s41_6 c9s41_6 0 0.1371f
CCc9s41_0 c9s41_0 c9s42_0 0.02861f
CCc9s41_2 c9s41_2 c9s42_2 0.1092f
CCc9s41_4 c9s41_4 c9s42_4 0.1021f
CCc9s41_6 c9s41_6 c9s42_6 0.1193f
Rc9s42_0 c9s42_0 c9s42_1 3.501
Rc9s42_1 c9s42_1 c9s42_2 3.249
Rc9s42_2 c9s42_2 c9s42_3 1.785
Rc9s42_3 c9s42_3 c9s42_4 2.873
Rc9s42_4 c9s42_4 c9s42_5 0.4547
Rc9s42_5 c9s42_5 c9s42_6 2.281
Cc9s42_0 c9s42_0 0 0.1001f
Cc9s42_1 c9s42_1 0 0.3167f
Cc9s42_2 c9s42_2 0 0.3356f
Cc9s42_3 c9s42_3 0 0.3105f
Cc9s42_4 c9s42_4 0 0.2219f
Cc9s42_5 c9s42_5 0 0.1824f
Cc9s42_6 c9s42_6 0 0.1521f
CCc9s42_0 c9s42_0 c9s43_0 0.1502f
CCc9s42_2 c9s42_2 c9s43_2 0.04501f
CCc9s42_4 c9s42_4 c9s43_4 0.02028f
CCc9s42_6 c9s42_6 c9s43_6 0.02235f
Rc9s43_0 c9s43_0 c9s43_1 3.603
Rc9s43_1 c9s43_1 c9s43_2 3.044
Rc9s43_2 c9s43_2 c9s43_3 1.138
Rc9s43_3 c9s43_3 c9s43_4 2.525
Rc9s43_4 c9s43_4 c9s43_5 2.973
Rc9s43_5 c9s43_5 c9s43_6 1.217
Cc9s43_0 c9s43_0 0 0.1068f
Cc9s43_1 c9s43_1 0 0.3097f
Cc9s43_2 c9s43_2 0 0.2788f
Cc9s43_3 c9s43_3 0 0.2442f
Cc9s43_4 c9s43_4 0 0.3665f
Cc9s43_5 c9s43_5 0 0.2793f
Cc9s43_6 c9s43_6 0 0.08113f
CCc9s43_0 c9s43_0 c9s44_0 0.1449f
CCc9s43_2 c9s43_2 c9s44_2 0.1021f
CCc9s43_4 c9s43_4 c9s44_4 0.07815f
CCc9s43_6 c9s43_6 c9s44_6 0.07313f
Rc9s44_0 c9s44_0 c9s44_1 2.989
Rc9s44_1 c9s44_1 c9s44_2 3.078
Rc9s44_2 c9s44_2 c9s44_3 3.024
Rc9s44_3 c9s44_3 c9s44_4 1.105
Rc9s44_4 c9s44_4 c9s44_5 0.6308
Rc9s44_5 c9s44_5 c9s44_6 0.9142
Cc9s44_0 c9s44_0 0 0.06593f
Cc9s44_1 c9s44_1 0 0.2711f
Cc9s44_2 c9s44_2 0 0.4068f
Cc9s44_3 c9s44_3 0 0.2753f
Cc9s44_4 c9s44_4 0 0.1157f
Cc9s44_5 c9s44_5 0 0.103f
Cc9s44_6 c9s44_6 0 0.06094f
CCc9s44_0 c9s44_0 c9s45_0 0.07503f
CCc9s44_2 c9s44_2 c9s45_2 0.07045f
CCc9s44_4 c9s44_4 c9s45_4 0.1511f
CCc9s44_6 c9s44_6 c9s45_6 0.127f
Rc9s45_0 c9s45_0 c9s45_1 2.981
Rc9s45_1 c9s45_1 c9s45_2 3.262
Rc9s45_2 c9s45_2 c9s45_3 3.477
Rc9s45_3 c9s45_3 c9s45_4 3.472
Rc9s45_4 c9s45_4 c9s45_5 2.024
Rc9s45_5 c9s45_5 c9s45_6 2.482
Cc9s45_0 c9s45_0 0 0.06541f
Cc9s45_1 c9s45_1 0 0.2829f
Cc9s45_2 c9s45_2 0 0.4492f
Cc9s45_3 c9s45_3 0 0.4632f
Cc9s45_4 c9s45_4 0 0.3664f
Cc9s45_5 c9s45_5 0 0.3004f
Cc9s45_6 c9s45_6 0 0.1655f
CCc9s45_0 c9s45_0 c9s46_0 0.147f
CCc9s45_2 c9s45_2 c9s46_2 0.04559f
CCc9s45_4 c9s45_4 c9s46_4 0.1597f
CCc9s45_6 c9s45_6 c9s46_6 0.06031f
Rc9s46_0 c9s46_0 c9s46_1 3.552
Rc9s46_1 c9s46_1 c9s46_2 1.213
Rc9s46_2 c9s46_2 c9s46_3 2.67
Rc9s46_3 c9s46_3 c9s46_4 2.754
Rc9s46_4 c9s46_4 c9s46_5 1.171
Rc9s46_5 c9s46_5 c9s46_6 1.136
Cc9s46_0 c9s46_0 0 0.1034f
Cc9s46_1 c9s46_1 0 0.1843f
Cc9s46_2 c9s46_2 0 0.2589f
Cc9s46_3 c9s46_3 0 0.3616f
Cc9s46_4 c9s46_4 0 0.2617f
Cc9s46_5 c9s46_5 0 0.1538f
Cc9s46_6 c9s46_6 0 0.07573f
CCc9s46_0 c9s46_0 c9s47_0 0.1593f
CCc9s46_2 c9s46_2 c9s47_2 0.1329f
CCc9s46_4 c9s46_4 c9s47_4 0.05764f
CCc9s46_6 c9s46_6 c9s47_6 0.1337f
Rc9s47_0 c9s47_0 c9s47_1 4.665
Rc9s47_1 c9s47_1 c9s47_2 1.805
Rc9s47_2 c9s47_2 c9s47_3 3.414
Rc9s47_3 c9s47_3 c9s47_4 2.771
Rc9s47_4 c9s47_4 c9s47_5 1.332
Rc9s47_5 c9s47_5 c9s47_6 3.321
Cc9s47_0 c9s47_0 0 0.1777f
Cc9s47_1 c9s47_1 0 0.298f
Cc9s47_2 c9s47_2 0 0.3479f
Cc9s47_3 c9s47_3 0 0.4123f
Cc9s47_4 c9s47_4 0 0.2735f
Cc9s47_5 c9s47_5 0 0.3102f
Cc9s47_6 c9s47_6 0 0.2214f
CCc9s47_0 c9s47_0 c9s48_0 0.07036f
CCc9s47_2 c9s47_2 c9s48_2 0.1296f
CCc9s47_4 c9s47_4 c9s48_4 0.08862f
CCc9s47_6 c9s47_6 c9s48_6 0.07753f
Rc9s48_0 c9s48_0 c9s48_1 3.086
Rc9s48_1 c9s48_1 c9s48_2 2.068
Rc9s48_2 c9s48_2 c9s48_3 2.118
Rc9s48_3 c9s48_3 c9s48_4 1.444
Rc9s48_4 c9s48_4 c9s48_5 1.183
Rc9s48_5 c9s48_5 c9s48_6 2.15
Cc9s48_0 c9s48_0 0 0.0724f
Cc9s48_1 c9s48_1 0 0.2102f
Cc9s48_2 c9s48_2 0 0.2791f
Cc9s48_3 c9s48_3 0 0.2375f
Cc9s48_4 c9s48_4 0 0.1751f
Cc9s48_5 c9s48_5 0 0.2222f
Cc9s48_6 c9s48_6 0 0.1433f
CCc9s48_0 c9s48_0 c9s49_0 0.07927f
Cc9s49_0 c9s49_0 0 0f
.save v(c0s9_0) v(c0s24_0) v(c0s49_0) v(c9s9_0) v(c9s24_0) v(c9s49_0)
.options reltol=1e-5 abstol=1e-14 vntol=1e-8
.tran .2p 1000p 0 .2p
.end
